Generated chess-board AHCT125 level-shifter channels
V5 5v 0 5.0
VIN1 spi_data_3v3 0 0
BOUT1 led_data_5v 0 V={V(5v)>4.5 && V(0)<0.8 ? (V(spi_data_3v3)>2.0 ? V(5v)-0.1 : 0.1) : 0}
VIN2 spi_clk_3v3 0 3.3
BOUT2 led_clk_5v 0 V={V(5v)>4.5 && V(0)<0.8 ? (V(spi_clk_3v3)>2.0 ? V(5v)-0.1 : 0.1) : 0}
.tran 1u 10u
.control
run
meas tran result_channel_1 FIND v(led_data_5v) AT=5u
meas tran result_channel_2 FIND v(led_clk_5v) AT=5u
if result_channel_1 < 0
echo "ASSERTION FAILED: result_channel_1 below 0"
quit 1
end
if result_channel_1 > 0.3
echo "ASSERTION FAILED: result_channel_1 above 0.3"
quit 1
end
if result_channel_2 < 4.5
echo "ASSERTION FAILED: result_channel_2 below 4.5"
quit 1
end
if result_channel_2 > 5.1
echo "ASSERTION FAILED: result_channel_2 above 5.1"
quit 1
end
quit 0
.endc
.end
