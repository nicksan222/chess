LED link LED_DATA_5V, Drive(ohms=75.47169811320761, rise_ns=3.0), 5.25 V
Tlled_data_5v_0 lled_data_5v_0 0 lled_data_5v_1 0 Z0=33.29027936627942 TD=0.22869577909593808n
Tlled_data_5v_1 lled_data_5v_2 0 lled_data_5v_0 0 Z0=33.29027936627942 TD=0.32692960290815n
Clled_data_5v_2 lled_data_5v_1 0 1.898581964251504e-14
Clled_data_5v_3 lled_data_5v_1 0 9.308599550164269e-14
Clled_data_5v_4 lled_data_5v_1 0 2.327149887541067e-13
Clled_data_5v_5 lled_data_5v_2 0 3.7234398200657075e-13
Clled_data_5v_6 lled_data_5v_1 0 4.654299775082134e-13
Clled_data_5v_7 lled_data_5v_1 0 9.308599550164269e-14
Clled_data_5v_8 lled_data_5v_1 0 2.3567512341105898e-14
Clled_data_5v_9 lled_data_5v_1 0 3.7234398200657075e-13
Clled_data_5v_10 lled_data_5v_1 0 3.7234398200657075e-13
Clled_data_5v_11 lled_data_5v_1 0 4.4215847863280275e-13
Clled_data_5v_12 lled_data_5v_1 0 6.050589707606775e-13
Clled_data_5v_13 lled_data_5v_1 0 3.537267829062422e-13
Clled_data_5v_14 lled_data_5v_1 0 6.516019685114988e-14
Clled_data_5v_15 lled_data_5v_1 0 1.8617199100328538e-14
Clled_data_5v_16 lled_data_5v_2 0 5.119729752590347e-13
Clled_data_5v_17 lled_data_5v_1 0 1.8617199100328538e-14
Clled_data_5v_18 lled_data_5v_2 0 2.327149887541067e-13
Clled_data_5v_19 lled_data_5v_2 0 3.7234398200657075e-13
Clled_data_5v_20 lled_data_5v_2 0 4.6542997750821344e-14
Clled_data_5v_21 lled_data_5v_2 0 2.327149887541067e-13
Clled_data_5v_22 lled_data_5v_2 0 2.632862913967562e-14
Clled_data_5v_23 lled_data_5v_2 0 1.8617199100328538e-13
Clled_data_5v_24 lled_data_5v_1 0 3.677102362204724e-13
Clled_data_5v_25 lled_data_5v_2 0 3.677102362204724e-13
Clled_data_5v_26 lled_data_5v_3 0 1.0146373509679054e-12
Rser_lled_data_5v lled_data_5v_1 lled_data_5v_3 55.44
Rpd_R17 lled_data_5v_1 0 10000.0
Vlled_data_5v lled_data_5v_src 0 PULSE(0.0 5.25 1.0n 3.0n 1n 100n 200n)
Rdrv_lled_data_5v lled_data_5v_src lled_data_5v_3 75.47169811320761
Crx_lled_data_5v lled_data_5v_2 0 5e-12
.tran 10p 60.0n
.control
run
meas tran cross WHEN v(lled_data_5v_2)=3.675 RISE=1
meas tran result_peak MAX v(lled_data_5v_2)
meas tran result_trough MIN v(lled_data_5v_2)
meas tran result_hold MIN v(lled_data_5v_2) FROM=$&cross
meas tran last WHEN v(lled_data_5v_2)=4.7250000000000005 CROSS=LAST
let result_settle = (last - 1.0n) * 1e9
let result_arrival = (cross - 1.0n) * 1e9
print result_settle
print result_arrival
if result_settle < 0
echo "ASSERTION FAILED: result_settle below 0"
quit 1
end
if result_settle > 25
echo "ASSERTION FAILED: result_settle above 25"
quit 1
end
if result_peak < 0
echo "ASSERTION FAILED: result_peak below 0"
quit 1
end
if result_peak > 5.5
echo "ASSERTION FAILED: result_peak above 5.5"
quit 1
end
if result_trough < -0.3
echo "ASSERTION FAILED: result_trough below -0.3"
quit 1
end
if result_trough > 5.25
echo "ASSERTION FAILED: result_trough above 5.25"
quit 1
end
if result_hold < 3.67
echo "ASSERTION FAILED: result_hold below 3.67"
quit 1
end
if result_hold > 5.55
echo "ASSERTION FAILED: result_hold above 5.55"
quit 1
end
quit 0
.endc
.end
