Generated chess-board LED outputs at enable/disable [BEH]
VOUT out 0 5.25
.model Q1P PMOS(LEVEL=1 VTO=-1.0 KP=17.44287458573173)
.model Q2N NMOS(LEVEL=1 VTO=1.5 KP=0.08)
.model Q1BODY D(IS=1e-12 N=1)
R13 en_pi en_g 1000.0
R14 en_g 0 100000.0
MQ2 en_n en_g 0 0 Q2N
R15 out en_n 10000.0
R16 en_n q1g 100000.0
C145 q1g led 10n
CQ1GS q1g out 2.92n
CQ1GD q1g led 0.33n
MQ1 led q1g out out Q1P
DQ1 led out Q1BODY
CLED led 0 6.4e-06
BCHAIN led 0 I={3.5199999999999996 * 0.5 * (1 + tanh((V(led) - 3.0) / 0.1))}
Bsgset sg_s 0 V={max(0.5*(1+tanh((V(q1g)-3.33)/0.01)), min(0.5*(1+tanh((V(q1g)-2.29)/0.01)), V(sg)))}
Rsg sg_s sg 1k
Csg sg 0 10p
Bsenset sen_s 0 V={max(0.5*(1+tanh((V(en_n)-3.33)/0.01)), min(0.5*(1+tanh((V(en_n)-2.29)/0.01)), V(sen)))}
Rsen sen_s sen 1k
Csen sen 0 10p
BOE oe 0 V={V(out)*min(1, (1-V(sg))*V(sen)*(1-1) + (1-V(sg))*V(sen)*1 + V(sg)*(1-V(sen))*1 + V(sg)*V(sen)*1)}
Roe_load oe 0 1e7
BENA ena 0 V={0.5*(1+tanh((2.0-V(oe))/0.02))}
.model U5SW SW(Ron=75 Roff=1e9 Vt=0.5 Vh=0.05)
SDATA out di_drv ena 0 U5SW
R9 di_drv di 56.0
SCLK out ci ena 0 U5SW
.model U6CLAMP D(IS=1e-14 N=1)
DDI di led U6CLAMP
DCI ci led U6CLAMP
CDI di 0 5e-12
CCI ci 0 5e-12
IOZDI 0 di_drv 2.5e-06
IOZCI 0 ci 2.5e-06
RPD_R17 di 0 10000.0
RPD_R18 ci 0 10000.0
VEN en_pi 0 PWL(0 0 1m 0 1.001m 3.3 15m 3.3 15.001m 0)
.tran 2u 30m 0 2u
.control
run
let over_di = v(di) - v(led)
let over_ci = v(ci) - v(led)
meas tran result_data_over MAX over_di
meas tran result_clock_over MAX over_ci
meas tran t_on WHEN v(oe)=2.0 FALL=1 FROM=1m
meas tran result_oe_while_on FIND v(oe) AT=14m
let result_enable_ms = (t_on - 1m) * 1000
meas tran result_rail_at_enable FIND v(led) AT=t_on
meas tran t_off WHEN v(oe)=2.0 RISE=1 FROM=15m
let result_disable_us = (t_off - 15m) * 1e6
print result_data_over result_clock_over result_enable_ms
print result_rail_at_enable result_disable_us result_oe_while_on
let off_until = t_on - 10u
let off_from = t_off + 50u
meas tran di_before MAX v(di) FROM=0 TO=$&off_until
meas tran ci_before MAX v(ci) FROM=0 TO=$&off_until
meas tran di_after MAX v(di) FROM=$&off_from TO=30m
meas tran ci_after MAX v(ci) FROM=$&off_from TO=30m
let result_off_high = max(max(di_before, ci_before), max(di_after, ci_after))
print result_off_high
if result_data_over < -1
echo "ASSERTION FAILED: result_data_over below -1"
quit 1
end
if result_data_over > 0.3
echo "ASSERTION FAILED: result_data_over above 0.3"
quit 1
end
if result_clock_over < -1
echo "ASSERTION FAILED: result_clock_over below -1"
quit 1
end
if result_clock_over > 0.3
echo "ASSERTION FAILED: result_clock_over above 0.3"
quit 1
end
if result_enable_ms < 0.5
echo "ASSERTION FAILED: result_enable_ms below 0.5"
quit 1
end
if result_enable_ms > 5
echo "ASSERTION FAILED: result_enable_ms above 5"
quit 1
end
if result_oe_while_on < -0.1
echo "ASSERTION FAILED: result_oe_while_on below -0.1"
quit 1
end
if result_oe_while_on > 0.8
echo "ASSERTION FAILED: result_oe_while_on above 0.8"
quit 1
end
if result_disable_us < 0
echo "ASSERTION FAILED: result_disable_us below 0"
quit 1
end
if result_disable_us > 10
echo "ASSERTION FAILED: result_disable_us above 10"
quit 1
end
if result_off_high < -0.1
echo "ASSERTION FAILED: result_off_high below -0.1"
quit 1
end
if result_off_high > 0.3
echo "ASSERTION FAILED: result_off_high above 0.3"
quit 1
end
quit 0
.endc
.end
