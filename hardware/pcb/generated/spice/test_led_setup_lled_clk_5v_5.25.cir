LED link LED_CLK_5V, Drive(ohms=75.47169811320761, rise_ns=1.0), 5.25 V
Tlled_clk_5v_0 lled_clk_5v_0 0 lled_clk_5v_1 0 Z0=33.29027936627942 TD=0.2829258080143516n
Tlled_clk_5v_1 lled_clk_5v_2 0 lled_clk_5v_0 0 Z0=33.29027936627942 TD=0.362566479054536n
Clled_clk_5v_2 lled_clk_5v_1 0 3.258009842557494e-13
Clled_clk_5v_3 lled_clk_5v_1 0 2.3271498875410672e-14
Clled_clk_5v_4 lled_clk_5v_1 0 3.537267829062422e-13
Clled_clk_5v_5 lled_clk_5v_1 0 1.8617199100328538e-14
Clled_clk_5v_6 lled_clk_5v_1 0 6.516019685114988e-14
Clled_clk_5v_7 lled_clk_5v_1 0 4.4215847863280275e-13
Clled_clk_5v_8 lled_clk_5v_1 0 2.327149887541067e-13
Clled_clk_5v_9 lled_clk_5v_1 0 1.1920778755931366e-14
Clled_clk_5v_10 lled_clk_5v_2 0 3.537267829062422e-13
Clled_clk_5v_11 lled_clk_5v_2 0 1.8617199100328538e-14
Clled_clk_5v_12 lled_clk_5v_1 0 8.843169572656055e-13
Clled_clk_5v_13 lled_clk_5v_1 0 5.585159730098562e-13
Clled_clk_5v_14 lled_clk_5v_1 0 5.585159730098562e-13
Rpd_R18 lled_clk_5v_1 0 10000.0
Vlled_clk_5v lled_clk_5v_src 0 PULSE(0.0 5.25 1.0n 1.0n 1n 100n 200n)
Rdrv_lled_clk_5v lled_clk_5v_src lled_clk_5v_1 75.47169811320761
Crx_lled_clk_5v lled_clk_5v_2 0 5e-12
.tran 10p 60.0n
.control
run
meas tran cross WHEN v(lled_clk_5v_2)=3.675 RISE=1
meas tran result_peak MAX v(lled_clk_5v_2)
meas tran result_trough MIN v(lled_clk_5v_2)
meas tran result_hold MIN v(lled_clk_5v_2) FROM=$&cross
meas tran last WHEN v(lled_clk_5v_2)=4.7250000000000005 CROSS=LAST
let result_settle = (last - 1.0n) * 1e9
let result_arrival = (cross - 1.0n) * 1e9
print result_settle
print result_arrival
if result_settle < 0
echo "ASSERTION FAILED: result_settle below 0"
quit 1
end
if result_settle > 25
echo "ASSERTION FAILED: result_settle above 25"
quit 1
end
if result_peak < 0
echo "ASSERTION FAILED: result_peak below 0"
quit 1
end
if result_peak > 5.55
echo "ASSERTION FAILED: result_peak above 5.55"
quit 1
end
if result_trough < -0.3
echo "ASSERTION FAILED: result_trough below -0.3"
quit 1
end
if result_trough > 5.25
echo "ASSERTION FAILED: result_trough above 5.25"
quit 1
end
if result_hold < 3.67
echo "ASSERTION FAILED: result_hold below 3.67"
quit 1
end
if result_hold > 5.55
echo "ASSERTION FAILED: result_hold above 5.55"
quit 1
end
quit 0
.endc
.end
