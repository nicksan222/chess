Generated chess-board LED level shift, low, 4.5 V
RSER_led_data_buf led_data_buf led_data_5v 56.0
RPD_R17 led_data_5v 0 10000.0
VHOST_led_data_5v spi_data_3v3 0 0.14
VBUF_led_data_5v open_led_data_5v 0 0.0978616352201258
RBUF_led_data_5v open_led_data_5v led_data_buf 42.76729559748427
RPD_R18 led_clk_5v 0 10000.0
VHOST_led_clk_5v spi_clk_3v3 0 0.14
VBUF_led_clk_5v open_led_clk_5v 0 0.0978616352201258
RBUF_led_clk_5v open_led_clk_5v led_clk_5v 42.76729559748427
.op
.control
run
let result_led_data_5v_input = 0.8 - v(spi_data_3v3)
let result_led_data_5v_led = 1.3499999999999999 - v(led_data_5v)
let result_led_clk_5v_input = 0.8 - v(spi_clk_3v3)
let result_led_clk_5v_led = 1.3499999999999999 - v(led_clk_5v)
if result_led_data_5v_input < 0
echo "ASSERTION FAILED: result_led_data_5v_input below 0"
quit 1
end
if result_led_data_5v_input > 4.5
echo "ASSERTION FAILED: result_led_data_5v_input above 4.5"
quit 1
end
if result_led_data_5v_led < 0
echo "ASSERTION FAILED: result_led_data_5v_led below 0"
quit 1
end
if result_led_data_5v_led > 4.5
echo "ASSERTION FAILED: result_led_data_5v_led above 4.5"
quit 1
end
if result_led_clk_5v_input < 0
echo "ASSERTION FAILED: result_led_clk_5v_input below 0"
quit 1
end
if result_led_clk_5v_input > 4.5
echo "ASSERTION FAILED: result_led_clk_5v_input above 4.5"
quit 1
end
if result_led_clk_5v_led < 0
echo "ASSERTION FAILED: result_led_clk_5v_led below 0"
quit 1
end
if result_led_clk_5v_led > 4.5
echo "ASSERTION FAILED: result_led_clk_5v_led above 4.5"
quit 1
end
quit 0
.endc
.end
