Generated chess-board Hall levels, empty, 3.135 V
VDD vdd 0 3.135
RPU_sq_a1 sq_a1 vdd 100000.0
ILEAK_sq_a1 sq_a1 0 1.1e-06
RPU_sq_a2 sq_a2 vdd 100000.0
ILEAK_sq_a2 sq_a2 0 1.1e-06
RPU_sq_a3 sq_a3 vdd 100000.0
ILEAK_sq_a3 sq_a3 0 1.1e-06
RPU_sq_a4 sq_a4 vdd 100000.0
ILEAK_sq_a4 sq_a4 0 1.1e-06
RPU_sq_a5 sq_a5 vdd 100000.0
ILEAK_sq_a5 sq_a5 0 1.1e-06
RPU_sq_a6 sq_a6 vdd 100000.0
ILEAK_sq_a6 sq_a6 0 1.1e-06
RPU_sq_a7 sq_a7 vdd 100000.0
ILEAK_sq_a7 sq_a7 0 1.1e-06
RPU_sq_a8 sq_a8 vdd 100000.0
ILEAK_sq_a8 sq_a8 0 1.1e-06
RPU_sq_b1 sq_b1 vdd 100000.0
ILEAK_sq_b1 sq_b1 0 1.1e-06
RPU_sq_b2 sq_b2 vdd 100000.0
ILEAK_sq_b2 sq_b2 0 1.1e-06
RPU_sq_b3 sq_b3 vdd 100000.0
ILEAK_sq_b3 sq_b3 0 1.1e-06
RPU_sq_b4 sq_b4 vdd 100000.0
ILEAK_sq_b4 sq_b4 0 1.1e-06
RPU_sq_b5 sq_b5 vdd 100000.0
ILEAK_sq_b5 sq_b5 0 1.1e-06
RPU_sq_b6 sq_b6 vdd 100000.0
ILEAK_sq_b6 sq_b6 0 1.1e-06
RPU_sq_b7 sq_b7 vdd 100000.0
ILEAK_sq_b7 sq_b7 0 1.1e-06
RPU_sq_b8 sq_b8 vdd 100000.0
ILEAK_sq_b8 sq_b8 0 1.1e-06
RPU_sq_c1 sq_c1 vdd 100000.0
ILEAK_sq_c1 sq_c1 0 1.1e-06
RPU_sq_c2 sq_c2 vdd 100000.0
ILEAK_sq_c2 sq_c2 0 1.1e-06
RPU_sq_c3 sq_c3 vdd 100000.0
ILEAK_sq_c3 sq_c3 0 1.1e-06
RPU_sq_c4 sq_c4 vdd 100000.0
ILEAK_sq_c4 sq_c4 0 1.1e-06
RPU_sq_c5 sq_c5 vdd 100000.0
ILEAK_sq_c5 sq_c5 0 1.1e-06
RPU_sq_c6 sq_c6 vdd 100000.0
ILEAK_sq_c6 sq_c6 0 1.1e-06
RPU_sq_c7 sq_c7 vdd 100000.0
ILEAK_sq_c7 sq_c7 0 1.1e-06
RPU_sq_c8 sq_c8 vdd 100000.0
ILEAK_sq_c8 sq_c8 0 1.1e-06
RPU_sq_d1 sq_d1 vdd 100000.0
ILEAK_sq_d1 sq_d1 0 1.1e-06
RPU_sq_d2 sq_d2 vdd 100000.0
ILEAK_sq_d2 sq_d2 0 1.1e-06
RPU_sq_d3 sq_d3 vdd 100000.0
ILEAK_sq_d3 sq_d3 0 1.1e-06
RPU_sq_d4 sq_d4 vdd 100000.0
ILEAK_sq_d4 sq_d4 0 1.1e-06
RPU_sq_d5 sq_d5 vdd 100000.0
ILEAK_sq_d5 sq_d5 0 1.1e-06
RPU_sq_d6 sq_d6 vdd 100000.0
ILEAK_sq_d6 sq_d6 0 1.1e-06
RPU_sq_d7 sq_d7 vdd 100000.0
ILEAK_sq_d7 sq_d7 0 1.1e-06
RPU_sq_d8 sq_d8 vdd 100000.0
ILEAK_sq_d8 sq_d8 0 1.1e-06
RPU_sq_e1 sq_e1 vdd 100000.0
ILEAK_sq_e1 sq_e1 0 1.1e-06
RPU_sq_e2 sq_e2 vdd 100000.0
ILEAK_sq_e2 sq_e2 0 1.1e-06
RPU_sq_e3 sq_e3 vdd 100000.0
ILEAK_sq_e3 sq_e3 0 1.1e-06
RPU_sq_e4 sq_e4 vdd 100000.0
ILEAK_sq_e4 sq_e4 0 1.1e-06
RPU_sq_e5 sq_e5 vdd 100000.0
ILEAK_sq_e5 sq_e5 0 1.1e-06
RPU_sq_e6 sq_e6 vdd 100000.0
ILEAK_sq_e6 sq_e6 0 1.1e-06
RPU_sq_e7 sq_e7 vdd 100000.0
ILEAK_sq_e7 sq_e7 0 1.1e-06
RPU_sq_e8 sq_e8 vdd 100000.0
ILEAK_sq_e8 sq_e8 0 1.1e-06
RPU_sq_f1 sq_f1 vdd 100000.0
ILEAK_sq_f1 sq_f1 0 1.1e-06
RPU_sq_f2 sq_f2 vdd 100000.0
ILEAK_sq_f2 sq_f2 0 1.1e-06
RPU_sq_f3 sq_f3 vdd 100000.0
ILEAK_sq_f3 sq_f3 0 1.1e-06
RPU_sq_f4 sq_f4 vdd 100000.0
ILEAK_sq_f4 sq_f4 0 1.1e-06
RPU_sq_f5 sq_f5 vdd 100000.0
ILEAK_sq_f5 sq_f5 0 1.1e-06
RPU_sq_f6 sq_f6 vdd 100000.0
ILEAK_sq_f6 sq_f6 0 1.1e-06
RPU_sq_f7 sq_f7 vdd 100000.0
ILEAK_sq_f7 sq_f7 0 1.1e-06
RPU_sq_f8 sq_f8 vdd 100000.0
ILEAK_sq_f8 sq_f8 0 1.1e-06
RPU_sq_g1 sq_g1 vdd 100000.0
ILEAK_sq_g1 sq_g1 0 1.1e-06
RPU_sq_g2 sq_g2 vdd 100000.0
ILEAK_sq_g2 sq_g2 0 1.1e-06
RPU_sq_g3 sq_g3 vdd 100000.0
ILEAK_sq_g3 sq_g3 0 1.1e-06
RPU_sq_g4 sq_g4 vdd 100000.0
ILEAK_sq_g4 sq_g4 0 1.1e-06
RPU_sq_g5 sq_g5 vdd 100000.0
ILEAK_sq_g5 sq_g5 0 1.1e-06
RPU_sq_g6 sq_g6 vdd 100000.0
ILEAK_sq_g6 sq_g6 0 1.1e-06
RPU_sq_g7 sq_g7 vdd 100000.0
ILEAK_sq_g7 sq_g7 0 1.1e-06
RPU_sq_g8 sq_g8 vdd 100000.0
ILEAK_sq_g8 sq_g8 0 1.1e-06
RPU_sq_h1 sq_h1 vdd 100000.0
ILEAK_sq_h1 sq_h1 0 1.1e-06
RPU_sq_h2 sq_h2 vdd 100000.0
ILEAK_sq_h2 sq_h2 0 1.1e-06
RPU_sq_h3 sq_h3 vdd 100000.0
ILEAK_sq_h3 sq_h3 0 1.1e-06
RPU_sq_h4 sq_h4 vdd 100000.0
ILEAK_sq_h4 sq_h4 0 1.1e-06
RPU_sq_h5 sq_h5 vdd 100000.0
ILEAK_sq_h5 sq_h5 0 1.1e-06
RPU_sq_h6 sq_h6 vdd 100000.0
ILEAK_sq_h6 sq_h6 0 1.1e-06
RPU_sq_h7 sq_h7 vdd 100000.0
ILEAK_sq_h7 sq_h7 0 1.1e-06
RPU_sq_h8 sq_h8 vdd 100000.0
ILEAK_sq_h8 sq_h8 0 1.1e-06
.op
.control
run
let result_a1 = v(sq_a1) - 2.508
let result_a2 = v(sq_a2) - 2.508
let result_a3 = v(sq_a3) - 2.508
let result_a4 = v(sq_a4) - 2.508
let result_a5 = v(sq_a5) - 2.508
let result_a6 = v(sq_a6) - 2.508
let result_a7 = v(sq_a7) - 2.508
let result_a8 = v(sq_a8) - 2.508
let result_b1 = v(sq_b1) - 2.508
let result_b2 = v(sq_b2) - 2.508
let result_b3 = v(sq_b3) - 2.508
let result_b4 = v(sq_b4) - 2.508
let result_b5 = v(sq_b5) - 2.508
let result_b6 = v(sq_b6) - 2.508
let result_b7 = v(sq_b7) - 2.508
let result_b8 = v(sq_b8) - 2.508
let result_c1 = v(sq_c1) - 2.508
let result_c2 = v(sq_c2) - 2.508
let result_c3 = v(sq_c3) - 2.508
let result_c4 = v(sq_c4) - 2.508
let result_c5 = v(sq_c5) - 2.508
let result_c6 = v(sq_c6) - 2.508
let result_c7 = v(sq_c7) - 2.508
let result_c8 = v(sq_c8) - 2.508
let result_d1 = v(sq_d1) - 2.508
let result_d2 = v(sq_d2) - 2.508
let result_d3 = v(sq_d3) - 2.508
let result_d4 = v(sq_d4) - 2.508
let result_d5 = v(sq_d5) - 2.508
let result_d6 = v(sq_d6) - 2.508
let result_d7 = v(sq_d7) - 2.508
let result_d8 = v(sq_d8) - 2.508
let result_e1 = v(sq_e1) - 2.508
let result_e2 = v(sq_e2) - 2.508
let result_e3 = v(sq_e3) - 2.508
let result_e4 = v(sq_e4) - 2.508
let result_e5 = v(sq_e5) - 2.508
let result_e6 = v(sq_e6) - 2.508
let result_e7 = v(sq_e7) - 2.508
let result_e8 = v(sq_e8) - 2.508
let result_f1 = v(sq_f1) - 2.508
let result_f2 = v(sq_f2) - 2.508
let result_f3 = v(sq_f3) - 2.508
let result_f4 = v(sq_f4) - 2.508
let result_f5 = v(sq_f5) - 2.508
let result_f6 = v(sq_f6) - 2.508
let result_f7 = v(sq_f7) - 2.508
let result_f8 = v(sq_f8) - 2.508
let result_g1 = v(sq_g1) - 2.508
let result_g2 = v(sq_g2) - 2.508
let result_g3 = v(sq_g3) - 2.508
let result_g4 = v(sq_g4) - 2.508
let result_g5 = v(sq_g5) - 2.508
let result_g6 = v(sq_g6) - 2.508
let result_g7 = v(sq_g7) - 2.508
let result_g8 = v(sq_g8) - 2.508
let result_h1 = v(sq_h1) - 2.508
let result_h2 = v(sq_h2) - 2.508
let result_h3 = v(sq_h3) - 2.508
let result_h4 = v(sq_h4) - 2.508
let result_h5 = v(sq_h5) - 2.508
let result_h6 = v(sq_h6) - 2.508
let result_h7 = v(sq_h7) - 2.508
let result_h8 = v(sq_h8) - 2.508
if result_a1 < 0
echo "ASSERTION FAILED: result_a1 below 0"
quit 1
end
if result_a1 > 3.135
echo "ASSERTION FAILED: result_a1 above 3.135"
quit 1
end
if result_a2 < 0
echo "ASSERTION FAILED: result_a2 below 0"
quit 1
end
if result_a2 > 3.135
echo "ASSERTION FAILED: result_a2 above 3.135"
quit 1
end
if result_a3 < 0
echo "ASSERTION FAILED: result_a3 below 0"
quit 1
end
if result_a3 > 3.135
echo "ASSERTION FAILED: result_a3 above 3.135"
quit 1
end
if result_a4 < 0
echo "ASSERTION FAILED: result_a4 below 0"
quit 1
end
if result_a4 > 3.135
echo "ASSERTION FAILED: result_a4 above 3.135"
quit 1
end
if result_a5 < 0
echo "ASSERTION FAILED: result_a5 below 0"
quit 1
end
if result_a5 > 3.135
echo "ASSERTION FAILED: result_a5 above 3.135"
quit 1
end
if result_a6 < 0
echo "ASSERTION FAILED: result_a6 below 0"
quit 1
end
if result_a6 > 3.135
echo "ASSERTION FAILED: result_a6 above 3.135"
quit 1
end
if result_a7 < 0
echo "ASSERTION FAILED: result_a7 below 0"
quit 1
end
if result_a7 > 3.135
echo "ASSERTION FAILED: result_a7 above 3.135"
quit 1
end
if result_a8 < 0
echo "ASSERTION FAILED: result_a8 below 0"
quit 1
end
if result_a8 > 3.135
echo "ASSERTION FAILED: result_a8 above 3.135"
quit 1
end
if result_b1 < 0
echo "ASSERTION FAILED: result_b1 below 0"
quit 1
end
if result_b1 > 3.135
echo "ASSERTION FAILED: result_b1 above 3.135"
quit 1
end
if result_b2 < 0
echo "ASSERTION FAILED: result_b2 below 0"
quit 1
end
if result_b2 > 3.135
echo "ASSERTION FAILED: result_b2 above 3.135"
quit 1
end
if result_b3 < 0
echo "ASSERTION FAILED: result_b3 below 0"
quit 1
end
if result_b3 > 3.135
echo "ASSERTION FAILED: result_b3 above 3.135"
quit 1
end
if result_b4 < 0
echo "ASSERTION FAILED: result_b4 below 0"
quit 1
end
if result_b4 > 3.135
echo "ASSERTION FAILED: result_b4 above 3.135"
quit 1
end
if result_b5 < 0
echo "ASSERTION FAILED: result_b5 below 0"
quit 1
end
if result_b5 > 3.135
echo "ASSERTION FAILED: result_b5 above 3.135"
quit 1
end
if result_b6 < 0
echo "ASSERTION FAILED: result_b6 below 0"
quit 1
end
if result_b6 > 3.135
echo "ASSERTION FAILED: result_b6 above 3.135"
quit 1
end
if result_b7 < 0
echo "ASSERTION FAILED: result_b7 below 0"
quit 1
end
if result_b7 > 3.135
echo "ASSERTION FAILED: result_b7 above 3.135"
quit 1
end
if result_b8 < 0
echo "ASSERTION FAILED: result_b8 below 0"
quit 1
end
if result_b8 > 3.135
echo "ASSERTION FAILED: result_b8 above 3.135"
quit 1
end
if result_c1 < 0
echo "ASSERTION FAILED: result_c1 below 0"
quit 1
end
if result_c1 > 3.135
echo "ASSERTION FAILED: result_c1 above 3.135"
quit 1
end
if result_c2 < 0
echo "ASSERTION FAILED: result_c2 below 0"
quit 1
end
if result_c2 > 3.135
echo "ASSERTION FAILED: result_c2 above 3.135"
quit 1
end
if result_c3 < 0
echo "ASSERTION FAILED: result_c3 below 0"
quit 1
end
if result_c3 > 3.135
echo "ASSERTION FAILED: result_c3 above 3.135"
quit 1
end
if result_c4 < 0
echo "ASSERTION FAILED: result_c4 below 0"
quit 1
end
if result_c4 > 3.135
echo "ASSERTION FAILED: result_c4 above 3.135"
quit 1
end
if result_c5 < 0
echo "ASSERTION FAILED: result_c5 below 0"
quit 1
end
if result_c5 > 3.135
echo "ASSERTION FAILED: result_c5 above 3.135"
quit 1
end
if result_c6 < 0
echo "ASSERTION FAILED: result_c6 below 0"
quit 1
end
if result_c6 > 3.135
echo "ASSERTION FAILED: result_c6 above 3.135"
quit 1
end
if result_c7 < 0
echo "ASSERTION FAILED: result_c7 below 0"
quit 1
end
if result_c7 > 3.135
echo "ASSERTION FAILED: result_c7 above 3.135"
quit 1
end
if result_c8 < 0
echo "ASSERTION FAILED: result_c8 below 0"
quit 1
end
if result_c8 > 3.135
echo "ASSERTION FAILED: result_c8 above 3.135"
quit 1
end
if result_d1 < 0
echo "ASSERTION FAILED: result_d1 below 0"
quit 1
end
if result_d1 > 3.135
echo "ASSERTION FAILED: result_d1 above 3.135"
quit 1
end
if result_d2 < 0
echo "ASSERTION FAILED: result_d2 below 0"
quit 1
end
if result_d2 > 3.135
echo "ASSERTION FAILED: result_d2 above 3.135"
quit 1
end
if result_d3 < 0
echo "ASSERTION FAILED: result_d3 below 0"
quit 1
end
if result_d3 > 3.135
echo "ASSERTION FAILED: result_d3 above 3.135"
quit 1
end
if result_d4 < 0
echo "ASSERTION FAILED: result_d4 below 0"
quit 1
end
if result_d4 > 3.135
echo "ASSERTION FAILED: result_d4 above 3.135"
quit 1
end
if result_d5 < 0
echo "ASSERTION FAILED: result_d5 below 0"
quit 1
end
if result_d5 > 3.135
echo "ASSERTION FAILED: result_d5 above 3.135"
quit 1
end
if result_d6 < 0
echo "ASSERTION FAILED: result_d6 below 0"
quit 1
end
if result_d6 > 3.135
echo "ASSERTION FAILED: result_d6 above 3.135"
quit 1
end
if result_d7 < 0
echo "ASSERTION FAILED: result_d7 below 0"
quit 1
end
if result_d7 > 3.135
echo "ASSERTION FAILED: result_d7 above 3.135"
quit 1
end
if result_d8 < 0
echo "ASSERTION FAILED: result_d8 below 0"
quit 1
end
if result_d8 > 3.135
echo "ASSERTION FAILED: result_d8 above 3.135"
quit 1
end
if result_e1 < 0
echo "ASSERTION FAILED: result_e1 below 0"
quit 1
end
if result_e1 > 3.135
echo "ASSERTION FAILED: result_e1 above 3.135"
quit 1
end
if result_e2 < 0
echo "ASSERTION FAILED: result_e2 below 0"
quit 1
end
if result_e2 > 3.135
echo "ASSERTION FAILED: result_e2 above 3.135"
quit 1
end
if result_e3 < 0
echo "ASSERTION FAILED: result_e3 below 0"
quit 1
end
if result_e3 > 3.135
echo "ASSERTION FAILED: result_e3 above 3.135"
quit 1
end
if result_e4 < 0
echo "ASSERTION FAILED: result_e4 below 0"
quit 1
end
if result_e4 > 3.135
echo "ASSERTION FAILED: result_e4 above 3.135"
quit 1
end
if result_e5 < 0
echo "ASSERTION FAILED: result_e5 below 0"
quit 1
end
if result_e5 > 3.135
echo "ASSERTION FAILED: result_e5 above 3.135"
quit 1
end
if result_e6 < 0
echo "ASSERTION FAILED: result_e6 below 0"
quit 1
end
if result_e6 > 3.135
echo "ASSERTION FAILED: result_e6 above 3.135"
quit 1
end
if result_e7 < 0
echo "ASSERTION FAILED: result_e7 below 0"
quit 1
end
if result_e7 > 3.135
echo "ASSERTION FAILED: result_e7 above 3.135"
quit 1
end
if result_e8 < 0
echo "ASSERTION FAILED: result_e8 below 0"
quit 1
end
if result_e8 > 3.135
echo "ASSERTION FAILED: result_e8 above 3.135"
quit 1
end
if result_f1 < 0
echo "ASSERTION FAILED: result_f1 below 0"
quit 1
end
if result_f1 > 3.135
echo "ASSERTION FAILED: result_f1 above 3.135"
quit 1
end
if result_f2 < 0
echo "ASSERTION FAILED: result_f2 below 0"
quit 1
end
if result_f2 > 3.135
echo "ASSERTION FAILED: result_f2 above 3.135"
quit 1
end
if result_f3 < 0
echo "ASSERTION FAILED: result_f3 below 0"
quit 1
end
if result_f3 > 3.135
echo "ASSERTION FAILED: result_f3 above 3.135"
quit 1
end
if result_f4 < 0
echo "ASSERTION FAILED: result_f4 below 0"
quit 1
end
if result_f4 > 3.135
echo "ASSERTION FAILED: result_f4 above 3.135"
quit 1
end
if result_f5 < 0
echo "ASSERTION FAILED: result_f5 below 0"
quit 1
end
if result_f5 > 3.135
echo "ASSERTION FAILED: result_f5 above 3.135"
quit 1
end
if result_f6 < 0
echo "ASSERTION FAILED: result_f6 below 0"
quit 1
end
if result_f6 > 3.135
echo "ASSERTION FAILED: result_f6 above 3.135"
quit 1
end
if result_f7 < 0
echo "ASSERTION FAILED: result_f7 below 0"
quit 1
end
if result_f7 > 3.135
echo "ASSERTION FAILED: result_f7 above 3.135"
quit 1
end
if result_f8 < 0
echo "ASSERTION FAILED: result_f8 below 0"
quit 1
end
if result_f8 > 3.135
echo "ASSERTION FAILED: result_f8 above 3.135"
quit 1
end
if result_g1 < 0
echo "ASSERTION FAILED: result_g1 below 0"
quit 1
end
if result_g1 > 3.135
echo "ASSERTION FAILED: result_g1 above 3.135"
quit 1
end
if result_g2 < 0
echo "ASSERTION FAILED: result_g2 below 0"
quit 1
end
if result_g2 > 3.135
echo "ASSERTION FAILED: result_g2 above 3.135"
quit 1
end
if result_g3 < 0
echo "ASSERTION FAILED: result_g3 below 0"
quit 1
end
if result_g3 > 3.135
echo "ASSERTION FAILED: result_g3 above 3.135"
quit 1
end
if result_g4 < 0
echo "ASSERTION FAILED: result_g4 below 0"
quit 1
end
if result_g4 > 3.135
echo "ASSERTION FAILED: result_g4 above 3.135"
quit 1
end
if result_g5 < 0
echo "ASSERTION FAILED: result_g5 below 0"
quit 1
end
if result_g5 > 3.135
echo "ASSERTION FAILED: result_g5 above 3.135"
quit 1
end
if result_g6 < 0
echo "ASSERTION FAILED: result_g6 below 0"
quit 1
end
if result_g6 > 3.135
echo "ASSERTION FAILED: result_g6 above 3.135"
quit 1
end
if result_g7 < 0
echo "ASSERTION FAILED: result_g7 below 0"
quit 1
end
if result_g7 > 3.135
echo "ASSERTION FAILED: result_g7 above 3.135"
quit 1
end
if result_g8 < 0
echo "ASSERTION FAILED: result_g8 below 0"
quit 1
end
if result_g8 > 3.135
echo "ASSERTION FAILED: result_g8 above 3.135"
quit 1
end
if result_h1 < 0
echo "ASSERTION FAILED: result_h1 below 0"
quit 1
end
if result_h1 > 3.135
echo "ASSERTION FAILED: result_h1 above 3.135"
quit 1
end
if result_h2 < 0
echo "ASSERTION FAILED: result_h2 below 0"
quit 1
end
if result_h2 > 3.135
echo "ASSERTION FAILED: result_h2 above 3.135"
quit 1
end
if result_h3 < 0
echo "ASSERTION FAILED: result_h3 below 0"
quit 1
end
if result_h3 > 3.135
echo "ASSERTION FAILED: result_h3 above 3.135"
quit 1
end
if result_h4 < 0
echo "ASSERTION FAILED: result_h4 below 0"
quit 1
end
if result_h4 > 3.135
echo "ASSERTION FAILED: result_h4 above 3.135"
quit 1
end
if result_h5 < 0
echo "ASSERTION FAILED: result_h5 below 0"
quit 1
end
if result_h5 > 3.135
echo "ASSERTION FAILED: result_h5 above 3.135"
quit 1
end
if result_h6 < 0
echo "ASSERTION FAILED: result_h6 below 0"
quit 1
end
if result_h6 > 3.135
echo "ASSERTION FAILED: result_h6 above 3.135"
quit 1
end
if result_h7 < 0
echo "ASSERTION FAILED: result_h7 below 0"
quit 1
end
if result_h7 > 3.135
echo "ASSERTION FAILED: result_h7 above 3.135"
quit 1
end
if result_h8 < 0
echo "ASSERTION FAILED: result_h8 below 0"
quit 1
end
if result_h8 > 3.135
echo "ASSERTION FAILED: result_h8 above 3.135"
quit 1
end
quit 0
.endc
.end
