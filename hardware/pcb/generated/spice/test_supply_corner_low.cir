Generated chess-board supply corner, low
Rph_0_0 p_0_0 p_1_0 5.017838e-04
Rpv_0_0 p_0_0 p_0_1 5.017838e-04
Rph_0_1 p_0_1 p_1_1 5.017838e-04
Rpv_0_1 p_0_1 p_0_2 5.017838e-04
Rph_0_2 p_0_2 p_1_2 5.017838e-04
Rpv_0_2 p_0_2 p_0_3 5.017838e-04
Rph_0_3 p_0_3 p_1_3 5.017838e-04
Rpv_0_3 p_0_3 p_0_4 5.017838e-04
Rph_0_4 p_0_4 p_1_4 5.017838e-04
Rpv_0_4 p_0_4 p_0_5 5.017838e-04
Rph_0_5 p_0_5 p_1_5 5.017838e-04
Rpv_0_5 p_0_5 p_0_6 5.017838e-04
Rph_0_6 p_0_6 p_1_6 5.017838e-04
Rpv_0_6 p_0_6 p_0_7 5.017838e-04
Rph_0_7 p_0_7 p_1_7 5.017838e-04
Rpv_0_7 p_0_7 p_0_8 5.017838e-04
Rph_0_8 p_0_8 p_1_8 5.017838e-04
Rpv_0_8 p_0_8 p_0_9 5.017838e-04
Rph_0_9 p_0_9 p_1_9 5.017838e-04
Rpv_0_9 p_0_9 p_0_10 5.017838e-04
Rph_0_10 p_0_10 p_1_10 5.017838e-04
Rpv_0_10 p_0_10 p_0_11 5.017838e-04
Rph_0_11 p_0_11 p_1_11 5.017838e-04
Rpv_0_11 p_0_11 p_0_12 5.017838e-04
Rph_0_12 p_0_12 p_1_12 5.017838e-04
Rpv_0_12 p_0_12 p_0_13 5.017838e-04
Rph_0_13 p_0_13 p_1_13 5.017838e-04
Rpv_0_13 p_0_13 p_0_14 5.017838e-04
Rph_0_14 p_0_14 p_1_14 5.017838e-04
Rpv_0_14 p_0_14 p_0_15 5.017838e-04
Rph_0_15 p_0_15 p_1_15 5.017838e-04
Rpv_0_15 p_0_15 p_0_16 5.017838e-04
Rph_0_16 p_0_16 p_1_16 5.017838e-04
Rpv_0_16 p_0_16 p_0_17 5.017838e-04
Rph_0_17 p_0_17 p_1_17 5.017838e-04
Rpv_0_17 p_0_17 p_0_18 5.017838e-04
Rph_0_18 p_0_18 p_1_18 5.017838e-04
Rpv_0_18 p_0_18 p_0_19 5.017838e-04
Rph_0_19 p_0_19 p_1_19 5.017838e-04
Rpv_0_19 p_0_19 p_0_20 5.017838e-04
Rph_0_20 p_0_20 p_1_20 5.017838e-04
Rpv_0_20 p_0_20 p_0_21 5.017838e-04
Rph_0_21 p_0_21 p_1_21 5.017838e-04
Rpv_0_21 p_0_21 p_0_22 5.017838e-04
Rph_0_22 p_0_22 p_1_22 5.017838e-04
Rpv_0_22 p_0_22 p_0_23 5.017838e-04
Rph_0_23 p_0_23 p_1_23 5.017838e-04
Rpv_0_23 p_0_23 p_0_24 5.017838e-04
Rph_0_24 p_0_24 p_1_24 5.017838e-04
Rpv_0_24 p_0_24 p_0_25 5.017838e-04
Rph_0_25 p_0_25 p_1_25 5.017838e-04
Rpv_0_25 p_0_25 p_0_26 5.017838e-04
Rph_0_26 p_0_26 p_1_26 5.017838e-04
Rpv_0_26 p_0_26 p_0_27 5.017838e-04
Rph_0_27 p_0_27 p_1_27 5.017838e-04
Rpv_0_27 p_0_27 p_0_28 5.017838e-04
Rph_0_28 p_0_28 p_1_28 5.017838e-04
Rpv_0_28 p_0_28 p_0_29 5.017838e-04
Rph_0_29 p_0_29 p_1_29 5.017838e-04
Rpv_0_29 p_0_29 p_0_30 5.017838e-04
Rph_0_30 p_0_30 p_1_30 5.017838e-04
Rpv_0_30 p_0_30 p_0_31 5.017838e-04
Rph_0_31 p_0_31 p_1_31 5.017838e-04
Rpv_0_31 p_0_31 p_0_32 5.017838e-04
Rph_0_32 p_0_32 p_1_32 5.017838e-04
Rpv_0_32 p_0_32 p_0_33 5.017838e-04
Rph_0_33 p_0_33 p_1_33 5.017838e-04
Rpv_0_33 p_0_33 p_0_34 5.017838e-04
Rph_0_34 p_0_34 p_1_34 5.017838e-04
Rpv_0_34 p_0_34 p_0_35 5.017838e-04
Rph_0_35 p_0_35 p_1_35 5.017838e-04
Rpv_0_35 p_0_35 p_0_36 5.017838e-04
Rph_0_36 p_0_36 p_1_36 5.017838e-04
Rpv_0_36 p_0_36 p_0_37 5.017838e-04
Rph_0_37 p_0_37 p_1_37 5.017838e-04
Rpv_0_37 p_0_37 p_0_38 5.017838e-04
Rph_0_38 p_0_38 p_1_38 5.017838e-04
Rpv_0_38 p_0_38 p_0_39 5.017838e-04
Rph_0_39 p_0_39 p_1_39 5.017838e-04
Rpv_0_39 p_0_39 p_0_40 5.017838e-04
Rph_0_40 p_0_40 p_1_40 5.017838e-04
Rpv_0_40 p_0_40 p_0_41 5.017838e-04
Rph_0_41 p_0_41 p_1_41 5.017838e-04
Rpv_0_41 p_0_41 p_0_42 5.017838e-04
Rph_0_42 p_0_42 p_1_42 5.017838e-04
Rpv_0_42 p_0_42 p_0_43 5.017838e-04
Rph_0_43 p_0_43 p_1_43 5.017838e-04
Rpv_0_43 p_0_43 p_0_44 5.017838e-04
Rph_0_44 p_0_44 p_1_44 5.017838e-04
Rpv_0_44 p_0_44 p_0_45 5.017838e-04
Rph_0_45 p_0_45 p_1_45 5.017838e-04
Rpv_0_45 p_0_45 p_0_46 5.017838e-04
Rph_0_46 p_0_46 p_1_46 5.017838e-04
Rpv_0_46 p_0_46 p_0_47 5.017838e-04
Rph_0_47 p_0_47 p_1_47 5.017838e-04
Rpv_0_47 p_0_47 p_0_48 5.017838e-04
Rph_0_48 p_0_48 p_1_48 5.017838e-04
Rpv_0_48 p_0_48 p_0_49 5.017838e-04
Rph_0_49 p_0_49 p_1_49 5.017838e-04
Rpv_0_49 p_0_49 p_0_50 5.017838e-04
Rph_0_50 p_0_50 p_1_50 5.017838e-04
Rpv_0_50 p_0_50 p_0_51 5.017838e-04
Rph_0_51 p_0_51 p_1_51 5.017838e-04
Rpv_0_51 p_0_51 p_0_52 5.017838e-04
Rph_0_52 p_0_52 p_1_52 5.017838e-04
Rpv_0_52 p_0_52 p_0_53 5.017838e-04
Rph_0_53 p_0_53 p_1_53 5.017838e-04
Rpv_0_53 p_0_53 p_0_54 5.017838e-04
Rph_0_54 p_0_54 p_1_54 5.017838e-04
Rpv_0_54 p_0_54 p_0_55 5.017838e-04
Rph_0_55 p_0_55 p_1_55 5.017838e-04
Rpv_0_55 p_0_55 p_0_56 5.017838e-04
Rph_0_56 p_0_56 p_1_56 5.017838e-04
Rpv_0_56 p_0_56 p_0_57 5.017838e-04
Rph_0_57 p_0_57 p_1_57 5.017838e-04
Rpv_0_57 p_0_57 p_0_58 5.017838e-04
Rph_0_58 p_0_58 p_1_58 5.017838e-04
Rpv_0_58 p_0_58 p_0_59 5.017838e-04
Rph_0_59 p_0_59 p_1_59 5.017838e-04
Rpv_0_59 p_0_59 p_0_60 5.017838e-04
Rph_0_60 p_0_60 p_1_60 5.017838e-04
Rpv_0_60 p_0_60 p_0_61 5.017838e-04
Rph_0_61 p_0_61 p_1_61 5.017838e-04
Rpv_0_61 p_0_61 p_0_62 5.017838e-04
Rph_0_62 p_0_62 p_1_62 5.017838e-04
Rpv_0_62 p_0_62 p_0_63 5.017838e-04
Rph_0_63 p_0_63 p_1_63 5.017838e-04
Rpv_0_63 p_0_63 p_0_64 5.017838e-04
Rph_0_64 p_0_64 p_1_64 5.017838e-04
Rpv_0_64 p_0_64 p_0_65 5.017838e-04
Rph_0_65 p_0_65 p_1_65 5.017838e-04
Rpv_0_65 p_0_65 p_0_66 5.017838e-04
Rph_0_66 p_0_66 p_1_66 5.017838e-04
Rpv_0_66 p_0_66 p_0_67 5.017838e-04
Rph_0_67 p_0_67 p_1_67 5.017838e-04
Rpv_0_67 p_0_67 p_0_68 5.017838e-04
Rph_0_68 p_0_68 p_1_68 5.017838e-04
Rpv_0_68 p_0_68 p_0_69 5.017838e-04
Rph_0_69 p_0_69 p_1_69 5.017838e-04
Rpv_0_69 p_0_69 p_0_70 5.017838e-04
Rph_0_70 p_0_70 p_1_70 5.017838e-04
Rpv_0_70 p_0_70 p_0_71 5.017838e-04
Rph_0_71 p_0_71 p_1_71 5.017838e-04
Rph_1_0 p_1_0 p_2_0 5.017838e-04
Rpv_1_0 p_1_0 p_1_1 5.017838e-04
Rph_1_1 p_1_1 p_2_1 5.017838e-04
Rpv_1_1 p_1_1 p_1_2 5.017838e-04
Rph_1_2 p_1_2 p_2_2 5.017838e-04
Rpv_1_2 p_1_2 p_1_3 5.017838e-04
Rph_1_3 p_1_3 p_2_3 5.017838e-04
Rpv_1_3 p_1_3 p_1_4 5.017838e-04
Rph_1_4 p_1_4 p_2_4 5.017838e-04
Rpv_1_4 p_1_4 p_1_5 5.017838e-04
Rph_1_5 p_1_5 p_2_5 5.017838e-04
Rpv_1_5 p_1_5 p_1_6 5.017838e-04
Rph_1_6 p_1_6 p_2_6 5.017838e-04
Rpv_1_6 p_1_6 p_1_7 5.017838e-04
Rph_1_7 p_1_7 p_2_7 5.017838e-04
Rpv_1_7 p_1_7 p_1_8 5.017838e-04
Rph_1_8 p_1_8 p_2_8 5.017838e-04
Rpv_1_8 p_1_8 p_1_9 5.017838e-04
Rph_1_9 p_1_9 p_2_9 5.017838e-04
Rpv_1_9 p_1_9 p_1_10 5.017838e-04
Rph_1_10 p_1_10 p_2_10 5.017838e-04
Rpv_1_10 p_1_10 p_1_11 5.017838e-04
Rph_1_11 p_1_11 p_2_11 5.017838e-04
Rpv_1_11 p_1_11 p_1_12 5.017838e-04
Rph_1_12 p_1_12 p_2_12 5.017838e-04
Rpv_1_12 p_1_12 p_1_13 5.017838e-04
Rph_1_13 p_1_13 p_2_13 5.017838e-04
Rpv_1_13 p_1_13 p_1_14 5.017838e-04
Rph_1_14 p_1_14 p_2_14 5.017838e-04
Rpv_1_14 p_1_14 p_1_15 5.017838e-04
Rph_1_15 p_1_15 p_2_15 5.017838e-04
Rpv_1_15 p_1_15 p_1_16 5.017838e-04
Rph_1_16 p_1_16 p_2_16 5.017838e-04
Rpv_1_16 p_1_16 p_1_17 5.017838e-04
Rph_1_17 p_1_17 p_2_17 5.017838e-04
Rpv_1_17 p_1_17 p_1_18 5.017838e-04
Rph_1_18 p_1_18 p_2_18 5.017838e-04
Rpv_1_18 p_1_18 p_1_19 5.017838e-04
Rph_1_19 p_1_19 p_2_19 5.017838e-04
Rpv_1_19 p_1_19 p_1_20 5.017838e-04
Rph_1_20 p_1_20 p_2_20 5.017838e-04
Rpv_1_20 p_1_20 p_1_21 5.017838e-04
Rph_1_21 p_1_21 p_2_21 5.017838e-04
Rpv_1_21 p_1_21 p_1_22 5.017838e-04
Rph_1_22 p_1_22 p_2_22 5.017838e-04
Rpv_1_22 p_1_22 p_1_23 5.017838e-04
Rph_1_23 p_1_23 p_2_23 5.017838e-04
Rpv_1_23 p_1_23 p_1_24 5.017838e-04
Rph_1_24 p_1_24 p_2_24 5.017838e-04
Rpv_1_24 p_1_24 p_1_25 5.017838e-04
Rph_1_25 p_1_25 p_2_25 5.017838e-04
Rpv_1_25 p_1_25 p_1_26 5.017838e-04
Rph_1_26 p_1_26 p_2_26 5.017838e-04
Rpv_1_26 p_1_26 p_1_27 5.017838e-04
Rph_1_27 p_1_27 p_2_27 5.017838e-04
Rpv_1_27 p_1_27 p_1_28 5.017838e-04
Rph_1_28 p_1_28 p_2_28 5.017838e-04
Rpv_1_28 p_1_28 p_1_29 5.017838e-04
Rph_1_29 p_1_29 p_2_29 5.017838e-04
Rpv_1_29 p_1_29 p_1_30 5.017838e-04
Rph_1_30 p_1_30 p_2_30 5.017838e-04
Rpv_1_30 p_1_30 p_1_31 5.017838e-04
Rph_1_31 p_1_31 p_2_31 5.017838e-04
Rpv_1_31 p_1_31 p_1_32 5.017838e-04
Rph_1_32 p_1_32 p_2_32 5.017838e-04
Rpv_1_32 p_1_32 p_1_33 5.017838e-04
Rph_1_33 p_1_33 p_2_33 5.017838e-04
Rpv_1_33 p_1_33 p_1_34 5.017838e-04
Rph_1_34 p_1_34 p_2_34 5.017838e-04
Rpv_1_34 p_1_34 p_1_35 5.017838e-04
Rph_1_35 p_1_35 p_2_35 5.017838e-04
Rpv_1_35 p_1_35 p_1_36 5.017838e-04
Rph_1_36 p_1_36 p_2_36 5.017838e-04
Rpv_1_36 p_1_36 p_1_37 5.017838e-04
Rph_1_37 p_1_37 p_2_37 5.017838e-04
Rpv_1_37 p_1_37 p_1_38 5.017838e-04
Rph_1_38 p_1_38 p_2_38 5.017838e-04
Rpv_1_38 p_1_38 p_1_39 5.017838e-04
Rph_1_39 p_1_39 p_2_39 5.017838e-04
Rpv_1_39 p_1_39 p_1_40 5.017838e-04
Rph_1_40 p_1_40 p_2_40 5.017838e-04
Rpv_1_40 p_1_40 p_1_41 5.017838e-04
Rph_1_41 p_1_41 p_2_41 5.017838e-04
Rpv_1_41 p_1_41 p_1_42 5.017838e-04
Rph_1_42 p_1_42 p_2_42 5.017838e-04
Rpv_1_42 p_1_42 p_1_43 5.017838e-04
Rph_1_43 p_1_43 p_2_43 5.017838e-04
Rpv_1_43 p_1_43 p_1_44 5.017838e-04
Rph_1_44 p_1_44 p_2_44 5.017838e-04
Rpv_1_44 p_1_44 p_1_45 5.017838e-04
Rph_1_45 p_1_45 p_2_45 5.017838e-04
Rpv_1_45 p_1_45 p_1_46 5.017838e-04
Rph_1_46 p_1_46 p_2_46 5.017838e-04
Rpv_1_46 p_1_46 p_1_47 5.017838e-04
Rph_1_47 p_1_47 p_2_47 5.017838e-04
Rpv_1_47 p_1_47 p_1_48 5.017838e-04
Rph_1_48 p_1_48 p_2_48 5.017838e-04
Rpv_1_48 p_1_48 p_1_49 5.017838e-04
Rph_1_49 p_1_49 p_2_49 5.017838e-04
Rpv_1_49 p_1_49 p_1_50 5.017838e-04
Rph_1_50 p_1_50 p_2_50 5.017838e-04
Rpv_1_50 p_1_50 p_1_51 5.017838e-04
Rph_1_51 p_1_51 p_2_51 5.017838e-04
Rpv_1_51 p_1_51 p_1_52 5.017838e-04
Rph_1_52 p_1_52 p_2_52 5.017838e-04
Rpv_1_52 p_1_52 p_1_53 5.017838e-04
Rph_1_53 p_1_53 p_2_53 5.017838e-04
Rpv_1_53 p_1_53 p_1_54 5.017838e-04
Rph_1_54 p_1_54 p_2_54 5.017838e-04
Rpv_1_54 p_1_54 p_1_55 5.017838e-04
Rph_1_55 p_1_55 p_2_55 5.017838e-04
Rpv_1_55 p_1_55 p_1_56 5.017838e-04
Rph_1_56 p_1_56 p_2_56 5.017838e-04
Rpv_1_56 p_1_56 p_1_57 5.017838e-04
Rph_1_57 p_1_57 p_2_57 5.017838e-04
Rpv_1_57 p_1_57 p_1_58 5.017838e-04
Rph_1_58 p_1_58 p_2_58 5.017838e-04
Rpv_1_58 p_1_58 p_1_59 5.017838e-04
Rph_1_59 p_1_59 p_2_59 5.017838e-04
Rpv_1_59 p_1_59 p_1_60 5.017838e-04
Rph_1_60 p_1_60 p_2_60 5.017838e-04
Rpv_1_60 p_1_60 p_1_61 5.017838e-04
Rph_1_61 p_1_61 p_2_61 5.017838e-04
Rpv_1_61 p_1_61 p_1_62 5.017838e-04
Rph_1_62 p_1_62 p_2_62 5.017838e-04
Rpv_1_62 p_1_62 p_1_63 5.017838e-04
Rph_1_63 p_1_63 p_2_63 5.017838e-04
Rpv_1_63 p_1_63 p_1_64 5.017838e-04
Rph_1_64 p_1_64 p_2_64 5.017838e-04
Rpv_1_64 p_1_64 p_1_65 5.017838e-04
Rph_1_65 p_1_65 p_2_65 5.017838e-04
Rpv_1_65 p_1_65 p_1_66 5.017838e-04
Rph_1_66 p_1_66 p_2_66 5.017838e-04
Rpv_1_66 p_1_66 p_1_67 5.017838e-04
Rph_1_67 p_1_67 p_2_67 5.017838e-04
Rpv_1_67 p_1_67 p_1_68 5.017838e-04
Rph_1_68 p_1_68 p_2_68 5.017838e-04
Rpv_1_68 p_1_68 p_1_69 5.017838e-04
Rph_1_69 p_1_69 p_2_69 5.017838e-04
Rpv_1_69 p_1_69 p_1_70 5.017838e-04
Rph_1_70 p_1_70 p_2_70 5.017838e-04
Rpv_1_70 p_1_70 p_1_71 5.017838e-04
Rph_1_71 p_1_71 p_2_71 5.017838e-04
Rph_2_0 p_2_0 p_3_0 5.017838e-04
Rpv_2_0 p_2_0 p_2_1 5.017838e-04
Rph_2_1 p_2_1 p_3_1 5.017838e-04
Rpv_2_1 p_2_1 p_2_2 5.017838e-04
Rph_2_2 p_2_2 p_3_2 5.017838e-04
Rpv_2_2 p_2_2 p_2_3 5.017838e-04
Rph_2_3 p_2_3 p_3_3 5.017838e-04
Rpv_2_3 p_2_3 p_2_4 5.017838e-04
Rph_2_4 p_2_4 p_3_4 5.017838e-04
Rpv_2_4 p_2_4 p_2_5 5.017838e-04
Rph_2_5 p_2_5 p_3_5 5.017838e-04
Rpv_2_5 p_2_5 p_2_6 5.017838e-04
Rph_2_6 p_2_6 p_3_6 5.017838e-04
Rpv_2_6 p_2_6 p_2_7 5.017838e-04
Rph_2_7 p_2_7 p_3_7 5.017838e-04
Rpv_2_7 p_2_7 p_2_8 5.017838e-04
Rph_2_8 p_2_8 p_3_8 5.017838e-04
Rpv_2_8 p_2_8 p_2_9 5.017838e-04
Rph_2_9 p_2_9 p_3_9 5.017838e-04
Rpv_2_9 p_2_9 p_2_10 5.017838e-04
Rph_2_10 p_2_10 p_3_10 5.017838e-04
Rpv_2_10 p_2_10 p_2_11 5.017838e-04
Rph_2_11 p_2_11 p_3_11 5.017838e-04
Rpv_2_11 p_2_11 p_2_12 5.017838e-04
Rph_2_12 p_2_12 p_3_12 5.017838e-04
Rpv_2_12 p_2_12 p_2_13 5.017838e-04
Rph_2_13 p_2_13 p_3_13 5.017838e-04
Rpv_2_13 p_2_13 p_2_14 5.017838e-04
Rph_2_14 p_2_14 p_3_14 5.017838e-04
Rpv_2_14 p_2_14 p_2_15 5.017838e-04
Rph_2_15 p_2_15 p_3_15 5.017838e-04
Rpv_2_15 p_2_15 p_2_16 5.017838e-04
Rph_2_16 p_2_16 p_3_16 5.017838e-04
Rpv_2_16 p_2_16 p_2_17 5.017838e-04
Rph_2_17 p_2_17 p_3_17 5.017838e-04
Rpv_2_17 p_2_17 p_2_18 5.017838e-04
Rph_2_18 p_2_18 p_3_18 5.017838e-04
Rpv_2_18 p_2_18 p_2_19 5.017838e-04
Rph_2_19 p_2_19 p_3_19 5.017838e-04
Rpv_2_19 p_2_19 p_2_20 5.017838e-04
Rph_2_20 p_2_20 p_3_20 5.017838e-04
Rpv_2_20 p_2_20 p_2_21 5.017838e-04
Rph_2_21 p_2_21 p_3_21 5.017838e-04
Rpv_2_21 p_2_21 p_2_22 5.017838e-04
Rph_2_22 p_2_22 p_3_22 5.017838e-04
Rpv_2_22 p_2_22 p_2_23 5.017838e-04
Rph_2_23 p_2_23 p_3_23 5.017838e-04
Rpv_2_23 p_2_23 p_2_24 5.017838e-04
Rph_2_24 p_2_24 p_3_24 5.017838e-04
Rpv_2_24 p_2_24 p_2_25 5.017838e-04
Rph_2_25 p_2_25 p_3_25 5.017838e-04
Rpv_2_25 p_2_25 p_2_26 5.017838e-04
Rph_2_26 p_2_26 p_3_26 5.017838e-04
Rpv_2_26 p_2_26 p_2_27 5.017838e-04
Rph_2_27 p_2_27 p_3_27 5.017838e-04
Rpv_2_27 p_2_27 p_2_28 5.017838e-04
Rph_2_28 p_2_28 p_3_28 5.017838e-04
Rpv_2_28 p_2_28 p_2_29 5.017838e-04
Rph_2_29 p_2_29 p_3_29 5.017838e-04
Rpv_2_29 p_2_29 p_2_30 5.017838e-04
Rph_2_30 p_2_30 p_3_30 5.017838e-04
Rpv_2_30 p_2_30 p_2_31 5.017838e-04
Rph_2_31 p_2_31 p_3_31 5.017838e-04
Rpv_2_31 p_2_31 p_2_32 5.017838e-04
Rph_2_32 p_2_32 p_3_32 5.017838e-04
Rpv_2_32 p_2_32 p_2_33 5.017838e-04
Rph_2_33 p_2_33 p_3_33 5.017838e-04
Rpv_2_33 p_2_33 p_2_34 5.017838e-04
Rph_2_34 p_2_34 p_3_34 5.017838e-04
Rpv_2_34 p_2_34 p_2_35 5.017838e-04
Rph_2_35 p_2_35 p_3_35 5.017838e-04
Rpv_2_35 p_2_35 p_2_36 5.017838e-04
Rph_2_36 p_2_36 p_3_36 5.017838e-04
Rpv_2_36 p_2_36 p_2_37 5.017838e-04
Rph_2_37 p_2_37 p_3_37 5.017838e-04
Rpv_2_37 p_2_37 p_2_38 5.017838e-04
Rph_2_38 p_2_38 p_3_38 5.017838e-04
Rpv_2_38 p_2_38 p_2_39 5.017838e-04
Rph_2_39 p_2_39 p_3_39 5.017838e-04
Rpv_2_39 p_2_39 p_2_40 5.017838e-04
Rph_2_40 p_2_40 p_3_40 5.017838e-04
Rpv_2_40 p_2_40 p_2_41 5.017838e-04
Rph_2_41 p_2_41 p_3_41 5.017838e-04
Rpv_2_41 p_2_41 p_2_42 5.017838e-04
Rph_2_42 p_2_42 p_3_42 5.017838e-04
Rpv_2_42 p_2_42 p_2_43 5.017838e-04
Rph_2_43 p_2_43 p_3_43 5.017838e-04
Rpv_2_43 p_2_43 p_2_44 5.017838e-04
Rph_2_44 p_2_44 p_3_44 5.017838e-04
Rpv_2_44 p_2_44 p_2_45 5.017838e-04
Rph_2_45 p_2_45 p_3_45 5.017838e-04
Rpv_2_45 p_2_45 p_2_46 5.017838e-04
Rph_2_46 p_2_46 p_3_46 5.017838e-04
Rpv_2_46 p_2_46 p_2_47 5.017838e-04
Rph_2_47 p_2_47 p_3_47 5.017838e-04
Rpv_2_47 p_2_47 p_2_48 5.017838e-04
Rph_2_48 p_2_48 p_3_48 5.017838e-04
Rpv_2_48 p_2_48 p_2_49 5.017838e-04
Rph_2_49 p_2_49 p_3_49 5.017838e-04
Rpv_2_49 p_2_49 p_2_50 5.017838e-04
Rph_2_50 p_2_50 p_3_50 5.017838e-04
Rpv_2_50 p_2_50 p_2_51 5.017838e-04
Rph_2_51 p_2_51 p_3_51 5.017838e-04
Rpv_2_51 p_2_51 p_2_52 5.017838e-04
Rph_2_52 p_2_52 p_3_52 5.017838e-04
Rpv_2_52 p_2_52 p_2_53 5.017838e-04
Rph_2_53 p_2_53 p_3_53 5.017838e-04
Rpv_2_53 p_2_53 p_2_54 5.017838e-04
Rph_2_54 p_2_54 p_3_54 5.017838e-04
Rpv_2_54 p_2_54 p_2_55 5.017838e-04
Rph_2_55 p_2_55 p_3_55 5.017838e-04
Rpv_2_55 p_2_55 p_2_56 5.017838e-04
Rph_2_56 p_2_56 p_3_56 5.017838e-04
Rpv_2_56 p_2_56 p_2_57 5.017838e-04
Rph_2_57 p_2_57 p_3_57 5.017838e-04
Rpv_2_57 p_2_57 p_2_58 5.017838e-04
Rph_2_58 p_2_58 p_3_58 5.017838e-04
Rpv_2_58 p_2_58 p_2_59 5.017838e-04
Rph_2_59 p_2_59 p_3_59 5.017838e-04
Rpv_2_59 p_2_59 p_2_60 5.017838e-04
Rph_2_60 p_2_60 p_3_60 5.017838e-04
Rpv_2_60 p_2_60 p_2_61 5.017838e-04
Rph_2_61 p_2_61 p_3_61 5.017838e-04
Rpv_2_61 p_2_61 p_2_62 5.017838e-04
Rph_2_62 p_2_62 p_3_62 5.017838e-04
Rpv_2_62 p_2_62 p_2_63 5.017838e-04
Rph_2_63 p_2_63 p_3_63 5.017838e-04
Rpv_2_63 p_2_63 p_2_64 5.017838e-04
Rph_2_64 p_2_64 p_3_64 5.017838e-04
Rpv_2_64 p_2_64 p_2_65 5.017838e-04
Rph_2_65 p_2_65 p_3_65 5.017838e-04
Rpv_2_65 p_2_65 p_2_66 5.017838e-04
Rph_2_66 p_2_66 p_3_66 5.017838e-04
Rpv_2_66 p_2_66 p_2_67 5.017838e-04
Rph_2_67 p_2_67 p_3_67 5.017838e-04
Rpv_2_67 p_2_67 p_2_68 5.017838e-04
Rph_2_68 p_2_68 p_3_68 5.017838e-04
Rpv_2_68 p_2_68 p_2_69 5.017838e-04
Rph_2_69 p_2_69 p_3_69 5.017838e-04
Rpv_2_69 p_2_69 p_2_70 5.017838e-04
Rph_2_70 p_2_70 p_3_70 5.017838e-04
Rpv_2_70 p_2_70 p_2_71 5.017838e-04
Rph_2_71 p_2_71 p_3_71 5.017838e-04
Rph_3_0 p_3_0 p_4_0 5.017838e-04
Rpv_3_0 p_3_0 p_3_1 5.017838e-04
Rph_3_1 p_3_1 p_4_1 5.017838e-04
Rpv_3_1 p_3_1 p_3_2 5.017838e-04
Rph_3_2 p_3_2 p_4_2 5.017838e-04
Rpv_3_2 p_3_2 p_3_3 5.017838e-04
Rph_3_3 p_3_3 p_4_3 5.017838e-04
Rpv_3_3 p_3_3 p_3_4 5.017838e-04
Rph_3_4 p_3_4 p_4_4 5.017838e-04
Rpv_3_4 p_3_4 p_3_5 5.017838e-04
Rph_3_5 p_3_5 p_4_5 5.017838e-04
Rpv_3_5 p_3_5 p_3_6 5.017838e-04
Rph_3_6 p_3_6 p_4_6 5.017838e-04
Rpv_3_6 p_3_6 p_3_7 5.017838e-04
Rph_3_7 p_3_7 p_4_7 5.017838e-04
Rpv_3_7 p_3_7 p_3_8 5.017838e-04
Rph_3_8 p_3_8 p_4_8 5.017838e-04
Rpv_3_8 p_3_8 p_3_9 5.017838e-04
Rph_3_9 p_3_9 p_4_9 5.017838e-04
Rpv_3_9 p_3_9 p_3_10 5.017838e-04
Rph_3_10 p_3_10 p_4_10 5.017838e-04
Rpv_3_10 p_3_10 p_3_11 5.017838e-04
Rph_3_11 p_3_11 p_4_11 5.017838e-04
Rpv_3_11 p_3_11 p_3_12 5.017838e-04
Rph_3_12 p_3_12 p_4_12 5.017838e-04
Rpv_3_12 p_3_12 p_3_13 5.017838e-04
Rph_3_13 p_3_13 p_4_13 5.017838e-04
Rpv_3_13 p_3_13 p_3_14 5.017838e-04
Rph_3_14 p_3_14 p_4_14 5.017838e-04
Rpv_3_14 p_3_14 p_3_15 5.017838e-04
Rph_3_15 p_3_15 p_4_15 5.017838e-04
Rpv_3_15 p_3_15 p_3_16 5.017838e-04
Rph_3_16 p_3_16 p_4_16 5.017838e-04
Rpv_3_16 p_3_16 p_3_17 5.017838e-04
Rph_3_17 p_3_17 p_4_17 5.017838e-04
Rpv_3_17 p_3_17 p_3_18 5.017838e-04
Rph_3_18 p_3_18 p_4_18 5.017838e-04
Rpv_3_18 p_3_18 p_3_19 5.017838e-04
Rph_3_19 p_3_19 p_4_19 5.017838e-04
Rpv_3_19 p_3_19 p_3_20 5.017838e-04
Rph_3_20 p_3_20 p_4_20 5.017838e-04
Rpv_3_20 p_3_20 p_3_21 5.017838e-04
Rph_3_21 p_3_21 p_4_21 5.017838e-04
Rpv_3_21 p_3_21 p_3_22 5.017838e-04
Rph_3_22 p_3_22 p_4_22 5.017838e-04
Rpv_3_22 p_3_22 p_3_23 5.017838e-04
Rph_3_23 p_3_23 p_4_23 5.017838e-04
Rpv_3_23 p_3_23 p_3_24 5.017838e-04
Rph_3_24 p_3_24 p_4_24 5.017838e-04
Rpv_3_24 p_3_24 p_3_25 5.017838e-04
Rph_3_25 p_3_25 p_4_25 5.017838e-04
Rpv_3_25 p_3_25 p_3_26 5.017838e-04
Rph_3_26 p_3_26 p_4_26 5.017838e-04
Rpv_3_26 p_3_26 p_3_27 5.017838e-04
Rph_3_27 p_3_27 p_4_27 5.017838e-04
Rpv_3_27 p_3_27 p_3_28 5.017838e-04
Rph_3_28 p_3_28 p_4_28 5.017838e-04
Rpv_3_28 p_3_28 p_3_29 5.017838e-04
Rph_3_29 p_3_29 p_4_29 5.017838e-04
Rpv_3_29 p_3_29 p_3_30 5.017838e-04
Rph_3_30 p_3_30 p_4_30 5.017838e-04
Rpv_3_30 p_3_30 p_3_31 5.017838e-04
Rph_3_31 p_3_31 p_4_31 5.017838e-04
Rpv_3_31 p_3_31 p_3_32 5.017838e-04
Rph_3_32 p_3_32 p_4_32 5.017838e-04
Rpv_3_32 p_3_32 p_3_33 5.017838e-04
Rph_3_33 p_3_33 p_4_33 5.017838e-04
Rpv_3_33 p_3_33 p_3_34 5.017838e-04
Rph_3_34 p_3_34 p_4_34 5.017838e-04
Rpv_3_34 p_3_34 p_3_35 5.017838e-04
Rph_3_35 p_3_35 p_4_35 5.017838e-04
Rpv_3_35 p_3_35 p_3_36 5.017838e-04
Rph_3_36 p_3_36 p_4_36 5.017838e-04
Rpv_3_36 p_3_36 p_3_37 5.017838e-04
Rph_3_37 p_3_37 p_4_37 5.017838e-04
Rpv_3_37 p_3_37 p_3_38 5.017838e-04
Rph_3_38 p_3_38 p_4_38 5.017838e-04
Rpv_3_38 p_3_38 p_3_39 5.017838e-04
Rph_3_39 p_3_39 p_4_39 5.017838e-04
Rpv_3_39 p_3_39 p_3_40 5.017838e-04
Rph_3_40 p_3_40 p_4_40 5.017838e-04
Rpv_3_40 p_3_40 p_3_41 5.017838e-04
Rph_3_41 p_3_41 p_4_41 5.017838e-04
Rpv_3_41 p_3_41 p_3_42 5.017838e-04
Rph_3_42 p_3_42 p_4_42 5.017838e-04
Rpv_3_42 p_3_42 p_3_43 5.017838e-04
Rph_3_43 p_3_43 p_4_43 5.017838e-04
Rpv_3_43 p_3_43 p_3_44 5.017838e-04
Rph_3_44 p_3_44 p_4_44 5.017838e-04
Rpv_3_44 p_3_44 p_3_45 5.017838e-04
Rph_3_45 p_3_45 p_4_45 5.017838e-04
Rpv_3_45 p_3_45 p_3_46 5.017838e-04
Rph_3_46 p_3_46 p_4_46 5.017838e-04
Rpv_3_46 p_3_46 p_3_47 5.017838e-04
Rph_3_47 p_3_47 p_4_47 5.017838e-04
Rpv_3_47 p_3_47 p_3_48 5.017838e-04
Rph_3_48 p_3_48 p_4_48 5.017838e-04
Rpv_3_48 p_3_48 p_3_49 5.017838e-04
Rph_3_49 p_3_49 p_4_49 5.017838e-04
Rpv_3_49 p_3_49 p_3_50 5.017838e-04
Rph_3_50 p_3_50 p_4_50 5.017838e-04
Rpv_3_50 p_3_50 p_3_51 5.017838e-04
Rph_3_51 p_3_51 p_4_51 5.017838e-04
Rpv_3_51 p_3_51 p_3_52 5.017838e-04
Rph_3_52 p_3_52 p_4_52 5.017838e-04
Rpv_3_52 p_3_52 p_3_53 5.017838e-04
Rph_3_53 p_3_53 p_4_53 5.017838e-04
Rpv_3_53 p_3_53 p_3_54 5.017838e-04
Rph_3_54 p_3_54 p_4_54 5.017838e-04
Rpv_3_54 p_3_54 p_3_55 5.017838e-04
Rph_3_55 p_3_55 p_4_55 5.017838e-04
Rpv_3_55 p_3_55 p_3_56 5.017838e-04
Rph_3_56 p_3_56 p_4_56 5.017838e-04
Rpv_3_56 p_3_56 p_3_57 5.017838e-04
Rph_3_57 p_3_57 p_4_57 5.017838e-04
Rpv_3_57 p_3_57 p_3_58 5.017838e-04
Rph_3_58 p_3_58 p_4_58 5.017838e-04
Rpv_3_58 p_3_58 p_3_59 5.017838e-04
Rph_3_59 p_3_59 p_4_59 5.017838e-04
Rpv_3_59 p_3_59 p_3_60 5.017838e-04
Rph_3_60 p_3_60 p_4_60 5.017838e-04
Rpv_3_60 p_3_60 p_3_61 5.017838e-04
Rph_3_61 p_3_61 p_4_61 5.017838e-04
Rpv_3_61 p_3_61 p_3_62 5.017838e-04
Rph_3_62 p_3_62 p_4_62 5.017838e-04
Rpv_3_62 p_3_62 p_3_63 5.017838e-04
Rph_3_63 p_3_63 p_4_63 5.017838e-04
Rpv_3_63 p_3_63 p_3_64 5.017838e-04
Rph_3_64 p_3_64 p_4_64 5.017838e-04
Rpv_3_64 p_3_64 p_3_65 5.017838e-04
Rph_3_65 p_3_65 p_4_65 5.017838e-04
Rpv_3_65 p_3_65 p_3_66 5.017838e-04
Rph_3_66 p_3_66 p_4_66 5.017838e-04
Rpv_3_66 p_3_66 p_3_67 5.017838e-04
Rph_3_67 p_3_67 p_4_67 5.017838e-04
Rpv_3_67 p_3_67 p_3_68 5.017838e-04
Rph_3_68 p_3_68 p_4_68 5.017838e-04
Rpv_3_68 p_3_68 p_3_69 5.017838e-04
Rph_3_69 p_3_69 p_4_69 5.017838e-04
Rpv_3_69 p_3_69 p_3_70 5.017838e-04
Rph_3_70 p_3_70 p_4_70 5.017838e-04
Rpv_3_70 p_3_70 p_3_71 5.017838e-04
Rph_3_71 p_3_71 p_4_71 5.017838e-04
Rph_4_0 p_4_0 p_5_0 5.017838e-04
Rpv_4_0 p_4_0 p_4_1 5.017838e-04
Rph_4_1 p_4_1 p_5_1 5.017838e-04
Rpv_4_1 p_4_1 p_4_2 5.017838e-04
Rph_4_2 p_4_2 p_5_2 5.017838e-04
Rpv_4_2 p_4_2 p_4_3 5.017838e-04
Rph_4_3 p_4_3 p_5_3 5.017838e-04
Rpv_4_3 p_4_3 p_4_4 5.017838e-04
Rph_4_4 p_4_4 p_5_4 5.017838e-04
Rpv_4_4 p_4_4 p_4_5 5.017838e-04
Rph_4_5 p_4_5 p_5_5 5.017838e-04
Rpv_4_5 p_4_5 p_4_6 5.017838e-04
Rph_4_6 p_4_6 p_5_6 5.017838e-04
Rpv_4_6 p_4_6 p_4_7 5.017838e-04
Rph_4_7 p_4_7 p_5_7 5.017838e-04
Rpv_4_7 p_4_7 p_4_8 5.017838e-04
Rph_4_8 p_4_8 p_5_8 5.017838e-04
Rpv_4_8 p_4_8 p_4_9 5.017838e-04
Rph_4_9 p_4_9 p_5_9 5.017838e-04
Rpv_4_9 p_4_9 p_4_10 5.017838e-04
Rph_4_10 p_4_10 p_5_10 5.017838e-04
Rpv_4_10 p_4_10 p_4_11 5.017838e-04
Rph_4_11 p_4_11 p_5_11 5.017838e-04
Rpv_4_11 p_4_11 p_4_12 5.017838e-04
Rph_4_12 p_4_12 p_5_12 5.017838e-04
Rpv_4_12 p_4_12 p_4_13 5.017838e-04
Rph_4_13 p_4_13 p_5_13 5.017838e-04
Rpv_4_13 p_4_13 p_4_14 5.017838e-04
Rph_4_14 p_4_14 p_5_14 5.017838e-04
Rpv_4_14 p_4_14 p_4_15 5.017838e-04
Rph_4_15 p_4_15 p_5_15 5.017838e-04
Rpv_4_15 p_4_15 p_4_16 5.017838e-04
Rph_4_16 p_4_16 p_5_16 5.017838e-04
Rpv_4_16 p_4_16 p_4_17 5.017838e-04
Rph_4_17 p_4_17 p_5_17 5.017838e-04
Rpv_4_17 p_4_17 p_4_18 5.017838e-04
Rph_4_18 p_4_18 p_5_18 5.017838e-04
Rpv_4_18 p_4_18 p_4_19 5.017838e-04
Rph_4_19 p_4_19 p_5_19 5.017838e-04
Rpv_4_19 p_4_19 p_4_20 5.017838e-04
Rph_4_20 p_4_20 p_5_20 5.017838e-04
Rpv_4_20 p_4_20 p_4_21 5.017838e-04
Rph_4_21 p_4_21 p_5_21 5.017838e-04
Rpv_4_21 p_4_21 p_4_22 5.017838e-04
Rph_4_22 p_4_22 p_5_22 5.017838e-04
Rpv_4_22 p_4_22 p_4_23 5.017838e-04
Rph_4_23 p_4_23 p_5_23 5.017838e-04
Rpv_4_23 p_4_23 p_4_24 5.017838e-04
Rph_4_24 p_4_24 p_5_24 5.017838e-04
Rpv_4_24 p_4_24 p_4_25 5.017838e-04
Rph_4_25 p_4_25 p_5_25 5.017838e-04
Rpv_4_25 p_4_25 p_4_26 5.017838e-04
Rph_4_26 p_4_26 p_5_26 5.017838e-04
Rpv_4_26 p_4_26 p_4_27 5.017838e-04
Rph_4_27 p_4_27 p_5_27 5.017838e-04
Rpv_4_27 p_4_27 p_4_28 5.017838e-04
Rph_4_28 p_4_28 p_5_28 5.017838e-04
Rpv_4_28 p_4_28 p_4_29 5.017838e-04
Rph_4_29 p_4_29 p_5_29 5.017838e-04
Rpv_4_29 p_4_29 p_4_30 5.017838e-04
Rph_4_30 p_4_30 p_5_30 5.017838e-04
Rpv_4_30 p_4_30 p_4_31 5.017838e-04
Rph_4_31 p_4_31 p_5_31 5.017838e-04
Rpv_4_31 p_4_31 p_4_32 5.017838e-04
Rph_4_32 p_4_32 p_5_32 5.017838e-04
Rpv_4_32 p_4_32 p_4_33 5.017838e-04
Rph_4_33 p_4_33 p_5_33 5.017838e-04
Rpv_4_33 p_4_33 p_4_34 5.017838e-04
Rph_4_34 p_4_34 p_5_34 5.017838e-04
Rpv_4_34 p_4_34 p_4_35 5.017838e-04
Rph_4_35 p_4_35 p_5_35 5.017838e-04
Rpv_4_35 p_4_35 p_4_36 5.017838e-04
Rph_4_36 p_4_36 p_5_36 5.017838e-04
Rpv_4_36 p_4_36 p_4_37 5.017838e-04
Rph_4_37 p_4_37 p_5_37 5.017838e-04
Rpv_4_37 p_4_37 p_4_38 5.017838e-04
Rph_4_38 p_4_38 p_5_38 5.017838e-04
Rpv_4_38 p_4_38 p_4_39 5.017838e-04
Rph_4_39 p_4_39 p_5_39 5.017838e-04
Rpv_4_39 p_4_39 p_4_40 5.017838e-04
Rph_4_40 p_4_40 p_5_40 5.017838e-04
Rpv_4_40 p_4_40 p_4_41 5.017838e-04
Rph_4_41 p_4_41 p_5_41 5.017838e-04
Rpv_4_41 p_4_41 p_4_42 5.017838e-04
Rph_4_42 p_4_42 p_5_42 5.017838e-04
Rpv_4_42 p_4_42 p_4_43 5.017838e-04
Rph_4_43 p_4_43 p_5_43 5.017838e-04
Rpv_4_43 p_4_43 p_4_44 5.017838e-04
Rph_4_44 p_4_44 p_5_44 5.017838e-04
Rpv_4_44 p_4_44 p_4_45 5.017838e-04
Rph_4_45 p_4_45 p_5_45 5.017838e-04
Rpv_4_45 p_4_45 p_4_46 5.017838e-04
Rph_4_46 p_4_46 p_5_46 5.017838e-04
Rpv_4_46 p_4_46 p_4_47 5.017838e-04
Rph_4_47 p_4_47 p_5_47 5.017838e-04
Rpv_4_47 p_4_47 p_4_48 5.017838e-04
Rph_4_48 p_4_48 p_5_48 5.017838e-04
Rpv_4_48 p_4_48 p_4_49 5.017838e-04
Rph_4_49 p_4_49 p_5_49 5.017838e-04
Rpv_4_49 p_4_49 p_4_50 5.017838e-04
Rph_4_50 p_4_50 p_5_50 5.017838e-04
Rpv_4_50 p_4_50 p_4_51 5.017838e-04
Rph_4_51 p_4_51 p_5_51 5.017838e-04
Rpv_4_51 p_4_51 p_4_52 5.017838e-04
Rph_4_52 p_4_52 p_5_52 5.017838e-04
Rpv_4_52 p_4_52 p_4_53 5.017838e-04
Rph_4_53 p_4_53 p_5_53 5.017838e-04
Rpv_4_53 p_4_53 p_4_54 5.017838e-04
Rph_4_54 p_4_54 p_5_54 5.017838e-04
Rpv_4_54 p_4_54 p_4_55 5.017838e-04
Rph_4_55 p_4_55 p_5_55 5.017838e-04
Rpv_4_55 p_4_55 p_4_56 5.017838e-04
Rph_4_56 p_4_56 p_5_56 5.017838e-04
Rpv_4_56 p_4_56 p_4_57 5.017838e-04
Rph_4_57 p_4_57 p_5_57 5.017838e-04
Rpv_4_57 p_4_57 p_4_58 5.017838e-04
Rph_4_58 p_4_58 p_5_58 5.017838e-04
Rpv_4_58 p_4_58 p_4_59 5.017838e-04
Rph_4_59 p_4_59 p_5_59 5.017838e-04
Rpv_4_59 p_4_59 p_4_60 5.017838e-04
Rph_4_60 p_4_60 p_5_60 5.017838e-04
Rpv_4_60 p_4_60 p_4_61 5.017838e-04
Rph_4_61 p_4_61 p_5_61 5.017838e-04
Rpv_4_61 p_4_61 p_4_62 5.017838e-04
Rph_4_62 p_4_62 p_5_62 5.017838e-04
Rpv_4_62 p_4_62 p_4_63 5.017838e-04
Rph_4_63 p_4_63 p_5_63 5.017838e-04
Rpv_4_63 p_4_63 p_4_64 5.017838e-04
Rph_4_64 p_4_64 p_5_64 5.017838e-04
Rpv_4_64 p_4_64 p_4_65 5.017838e-04
Rph_4_65 p_4_65 p_5_65 5.017838e-04
Rpv_4_65 p_4_65 p_4_66 5.017838e-04
Rph_4_66 p_4_66 p_5_66 5.017838e-04
Rpv_4_66 p_4_66 p_4_67 5.017838e-04
Rph_4_67 p_4_67 p_5_67 5.017838e-04
Rpv_4_67 p_4_67 p_4_68 5.017838e-04
Rph_4_68 p_4_68 p_5_68 5.017838e-04
Rpv_4_68 p_4_68 p_4_69 5.017838e-04
Rph_4_69 p_4_69 p_5_69 5.017838e-04
Rpv_4_69 p_4_69 p_4_70 5.017838e-04
Rph_4_70 p_4_70 p_5_70 5.017838e-04
Rpv_4_70 p_4_70 p_4_71 5.017838e-04
Rph_4_71 p_4_71 p_5_71 5.017838e-04
Rph_5_0 p_5_0 p_6_0 5.017838e-04
Rpv_5_0 p_5_0 p_5_1 5.017838e-04
Rph_5_1 p_5_1 p_6_1 5.017838e-04
Rpv_5_1 p_5_1 p_5_2 5.017838e-04
Rph_5_2 p_5_2 p_6_2 5.017838e-04
Rpv_5_2 p_5_2 p_5_3 5.017838e-04
Rph_5_3 p_5_3 p_6_3 5.017838e-04
Rpv_5_3 p_5_3 p_5_4 5.017838e-04
Rph_5_4 p_5_4 p_6_4 5.017838e-04
Rpv_5_4 p_5_4 p_5_5 5.017838e-04
Rph_5_5 p_5_5 p_6_5 5.017838e-04
Rpv_5_5 p_5_5 p_5_6 5.017838e-04
Rph_5_6 p_5_6 p_6_6 5.017838e-04
Rpv_5_6 p_5_6 p_5_7 5.017838e-04
Rph_5_7 p_5_7 p_6_7 5.017838e-04
Rpv_5_7 p_5_7 p_5_8 5.017838e-04
Rph_5_8 p_5_8 p_6_8 5.017838e-04
Rpv_5_8 p_5_8 p_5_9 5.017838e-04
Rph_5_9 p_5_9 p_6_9 5.017838e-04
Rpv_5_9 p_5_9 p_5_10 5.017838e-04
Rph_5_10 p_5_10 p_6_10 5.017838e-04
Rpv_5_10 p_5_10 p_5_11 5.017838e-04
Rph_5_11 p_5_11 p_6_11 5.017838e-04
Rpv_5_11 p_5_11 p_5_12 5.017838e-04
Rph_5_12 p_5_12 p_6_12 5.017838e-04
Rpv_5_12 p_5_12 p_5_13 5.017838e-04
Rph_5_13 p_5_13 p_6_13 5.017838e-04
Rpv_5_13 p_5_13 p_5_14 5.017838e-04
Rph_5_14 p_5_14 p_6_14 5.017838e-04
Rpv_5_14 p_5_14 p_5_15 5.017838e-04
Rph_5_15 p_5_15 p_6_15 5.017838e-04
Rpv_5_15 p_5_15 p_5_16 5.017838e-04
Rph_5_16 p_5_16 p_6_16 5.017838e-04
Rpv_5_16 p_5_16 p_5_17 5.017838e-04
Rph_5_17 p_5_17 p_6_17 5.017838e-04
Rpv_5_17 p_5_17 p_5_18 5.017838e-04
Rph_5_18 p_5_18 p_6_18 5.017838e-04
Rpv_5_18 p_5_18 p_5_19 5.017838e-04
Rph_5_19 p_5_19 p_6_19 5.017838e-04
Rpv_5_19 p_5_19 p_5_20 5.017838e-04
Rph_5_20 p_5_20 p_6_20 5.017838e-04
Rpv_5_20 p_5_20 p_5_21 5.017838e-04
Rph_5_21 p_5_21 p_6_21 5.017838e-04
Rpv_5_21 p_5_21 p_5_22 5.017838e-04
Rph_5_22 p_5_22 p_6_22 5.017838e-04
Rpv_5_22 p_5_22 p_5_23 5.017838e-04
Rph_5_23 p_5_23 p_6_23 5.017838e-04
Rpv_5_23 p_5_23 p_5_24 5.017838e-04
Rph_5_24 p_5_24 p_6_24 5.017838e-04
Rpv_5_24 p_5_24 p_5_25 5.017838e-04
Rph_5_25 p_5_25 p_6_25 5.017838e-04
Rpv_5_25 p_5_25 p_5_26 5.017838e-04
Rph_5_26 p_5_26 p_6_26 5.017838e-04
Rpv_5_26 p_5_26 p_5_27 5.017838e-04
Rph_5_27 p_5_27 p_6_27 5.017838e-04
Rpv_5_27 p_5_27 p_5_28 5.017838e-04
Rph_5_28 p_5_28 p_6_28 5.017838e-04
Rpv_5_28 p_5_28 p_5_29 5.017838e-04
Rph_5_29 p_5_29 p_6_29 5.017838e-04
Rpv_5_29 p_5_29 p_5_30 5.017838e-04
Rph_5_30 p_5_30 p_6_30 5.017838e-04
Rpv_5_30 p_5_30 p_5_31 5.017838e-04
Rph_5_31 p_5_31 p_6_31 5.017838e-04
Rpv_5_31 p_5_31 p_5_32 5.017838e-04
Rph_5_32 p_5_32 p_6_32 5.017838e-04
Rpv_5_32 p_5_32 p_5_33 5.017838e-04
Rph_5_33 p_5_33 p_6_33 5.017838e-04
Rpv_5_33 p_5_33 p_5_34 5.017838e-04
Rph_5_34 p_5_34 p_6_34 5.017838e-04
Rpv_5_34 p_5_34 p_5_35 5.017838e-04
Rph_5_35 p_5_35 p_6_35 5.017838e-04
Rpv_5_35 p_5_35 p_5_36 5.017838e-04
Rph_5_36 p_5_36 p_6_36 5.017838e-04
Rpv_5_36 p_5_36 p_5_37 5.017838e-04
Rph_5_37 p_5_37 p_6_37 5.017838e-04
Rpv_5_37 p_5_37 p_5_38 5.017838e-04
Rph_5_38 p_5_38 p_6_38 5.017838e-04
Rpv_5_38 p_5_38 p_5_39 5.017838e-04
Rph_5_39 p_5_39 p_6_39 5.017838e-04
Rpv_5_39 p_5_39 p_5_40 5.017838e-04
Rph_5_40 p_5_40 p_6_40 5.017838e-04
Rpv_5_40 p_5_40 p_5_41 5.017838e-04
Rph_5_41 p_5_41 p_6_41 5.017838e-04
Rpv_5_41 p_5_41 p_5_42 5.017838e-04
Rph_5_42 p_5_42 p_6_42 5.017838e-04
Rpv_5_42 p_5_42 p_5_43 5.017838e-04
Rph_5_43 p_5_43 p_6_43 5.017838e-04
Rpv_5_43 p_5_43 p_5_44 5.017838e-04
Rph_5_44 p_5_44 p_6_44 5.017838e-04
Rpv_5_44 p_5_44 p_5_45 5.017838e-04
Rph_5_45 p_5_45 p_6_45 5.017838e-04
Rpv_5_45 p_5_45 p_5_46 5.017838e-04
Rph_5_46 p_5_46 p_6_46 5.017838e-04
Rpv_5_46 p_5_46 p_5_47 5.017838e-04
Rph_5_47 p_5_47 p_6_47 5.017838e-04
Rpv_5_47 p_5_47 p_5_48 5.017838e-04
Rph_5_48 p_5_48 p_6_48 5.017838e-04
Rpv_5_48 p_5_48 p_5_49 5.017838e-04
Rph_5_49 p_5_49 p_6_49 5.017838e-04
Rpv_5_49 p_5_49 p_5_50 5.017838e-04
Rph_5_50 p_5_50 p_6_50 5.017838e-04
Rpv_5_50 p_5_50 p_5_51 5.017838e-04
Rph_5_51 p_5_51 p_6_51 5.017838e-04
Rpv_5_51 p_5_51 p_5_52 5.017838e-04
Rph_5_52 p_5_52 p_6_52 5.017838e-04
Rpv_5_52 p_5_52 p_5_53 5.017838e-04
Rph_5_53 p_5_53 p_6_53 5.017838e-04
Rpv_5_53 p_5_53 p_5_54 5.017838e-04
Rph_5_54 p_5_54 p_6_54 5.017838e-04
Rpv_5_54 p_5_54 p_5_55 5.017838e-04
Rph_5_55 p_5_55 p_6_55 5.017838e-04
Rpv_5_55 p_5_55 p_5_56 5.017838e-04
Rph_5_56 p_5_56 p_6_56 5.017838e-04
Rpv_5_56 p_5_56 p_5_57 5.017838e-04
Rph_5_57 p_5_57 p_6_57 5.017838e-04
Rpv_5_57 p_5_57 p_5_58 5.017838e-04
Rph_5_58 p_5_58 p_6_58 5.017838e-04
Rpv_5_58 p_5_58 p_5_59 5.017838e-04
Rph_5_59 p_5_59 p_6_59 5.017838e-04
Rpv_5_59 p_5_59 p_5_60 5.017838e-04
Rph_5_60 p_5_60 p_6_60 5.017838e-04
Rpv_5_60 p_5_60 p_5_61 5.017838e-04
Rph_5_61 p_5_61 p_6_61 5.017838e-04
Rpv_5_61 p_5_61 p_5_62 5.017838e-04
Rph_5_62 p_5_62 p_6_62 5.017838e-04
Rpv_5_62 p_5_62 p_5_63 5.017838e-04
Rph_5_63 p_5_63 p_6_63 5.017838e-04
Rpv_5_63 p_5_63 p_5_64 5.017838e-04
Rph_5_64 p_5_64 p_6_64 5.017838e-04
Rpv_5_64 p_5_64 p_5_65 5.017838e-04
Rph_5_65 p_5_65 p_6_65 5.017838e-04
Rpv_5_65 p_5_65 p_5_66 5.017838e-04
Rph_5_66 p_5_66 p_6_66 5.017838e-04
Rpv_5_66 p_5_66 p_5_67 5.017838e-04
Rph_5_67 p_5_67 p_6_67 5.017838e-04
Rpv_5_67 p_5_67 p_5_68 5.017838e-04
Rph_5_68 p_5_68 p_6_68 5.017838e-04
Rpv_5_68 p_5_68 p_5_69 5.017838e-04
Rph_5_69 p_5_69 p_6_69 5.017838e-04
Rpv_5_69 p_5_69 p_5_70 5.017838e-04
Rph_5_70 p_5_70 p_6_70 5.017838e-04
Rpv_5_70 p_5_70 p_5_71 5.017838e-04
Rph_5_71 p_5_71 p_6_71 5.017838e-04
Rph_6_0 p_6_0 p_7_0 5.017838e-04
Rpv_6_0 p_6_0 p_6_1 5.017838e-04
Rph_6_1 p_6_1 p_7_1 5.017838e-04
Rpv_6_1 p_6_1 p_6_2 5.017838e-04
Rph_6_2 p_6_2 p_7_2 5.017838e-04
Rpv_6_2 p_6_2 p_6_3 5.017838e-04
Rph_6_3 p_6_3 p_7_3 5.017838e-04
Rpv_6_3 p_6_3 p_6_4 5.017838e-04
Rph_6_4 p_6_4 p_7_4 5.017838e-04
Rpv_6_4 p_6_4 p_6_5 5.017838e-04
Rph_6_5 p_6_5 p_7_5 5.017838e-04
Rpv_6_5 p_6_5 p_6_6 5.017838e-04
Rph_6_6 p_6_6 p_7_6 5.017838e-04
Rpv_6_6 p_6_6 p_6_7 5.017838e-04
Rph_6_7 p_6_7 p_7_7 5.017838e-04
Rpv_6_7 p_6_7 p_6_8 5.017838e-04
Rph_6_8 p_6_8 p_7_8 5.017838e-04
Rpv_6_8 p_6_8 p_6_9 5.017838e-04
Rph_6_9 p_6_9 p_7_9 5.017838e-04
Rpv_6_9 p_6_9 p_6_10 5.017838e-04
Rph_6_10 p_6_10 p_7_10 5.017838e-04
Rpv_6_10 p_6_10 p_6_11 5.017838e-04
Rph_6_11 p_6_11 p_7_11 5.017838e-04
Rpv_6_11 p_6_11 p_6_12 5.017838e-04
Rph_6_12 p_6_12 p_7_12 5.017838e-04
Rpv_6_12 p_6_12 p_6_13 5.017838e-04
Rph_6_13 p_6_13 p_7_13 5.017838e-04
Rpv_6_13 p_6_13 p_6_14 5.017838e-04
Rph_6_14 p_6_14 p_7_14 5.017838e-04
Rpv_6_14 p_6_14 p_6_15 5.017838e-04
Rph_6_15 p_6_15 p_7_15 5.017838e-04
Rpv_6_15 p_6_15 p_6_16 5.017838e-04
Rph_6_16 p_6_16 p_7_16 5.017838e-04
Rpv_6_16 p_6_16 p_6_17 5.017838e-04
Rph_6_17 p_6_17 p_7_17 5.017838e-04
Rpv_6_17 p_6_17 p_6_18 5.017838e-04
Rph_6_18 p_6_18 p_7_18 5.017838e-04
Rpv_6_18 p_6_18 p_6_19 5.017838e-04
Rph_6_19 p_6_19 p_7_19 5.017838e-04
Rpv_6_19 p_6_19 p_6_20 5.017838e-04
Rph_6_20 p_6_20 p_7_20 5.017838e-04
Rpv_6_20 p_6_20 p_6_21 5.017838e-04
Rph_6_21 p_6_21 p_7_21 5.017838e-04
Rpv_6_21 p_6_21 p_6_22 5.017838e-04
Rph_6_22 p_6_22 p_7_22 5.017838e-04
Rpv_6_22 p_6_22 p_6_23 5.017838e-04
Rph_6_23 p_6_23 p_7_23 5.017838e-04
Rpv_6_23 p_6_23 p_6_24 5.017838e-04
Rph_6_24 p_6_24 p_7_24 5.017838e-04
Rpv_6_24 p_6_24 p_6_25 5.017838e-04
Rph_6_25 p_6_25 p_7_25 5.017838e-04
Rpv_6_25 p_6_25 p_6_26 5.017838e-04
Rph_6_26 p_6_26 p_7_26 5.017838e-04
Rpv_6_26 p_6_26 p_6_27 5.017838e-04
Rph_6_27 p_6_27 p_7_27 5.017838e-04
Rpv_6_27 p_6_27 p_6_28 5.017838e-04
Rph_6_28 p_6_28 p_7_28 5.017838e-04
Rpv_6_28 p_6_28 p_6_29 5.017838e-04
Rph_6_29 p_6_29 p_7_29 5.017838e-04
Rpv_6_29 p_6_29 p_6_30 5.017838e-04
Rph_6_30 p_6_30 p_7_30 5.017838e-04
Rpv_6_30 p_6_30 p_6_31 5.017838e-04
Rph_6_31 p_6_31 p_7_31 5.017838e-04
Rpv_6_31 p_6_31 p_6_32 5.017838e-04
Rph_6_32 p_6_32 p_7_32 5.017838e-04
Rpv_6_32 p_6_32 p_6_33 5.017838e-04
Rph_6_33 p_6_33 p_7_33 5.017838e-04
Rpv_6_33 p_6_33 p_6_34 5.017838e-04
Rph_6_34 p_6_34 p_7_34 5.017838e-04
Rpv_6_34 p_6_34 p_6_35 5.017838e-04
Rph_6_35 p_6_35 p_7_35 5.017838e-04
Rpv_6_35 p_6_35 p_6_36 5.017838e-04
Rph_6_36 p_6_36 p_7_36 5.017838e-04
Rpv_6_36 p_6_36 p_6_37 5.017838e-04
Rph_6_37 p_6_37 p_7_37 5.017838e-04
Rpv_6_37 p_6_37 p_6_38 5.017838e-04
Rph_6_38 p_6_38 p_7_38 5.017838e-04
Rpv_6_38 p_6_38 p_6_39 5.017838e-04
Rph_6_39 p_6_39 p_7_39 5.017838e-04
Rpv_6_39 p_6_39 p_6_40 5.017838e-04
Rph_6_40 p_6_40 p_7_40 5.017838e-04
Rpv_6_40 p_6_40 p_6_41 5.017838e-04
Rph_6_41 p_6_41 p_7_41 5.017838e-04
Rpv_6_41 p_6_41 p_6_42 5.017838e-04
Rph_6_42 p_6_42 p_7_42 5.017838e-04
Rpv_6_42 p_6_42 p_6_43 5.017838e-04
Rph_6_43 p_6_43 p_7_43 5.017838e-04
Rpv_6_43 p_6_43 p_6_44 5.017838e-04
Rph_6_44 p_6_44 p_7_44 5.017838e-04
Rpv_6_44 p_6_44 p_6_45 5.017838e-04
Rph_6_45 p_6_45 p_7_45 5.017838e-04
Rpv_6_45 p_6_45 p_6_46 5.017838e-04
Rph_6_46 p_6_46 p_7_46 5.017838e-04
Rpv_6_46 p_6_46 p_6_47 5.017838e-04
Rph_6_47 p_6_47 p_7_47 5.017838e-04
Rpv_6_47 p_6_47 p_6_48 5.017838e-04
Rph_6_48 p_6_48 p_7_48 5.017838e-04
Rpv_6_48 p_6_48 p_6_49 5.017838e-04
Rph_6_49 p_6_49 p_7_49 5.017838e-04
Rpv_6_49 p_6_49 p_6_50 5.017838e-04
Rph_6_50 p_6_50 p_7_50 5.017838e-04
Rpv_6_50 p_6_50 p_6_51 5.017838e-04
Rph_6_51 p_6_51 p_7_51 5.017838e-04
Rpv_6_51 p_6_51 p_6_52 5.017838e-04
Rph_6_52 p_6_52 p_7_52 5.017838e-04
Rpv_6_52 p_6_52 p_6_53 5.017838e-04
Rph_6_53 p_6_53 p_7_53 5.017838e-04
Rpv_6_53 p_6_53 p_6_54 5.017838e-04
Rph_6_54 p_6_54 p_7_54 5.017838e-04
Rpv_6_54 p_6_54 p_6_55 5.017838e-04
Rph_6_55 p_6_55 p_7_55 5.017838e-04
Rpv_6_55 p_6_55 p_6_56 5.017838e-04
Rph_6_56 p_6_56 p_7_56 5.017838e-04
Rpv_6_56 p_6_56 p_6_57 5.017838e-04
Rph_6_57 p_6_57 p_7_57 5.017838e-04
Rpv_6_57 p_6_57 p_6_58 5.017838e-04
Rph_6_58 p_6_58 p_7_58 5.017838e-04
Rpv_6_58 p_6_58 p_6_59 5.017838e-04
Rph_6_59 p_6_59 p_7_59 5.017838e-04
Rpv_6_59 p_6_59 p_6_60 5.017838e-04
Rph_6_60 p_6_60 p_7_60 5.017838e-04
Rpv_6_60 p_6_60 p_6_61 5.017838e-04
Rph_6_61 p_6_61 p_7_61 5.017838e-04
Rpv_6_61 p_6_61 p_6_62 5.017838e-04
Rph_6_62 p_6_62 p_7_62 5.017838e-04
Rpv_6_62 p_6_62 p_6_63 5.017838e-04
Rph_6_63 p_6_63 p_7_63 5.017838e-04
Rpv_6_63 p_6_63 p_6_64 5.017838e-04
Rph_6_64 p_6_64 p_7_64 5.017838e-04
Rpv_6_64 p_6_64 p_6_65 5.017838e-04
Rph_6_65 p_6_65 p_7_65 5.017838e-04
Rpv_6_65 p_6_65 p_6_66 5.017838e-04
Rph_6_66 p_6_66 p_7_66 5.017838e-04
Rpv_6_66 p_6_66 p_6_67 5.017838e-04
Rph_6_67 p_6_67 p_7_67 5.017838e-04
Rpv_6_67 p_6_67 p_6_68 5.017838e-04
Rph_6_68 p_6_68 p_7_68 5.017838e-04
Rpv_6_68 p_6_68 p_6_69 5.017838e-04
Rph_6_69 p_6_69 p_7_69 5.017838e-04
Rpv_6_69 p_6_69 p_6_70 5.017838e-04
Rph_6_70 p_6_70 p_7_70 5.017838e-04
Rpv_6_70 p_6_70 p_6_71 5.017838e-04
Rph_6_71 p_6_71 p_7_71 5.017838e-04
Rph_7_0 p_7_0 p_8_0 5.017838e-04
Rpv_7_0 p_7_0 p_7_1 5.017838e-04
Rph_7_1 p_7_1 p_8_1 5.017838e-04
Rpv_7_1 p_7_1 p_7_2 5.017838e-04
Rph_7_2 p_7_2 p_8_2 5.017838e-04
Rpv_7_2 p_7_2 p_7_3 5.017838e-04
Rph_7_3 p_7_3 p_8_3 5.017838e-04
Rpv_7_3 p_7_3 p_7_4 5.017838e-04
Rph_7_4 p_7_4 p_8_4 5.017838e-04
Rpv_7_4 p_7_4 p_7_5 5.017838e-04
Rph_7_5 p_7_5 p_8_5 5.017838e-04
Rpv_7_5 p_7_5 p_7_6 5.017838e-04
Rph_7_6 p_7_6 p_8_6 5.017838e-04
Rpv_7_6 p_7_6 p_7_7 5.017838e-04
Rph_7_7 p_7_7 p_8_7 5.017838e-04
Rpv_7_7 p_7_7 p_7_8 5.017838e-04
Rph_7_8 p_7_8 p_8_8 5.017838e-04
Rpv_7_8 p_7_8 p_7_9 5.017838e-04
Rph_7_9 p_7_9 p_8_9 5.017838e-04
Rpv_7_9 p_7_9 p_7_10 5.017838e-04
Rph_7_10 p_7_10 p_8_10 5.017838e-04
Rpv_7_10 p_7_10 p_7_11 5.017838e-04
Rph_7_11 p_7_11 p_8_11 5.017838e-04
Rpv_7_11 p_7_11 p_7_12 5.017838e-04
Rph_7_12 p_7_12 p_8_12 5.017838e-04
Rpv_7_12 p_7_12 p_7_13 5.017838e-04
Rph_7_13 p_7_13 p_8_13 5.017838e-04
Rpv_7_13 p_7_13 p_7_14 5.017838e-04
Rph_7_14 p_7_14 p_8_14 5.017838e-04
Rpv_7_14 p_7_14 p_7_15 5.017838e-04
Rph_7_15 p_7_15 p_8_15 5.017838e-04
Rpv_7_15 p_7_15 p_7_16 5.017838e-04
Rph_7_16 p_7_16 p_8_16 5.017838e-04
Rpv_7_16 p_7_16 p_7_17 5.017838e-04
Rph_7_17 p_7_17 p_8_17 5.017838e-04
Rpv_7_17 p_7_17 p_7_18 5.017838e-04
Rph_7_18 p_7_18 p_8_18 5.017838e-04
Rpv_7_18 p_7_18 p_7_19 5.017838e-04
Rph_7_19 p_7_19 p_8_19 5.017838e-04
Rpv_7_19 p_7_19 p_7_20 5.017838e-04
Rph_7_20 p_7_20 p_8_20 5.017838e-04
Rpv_7_20 p_7_20 p_7_21 5.017838e-04
Rph_7_21 p_7_21 p_8_21 5.017838e-04
Rpv_7_21 p_7_21 p_7_22 5.017838e-04
Rph_7_22 p_7_22 p_8_22 5.017838e-04
Rpv_7_22 p_7_22 p_7_23 5.017838e-04
Rph_7_23 p_7_23 p_8_23 5.017838e-04
Rpv_7_23 p_7_23 p_7_24 5.017838e-04
Rph_7_24 p_7_24 p_8_24 5.017838e-04
Rpv_7_24 p_7_24 p_7_25 5.017838e-04
Rph_7_25 p_7_25 p_8_25 5.017838e-04
Rpv_7_25 p_7_25 p_7_26 5.017838e-04
Rph_7_26 p_7_26 p_8_26 5.017838e-04
Rpv_7_26 p_7_26 p_7_27 5.017838e-04
Rph_7_27 p_7_27 p_8_27 5.017838e-04
Rpv_7_27 p_7_27 p_7_28 5.017838e-04
Rph_7_28 p_7_28 p_8_28 5.017838e-04
Rpv_7_28 p_7_28 p_7_29 5.017838e-04
Rph_7_29 p_7_29 p_8_29 5.017838e-04
Rpv_7_29 p_7_29 p_7_30 5.017838e-04
Rph_7_30 p_7_30 p_8_30 5.017838e-04
Rpv_7_30 p_7_30 p_7_31 5.017838e-04
Rph_7_31 p_7_31 p_8_31 5.017838e-04
Rpv_7_31 p_7_31 p_7_32 5.017838e-04
Rph_7_32 p_7_32 p_8_32 5.017838e-04
Rpv_7_32 p_7_32 p_7_33 5.017838e-04
Rph_7_33 p_7_33 p_8_33 5.017838e-04
Rpv_7_33 p_7_33 p_7_34 5.017838e-04
Rph_7_34 p_7_34 p_8_34 5.017838e-04
Rpv_7_34 p_7_34 p_7_35 5.017838e-04
Rph_7_35 p_7_35 p_8_35 5.017838e-04
Rpv_7_35 p_7_35 p_7_36 5.017838e-04
Rph_7_36 p_7_36 p_8_36 5.017838e-04
Rpv_7_36 p_7_36 p_7_37 5.017838e-04
Rph_7_37 p_7_37 p_8_37 5.017838e-04
Rpv_7_37 p_7_37 p_7_38 5.017838e-04
Rph_7_38 p_7_38 p_8_38 5.017838e-04
Rpv_7_38 p_7_38 p_7_39 5.017838e-04
Rph_7_39 p_7_39 p_8_39 5.017838e-04
Rpv_7_39 p_7_39 p_7_40 5.017838e-04
Rph_7_40 p_7_40 p_8_40 5.017838e-04
Rpv_7_40 p_7_40 p_7_41 5.017838e-04
Rph_7_41 p_7_41 p_8_41 5.017838e-04
Rpv_7_41 p_7_41 p_7_42 5.017838e-04
Rph_7_42 p_7_42 p_8_42 5.017838e-04
Rpv_7_42 p_7_42 p_7_43 5.017838e-04
Rph_7_43 p_7_43 p_8_43 5.017838e-04
Rpv_7_43 p_7_43 p_7_44 5.017838e-04
Rph_7_44 p_7_44 p_8_44 5.017838e-04
Rpv_7_44 p_7_44 p_7_45 5.017838e-04
Rph_7_45 p_7_45 p_8_45 5.017838e-04
Rpv_7_45 p_7_45 p_7_46 5.017838e-04
Rph_7_46 p_7_46 p_8_46 5.017838e-04
Rpv_7_46 p_7_46 p_7_47 5.017838e-04
Rph_7_47 p_7_47 p_8_47 5.017838e-04
Rpv_7_47 p_7_47 p_7_48 5.017838e-04
Rph_7_48 p_7_48 p_8_48 5.017838e-04
Rpv_7_48 p_7_48 p_7_49 5.017838e-04
Rph_7_49 p_7_49 p_8_49 5.017838e-04
Rpv_7_49 p_7_49 p_7_50 5.017838e-04
Rph_7_50 p_7_50 p_8_50 5.017838e-04
Rpv_7_50 p_7_50 p_7_51 5.017838e-04
Rph_7_51 p_7_51 p_8_51 5.017838e-04
Rpv_7_51 p_7_51 p_7_52 5.017838e-04
Rph_7_52 p_7_52 p_8_52 5.017838e-04
Rpv_7_52 p_7_52 p_7_53 5.017838e-04
Rph_7_53 p_7_53 p_8_53 5.017838e-04
Rpv_7_53 p_7_53 p_7_54 5.017838e-04
Rph_7_54 p_7_54 p_8_54 5.017838e-04
Rpv_7_54 p_7_54 p_7_55 5.017838e-04
Rph_7_55 p_7_55 p_8_55 5.017838e-04
Rpv_7_55 p_7_55 p_7_56 5.017838e-04
Rph_7_56 p_7_56 p_8_56 5.017838e-04
Rpv_7_56 p_7_56 p_7_57 5.017838e-04
Rph_7_57 p_7_57 p_8_57 5.017838e-04
Rpv_7_57 p_7_57 p_7_58 5.017838e-04
Rph_7_58 p_7_58 p_8_58 5.017838e-04
Rpv_7_58 p_7_58 p_7_59 5.017838e-04
Rph_7_59 p_7_59 p_8_59 5.017838e-04
Rpv_7_59 p_7_59 p_7_60 5.017838e-04
Rph_7_60 p_7_60 p_8_60 5.017838e-04
Rpv_7_60 p_7_60 p_7_61 5.017838e-04
Rph_7_61 p_7_61 p_8_61 5.017838e-04
Rpv_7_61 p_7_61 p_7_62 5.017838e-04
Rph_7_62 p_7_62 p_8_62 5.017838e-04
Rpv_7_62 p_7_62 p_7_63 5.017838e-04
Rph_7_63 p_7_63 p_8_63 5.017838e-04
Rpv_7_63 p_7_63 p_7_64 5.017838e-04
Rph_7_64 p_7_64 p_8_64 5.017838e-04
Rpv_7_64 p_7_64 p_7_65 5.017838e-04
Rph_7_65 p_7_65 p_8_65 5.017838e-04
Rpv_7_65 p_7_65 p_7_66 5.017838e-04
Rph_7_66 p_7_66 p_8_66 5.017838e-04
Rpv_7_66 p_7_66 p_7_67 5.017838e-04
Rph_7_67 p_7_67 p_8_67 5.017838e-04
Rpv_7_67 p_7_67 p_7_68 5.017838e-04
Rph_7_68 p_7_68 p_8_68 5.017838e-04
Rpv_7_68 p_7_68 p_7_69 5.017838e-04
Rph_7_69 p_7_69 p_8_69 5.017838e-04
Rpv_7_69 p_7_69 p_7_70 5.017838e-04
Rph_7_70 p_7_70 p_8_70 5.017838e-04
Rpv_7_70 p_7_70 p_7_71 5.017838e-04
Rph_7_71 p_7_71 p_8_71 5.017838e-04
Rph_8_0 p_8_0 p_9_0 5.017838e-04
Rpv_8_0 p_8_0 p_8_1 5.017838e-04
Rph_8_1 p_8_1 p_9_1 5.017838e-04
Rpv_8_1 p_8_1 p_8_2 5.017838e-04
Rph_8_2 p_8_2 p_9_2 5.017838e-04
Rpv_8_2 p_8_2 p_8_3 5.017838e-04
Rph_8_3 p_8_3 p_9_3 5.017838e-04
Rpv_8_3 p_8_3 p_8_4 5.017838e-04
Rph_8_4 p_8_4 p_9_4 5.017838e-04
Rpv_8_4 p_8_4 p_8_5 5.017838e-04
Rph_8_5 p_8_5 p_9_5 5.017838e-04
Rpv_8_5 p_8_5 p_8_6 5.017838e-04
Rph_8_6 p_8_6 p_9_6 5.017838e-04
Rpv_8_6 p_8_6 p_8_7 5.017838e-04
Rph_8_7 p_8_7 p_9_7 5.017838e-04
Rpv_8_7 p_8_7 p_8_8 5.017838e-04
Rph_8_8 p_8_8 p_9_8 5.017838e-04
Rpv_8_8 p_8_8 p_8_9 5.017838e-04
Rph_8_9 p_8_9 p_9_9 5.017838e-04
Rpv_8_9 p_8_9 p_8_10 5.017838e-04
Rph_8_10 p_8_10 p_9_10 5.017838e-04
Rpv_8_10 p_8_10 p_8_11 5.017838e-04
Rph_8_11 p_8_11 p_9_11 5.017838e-04
Rpv_8_11 p_8_11 p_8_12 5.017838e-04
Rph_8_12 p_8_12 p_9_12 5.017838e-04
Rpv_8_12 p_8_12 p_8_13 5.017838e-04
Rph_8_13 p_8_13 p_9_13 5.017838e-04
Rpv_8_13 p_8_13 p_8_14 5.017838e-04
Rph_8_14 p_8_14 p_9_14 5.017838e-04
Rpv_8_14 p_8_14 p_8_15 5.017838e-04
Rph_8_15 p_8_15 p_9_15 5.017838e-04
Rpv_8_15 p_8_15 p_8_16 5.017838e-04
Rph_8_16 p_8_16 p_9_16 5.017838e-04
Rpv_8_16 p_8_16 p_8_17 5.017838e-04
Rph_8_17 p_8_17 p_9_17 5.017838e-04
Rpv_8_17 p_8_17 p_8_18 5.017838e-04
Rph_8_18 p_8_18 p_9_18 5.017838e-04
Rpv_8_18 p_8_18 p_8_19 5.017838e-04
Rph_8_19 p_8_19 p_9_19 5.017838e-04
Rpv_8_19 p_8_19 p_8_20 5.017838e-04
Rph_8_20 p_8_20 p_9_20 5.017838e-04
Rpv_8_20 p_8_20 p_8_21 5.017838e-04
Rph_8_21 p_8_21 p_9_21 5.017838e-04
Rpv_8_21 p_8_21 p_8_22 5.017838e-04
Rph_8_22 p_8_22 p_9_22 5.017838e-04
Rpv_8_22 p_8_22 p_8_23 5.017838e-04
Rph_8_23 p_8_23 p_9_23 5.017838e-04
Rpv_8_23 p_8_23 p_8_24 5.017838e-04
Rph_8_24 p_8_24 p_9_24 5.017838e-04
Rpv_8_24 p_8_24 p_8_25 5.017838e-04
Rph_8_25 p_8_25 p_9_25 5.017838e-04
Rpv_8_25 p_8_25 p_8_26 5.017838e-04
Rph_8_26 p_8_26 p_9_26 5.017838e-04
Rpv_8_26 p_8_26 p_8_27 5.017838e-04
Rph_8_27 p_8_27 p_9_27 5.017838e-04
Rpv_8_27 p_8_27 p_8_28 5.017838e-04
Rph_8_28 p_8_28 p_9_28 5.017838e-04
Rpv_8_28 p_8_28 p_8_29 5.017838e-04
Rph_8_29 p_8_29 p_9_29 5.017838e-04
Rpv_8_29 p_8_29 p_8_30 5.017838e-04
Rph_8_30 p_8_30 p_9_30 5.017838e-04
Rpv_8_30 p_8_30 p_8_31 5.017838e-04
Rph_8_31 p_8_31 p_9_31 5.017838e-04
Rpv_8_31 p_8_31 p_8_32 5.017838e-04
Rph_8_32 p_8_32 p_9_32 5.017838e-04
Rpv_8_32 p_8_32 p_8_33 5.017838e-04
Rph_8_33 p_8_33 p_9_33 5.017838e-04
Rpv_8_33 p_8_33 p_8_34 5.017838e-04
Rph_8_34 p_8_34 p_9_34 5.017838e-04
Rpv_8_34 p_8_34 p_8_35 5.017838e-04
Rph_8_35 p_8_35 p_9_35 5.017838e-04
Rpv_8_35 p_8_35 p_8_36 5.017838e-04
Rph_8_36 p_8_36 p_9_36 5.017838e-04
Rpv_8_36 p_8_36 p_8_37 5.017838e-04
Rph_8_37 p_8_37 p_9_37 5.017838e-04
Rpv_8_37 p_8_37 p_8_38 5.017838e-04
Rph_8_38 p_8_38 p_9_38 5.017838e-04
Rpv_8_38 p_8_38 p_8_39 5.017838e-04
Rph_8_39 p_8_39 p_9_39 5.017838e-04
Rpv_8_39 p_8_39 p_8_40 5.017838e-04
Rph_8_40 p_8_40 p_9_40 5.017838e-04
Rpv_8_40 p_8_40 p_8_41 5.017838e-04
Rph_8_41 p_8_41 p_9_41 5.017838e-04
Rpv_8_41 p_8_41 p_8_42 5.017838e-04
Rph_8_42 p_8_42 p_9_42 5.017838e-04
Rpv_8_42 p_8_42 p_8_43 5.017838e-04
Rph_8_43 p_8_43 p_9_43 5.017838e-04
Rpv_8_43 p_8_43 p_8_44 5.017838e-04
Rph_8_44 p_8_44 p_9_44 5.017838e-04
Rpv_8_44 p_8_44 p_8_45 5.017838e-04
Rph_8_45 p_8_45 p_9_45 5.017838e-04
Rpv_8_45 p_8_45 p_8_46 5.017838e-04
Rph_8_46 p_8_46 p_9_46 5.017838e-04
Rpv_8_46 p_8_46 p_8_47 5.017838e-04
Rph_8_47 p_8_47 p_9_47 5.017838e-04
Rpv_8_47 p_8_47 p_8_48 5.017838e-04
Rph_8_48 p_8_48 p_9_48 5.017838e-04
Rpv_8_48 p_8_48 p_8_49 5.017838e-04
Rph_8_49 p_8_49 p_9_49 5.017838e-04
Rpv_8_49 p_8_49 p_8_50 5.017838e-04
Rph_8_50 p_8_50 p_9_50 5.017838e-04
Rpv_8_50 p_8_50 p_8_51 5.017838e-04
Rph_8_51 p_8_51 p_9_51 5.017838e-04
Rpv_8_51 p_8_51 p_8_52 5.017838e-04
Rph_8_52 p_8_52 p_9_52 5.017838e-04
Rpv_8_52 p_8_52 p_8_53 5.017838e-04
Rph_8_53 p_8_53 p_9_53 5.017838e-04
Rpv_8_53 p_8_53 p_8_54 5.017838e-04
Rph_8_54 p_8_54 p_9_54 5.017838e-04
Rpv_8_54 p_8_54 p_8_55 5.017838e-04
Rph_8_55 p_8_55 p_9_55 5.017838e-04
Rpv_8_55 p_8_55 p_8_56 5.017838e-04
Rph_8_56 p_8_56 p_9_56 5.017838e-04
Rpv_8_56 p_8_56 p_8_57 5.017838e-04
Rph_8_57 p_8_57 p_9_57 5.017838e-04
Rpv_8_57 p_8_57 p_8_58 5.017838e-04
Rph_8_58 p_8_58 p_9_58 5.017838e-04
Rpv_8_58 p_8_58 p_8_59 5.017838e-04
Rph_8_59 p_8_59 p_9_59 5.017838e-04
Rpv_8_59 p_8_59 p_8_60 5.017838e-04
Rph_8_60 p_8_60 p_9_60 5.017838e-04
Rpv_8_60 p_8_60 p_8_61 5.017838e-04
Rph_8_61 p_8_61 p_9_61 5.017838e-04
Rpv_8_61 p_8_61 p_8_62 5.017838e-04
Rph_8_62 p_8_62 p_9_62 5.017838e-04
Rpv_8_62 p_8_62 p_8_63 5.017838e-04
Rph_8_63 p_8_63 p_9_63 5.017838e-04
Rpv_8_63 p_8_63 p_8_64 5.017838e-04
Rph_8_64 p_8_64 p_9_64 5.017838e-04
Rpv_8_64 p_8_64 p_8_65 5.017838e-04
Rph_8_65 p_8_65 p_9_65 5.017838e-04
Rpv_8_65 p_8_65 p_8_66 5.017838e-04
Rph_8_66 p_8_66 p_9_66 5.017838e-04
Rpv_8_66 p_8_66 p_8_67 5.017838e-04
Rph_8_67 p_8_67 p_9_67 5.017838e-04
Rpv_8_67 p_8_67 p_8_68 5.017838e-04
Rph_8_68 p_8_68 p_9_68 5.017838e-04
Rpv_8_68 p_8_68 p_8_69 5.017838e-04
Rph_8_69 p_8_69 p_9_69 5.017838e-04
Rpv_8_69 p_8_69 p_8_70 5.017838e-04
Rph_8_70 p_8_70 p_9_70 5.017838e-04
Rpv_8_70 p_8_70 p_8_71 5.017838e-04
Rph_8_71 p_8_71 p_9_71 5.017838e-04
Rph_9_0 p_9_0 p_10_0 5.017838e-04
Rpv_9_0 p_9_0 p_9_1 5.017838e-04
Rph_9_1 p_9_1 p_10_1 5.017838e-04
Rpv_9_1 p_9_1 p_9_2 5.017838e-04
Rph_9_2 p_9_2 p_10_2 5.017838e-04
Rpv_9_2 p_9_2 p_9_3 5.017838e-04
Rph_9_3 p_9_3 p_10_3 5.017838e-04
Rpv_9_3 p_9_3 p_9_4 5.017838e-04
Rph_9_4 p_9_4 p_10_4 5.017838e-04
Rpv_9_4 p_9_4 p_9_5 5.017838e-04
Rph_9_5 p_9_5 p_10_5 5.017838e-04
Rpv_9_5 p_9_5 p_9_6 5.017838e-04
Rph_9_6 p_9_6 p_10_6 5.017838e-04
Rpv_9_6 p_9_6 p_9_7 5.017838e-04
Rph_9_7 p_9_7 p_10_7 5.017838e-04
Rpv_9_7 p_9_7 p_9_8 5.017838e-04
Rph_9_8 p_9_8 p_10_8 5.017838e-04
Rpv_9_8 p_9_8 p_9_9 5.017838e-04
Rph_9_9 p_9_9 p_10_9 5.017838e-04
Rpv_9_9 p_9_9 p_9_10 5.017838e-04
Rph_9_10 p_9_10 p_10_10 5.017838e-04
Rpv_9_10 p_9_10 p_9_11 5.017838e-04
Rph_9_11 p_9_11 p_10_11 5.017838e-04
Rpv_9_11 p_9_11 p_9_12 5.017838e-04
Rph_9_12 p_9_12 p_10_12 5.017838e-04
Rpv_9_12 p_9_12 p_9_13 5.017838e-04
Rph_9_13 p_9_13 p_10_13 5.017838e-04
Rpv_9_13 p_9_13 p_9_14 5.017838e-04
Rph_9_14 p_9_14 p_10_14 5.017838e-04
Rpv_9_14 p_9_14 p_9_15 5.017838e-04
Rph_9_15 p_9_15 p_10_15 5.017838e-04
Rpv_9_15 p_9_15 p_9_16 5.017838e-04
Rph_9_16 p_9_16 p_10_16 5.017838e-04
Rpv_9_16 p_9_16 p_9_17 5.017838e-04
Rph_9_17 p_9_17 p_10_17 5.017838e-04
Rpv_9_17 p_9_17 p_9_18 5.017838e-04
Rph_9_18 p_9_18 p_10_18 5.017838e-04
Rpv_9_18 p_9_18 p_9_19 5.017838e-04
Rph_9_19 p_9_19 p_10_19 5.017838e-04
Rpv_9_19 p_9_19 p_9_20 5.017838e-04
Rph_9_20 p_9_20 p_10_20 5.017838e-04
Rpv_9_20 p_9_20 p_9_21 5.017838e-04
Rph_9_21 p_9_21 p_10_21 5.017838e-04
Rpv_9_21 p_9_21 p_9_22 5.017838e-04
Rph_9_22 p_9_22 p_10_22 5.017838e-04
Rpv_9_22 p_9_22 p_9_23 5.017838e-04
Rph_9_23 p_9_23 p_10_23 5.017838e-04
Rpv_9_23 p_9_23 p_9_24 5.017838e-04
Rph_9_24 p_9_24 p_10_24 5.017838e-04
Rpv_9_24 p_9_24 p_9_25 5.017838e-04
Rph_9_25 p_9_25 p_10_25 5.017838e-04
Rpv_9_25 p_9_25 p_9_26 5.017838e-04
Rph_9_26 p_9_26 p_10_26 5.017838e-04
Rpv_9_26 p_9_26 p_9_27 5.017838e-04
Rph_9_27 p_9_27 p_10_27 5.017838e-04
Rpv_9_27 p_9_27 p_9_28 5.017838e-04
Rph_9_28 p_9_28 p_10_28 5.017838e-04
Rpv_9_28 p_9_28 p_9_29 5.017838e-04
Rph_9_29 p_9_29 p_10_29 5.017838e-04
Rpv_9_29 p_9_29 p_9_30 5.017838e-04
Rph_9_30 p_9_30 p_10_30 5.017838e-04
Rpv_9_30 p_9_30 p_9_31 5.017838e-04
Rph_9_31 p_9_31 p_10_31 5.017838e-04
Rpv_9_31 p_9_31 p_9_32 5.017838e-04
Rph_9_32 p_9_32 p_10_32 5.017838e-04
Rpv_9_32 p_9_32 p_9_33 5.017838e-04
Rph_9_33 p_9_33 p_10_33 5.017838e-04
Rpv_9_33 p_9_33 p_9_34 5.017838e-04
Rph_9_34 p_9_34 p_10_34 5.017838e-04
Rpv_9_34 p_9_34 p_9_35 5.017838e-04
Rph_9_35 p_9_35 p_10_35 5.017838e-04
Rpv_9_35 p_9_35 p_9_36 5.017838e-04
Rph_9_36 p_9_36 p_10_36 5.017838e-04
Rpv_9_36 p_9_36 p_9_37 5.017838e-04
Rph_9_37 p_9_37 p_10_37 5.017838e-04
Rpv_9_37 p_9_37 p_9_38 5.017838e-04
Rph_9_38 p_9_38 p_10_38 5.017838e-04
Rpv_9_38 p_9_38 p_9_39 5.017838e-04
Rph_9_39 p_9_39 p_10_39 5.017838e-04
Rpv_9_39 p_9_39 p_9_40 5.017838e-04
Rph_9_40 p_9_40 p_10_40 5.017838e-04
Rpv_9_40 p_9_40 p_9_41 5.017838e-04
Rph_9_41 p_9_41 p_10_41 5.017838e-04
Rpv_9_41 p_9_41 p_9_42 5.017838e-04
Rph_9_42 p_9_42 p_10_42 5.017838e-04
Rpv_9_42 p_9_42 p_9_43 5.017838e-04
Rph_9_43 p_9_43 p_10_43 5.017838e-04
Rpv_9_43 p_9_43 p_9_44 5.017838e-04
Rph_9_44 p_9_44 p_10_44 5.017838e-04
Rpv_9_44 p_9_44 p_9_45 5.017838e-04
Rph_9_45 p_9_45 p_10_45 5.017838e-04
Rpv_9_45 p_9_45 p_9_46 5.017838e-04
Rph_9_46 p_9_46 p_10_46 5.017838e-04
Rpv_9_46 p_9_46 p_9_47 5.017838e-04
Rph_9_47 p_9_47 p_10_47 5.017838e-04
Rpv_9_47 p_9_47 p_9_48 5.017838e-04
Rph_9_48 p_9_48 p_10_48 5.017838e-04
Rpv_9_48 p_9_48 p_9_49 5.017838e-04
Rph_9_49 p_9_49 p_10_49 5.017838e-04
Rpv_9_49 p_9_49 p_9_50 5.017838e-04
Rph_9_50 p_9_50 p_10_50 5.017838e-04
Rpv_9_50 p_9_50 p_9_51 5.017838e-04
Rph_9_51 p_9_51 p_10_51 5.017838e-04
Rpv_9_51 p_9_51 p_9_52 5.017838e-04
Rph_9_52 p_9_52 p_10_52 5.017838e-04
Rpv_9_52 p_9_52 p_9_53 5.017838e-04
Rph_9_53 p_9_53 p_10_53 5.017838e-04
Rpv_9_53 p_9_53 p_9_54 5.017838e-04
Rph_9_54 p_9_54 p_10_54 5.017838e-04
Rpv_9_54 p_9_54 p_9_55 5.017838e-04
Rph_9_55 p_9_55 p_10_55 5.017838e-04
Rpv_9_55 p_9_55 p_9_56 5.017838e-04
Rph_9_56 p_9_56 p_10_56 5.017838e-04
Rpv_9_56 p_9_56 p_9_57 5.017838e-04
Rph_9_57 p_9_57 p_10_57 5.017838e-04
Rpv_9_57 p_9_57 p_9_58 5.017838e-04
Rph_9_58 p_9_58 p_10_58 5.017838e-04
Rpv_9_58 p_9_58 p_9_59 5.017838e-04
Rph_9_59 p_9_59 p_10_59 5.017838e-04
Rpv_9_59 p_9_59 p_9_60 5.017838e-04
Rph_9_60 p_9_60 p_10_60 5.017838e-04
Rpv_9_60 p_9_60 p_9_61 5.017838e-04
Rph_9_61 p_9_61 p_10_61 5.017838e-04
Rpv_9_61 p_9_61 p_9_62 5.017838e-04
Rph_9_62 p_9_62 p_10_62 5.017838e-04
Rpv_9_62 p_9_62 p_9_63 5.017838e-04
Rph_9_63 p_9_63 p_10_63 5.017838e-04
Rpv_9_63 p_9_63 p_9_64 5.017838e-04
Rph_9_64 p_9_64 p_10_64 5.017838e-04
Rpv_9_64 p_9_64 p_9_65 5.017838e-04
Rph_9_65 p_9_65 p_10_65 5.017838e-04
Rpv_9_65 p_9_65 p_9_66 5.017838e-04
Rph_9_66 p_9_66 p_10_66 5.017838e-04
Rpv_9_66 p_9_66 p_9_67 5.017838e-04
Rph_9_67 p_9_67 p_10_67 5.017838e-04
Rpv_9_67 p_9_67 p_9_68 5.017838e-04
Rph_9_68 p_9_68 p_10_68 5.017838e-04
Rpv_9_68 p_9_68 p_9_69 5.017838e-04
Rph_9_69 p_9_69 p_10_69 5.017838e-04
Rpv_9_69 p_9_69 p_9_70 5.017838e-04
Rph_9_70 p_9_70 p_10_70 5.017838e-04
Rpv_9_70 p_9_70 p_9_71 5.017838e-04
Rph_9_71 p_9_71 p_10_71 5.017838e-04
Rph_10_0 p_10_0 p_11_0 5.017838e-04
Rpv_10_0 p_10_0 p_10_1 5.017838e-04
Rph_10_1 p_10_1 p_11_1 5.017838e-04
Rpv_10_1 p_10_1 p_10_2 5.017838e-04
Rph_10_2 p_10_2 p_11_2 5.017838e-04
Rpv_10_2 p_10_2 p_10_3 5.017838e-04
Rph_10_3 p_10_3 p_11_3 5.017838e-04
Rpv_10_3 p_10_3 p_10_4 5.017838e-04
Rph_10_4 p_10_4 p_11_4 5.017838e-04
Rpv_10_4 p_10_4 p_10_5 5.017838e-04
Rph_10_5 p_10_5 p_11_5 5.017838e-04
Rpv_10_5 p_10_5 p_10_6 5.017838e-04
Rph_10_6 p_10_6 p_11_6 5.017838e-04
Rpv_10_6 p_10_6 p_10_7 5.017838e-04
Rph_10_7 p_10_7 p_11_7 5.017838e-04
Rpv_10_7 p_10_7 p_10_8 5.017838e-04
Rph_10_8 p_10_8 p_11_8 5.017838e-04
Rpv_10_8 p_10_8 p_10_9 5.017838e-04
Rph_10_9 p_10_9 p_11_9 5.017838e-04
Rpv_10_9 p_10_9 p_10_10 5.017838e-04
Rph_10_10 p_10_10 p_11_10 5.017838e-04
Rpv_10_10 p_10_10 p_10_11 5.017838e-04
Rph_10_11 p_10_11 p_11_11 5.017838e-04
Rpv_10_11 p_10_11 p_10_12 5.017838e-04
Rph_10_12 p_10_12 p_11_12 5.017838e-04
Rpv_10_12 p_10_12 p_10_13 5.017838e-04
Rph_10_13 p_10_13 p_11_13 5.017838e-04
Rpv_10_13 p_10_13 p_10_14 5.017838e-04
Rph_10_14 p_10_14 p_11_14 5.017838e-04
Rpv_10_14 p_10_14 p_10_15 5.017838e-04
Rph_10_15 p_10_15 p_11_15 5.017838e-04
Rpv_10_15 p_10_15 p_10_16 5.017838e-04
Rph_10_16 p_10_16 p_11_16 5.017838e-04
Rpv_10_16 p_10_16 p_10_17 5.017838e-04
Rph_10_17 p_10_17 p_11_17 5.017838e-04
Rpv_10_17 p_10_17 p_10_18 5.017838e-04
Rph_10_18 p_10_18 p_11_18 5.017838e-04
Rpv_10_18 p_10_18 p_10_19 5.017838e-04
Rph_10_19 p_10_19 p_11_19 5.017838e-04
Rpv_10_19 p_10_19 p_10_20 5.017838e-04
Rph_10_20 p_10_20 p_11_20 5.017838e-04
Rpv_10_20 p_10_20 p_10_21 5.017838e-04
Rph_10_21 p_10_21 p_11_21 5.017838e-04
Rpv_10_21 p_10_21 p_10_22 5.017838e-04
Rph_10_22 p_10_22 p_11_22 5.017838e-04
Rpv_10_22 p_10_22 p_10_23 5.017838e-04
Rph_10_23 p_10_23 p_11_23 5.017838e-04
Rpv_10_23 p_10_23 p_10_24 5.017838e-04
Rph_10_24 p_10_24 p_11_24 5.017838e-04
Rpv_10_24 p_10_24 p_10_25 5.017838e-04
Rph_10_25 p_10_25 p_11_25 5.017838e-04
Rpv_10_25 p_10_25 p_10_26 5.017838e-04
Rph_10_26 p_10_26 p_11_26 5.017838e-04
Rpv_10_26 p_10_26 p_10_27 5.017838e-04
Rph_10_27 p_10_27 p_11_27 5.017838e-04
Rpv_10_27 p_10_27 p_10_28 5.017838e-04
Rph_10_28 p_10_28 p_11_28 5.017838e-04
Rpv_10_28 p_10_28 p_10_29 5.017838e-04
Rph_10_29 p_10_29 p_11_29 5.017838e-04
Rpv_10_29 p_10_29 p_10_30 5.017838e-04
Rph_10_30 p_10_30 p_11_30 5.017838e-04
Rpv_10_30 p_10_30 p_10_31 5.017838e-04
Rph_10_31 p_10_31 p_11_31 5.017838e-04
Rpv_10_31 p_10_31 p_10_32 5.017838e-04
Rph_10_32 p_10_32 p_11_32 5.017838e-04
Rpv_10_32 p_10_32 p_10_33 5.017838e-04
Rph_10_33 p_10_33 p_11_33 5.017838e-04
Rpv_10_33 p_10_33 p_10_34 5.017838e-04
Rph_10_34 p_10_34 p_11_34 5.017838e-04
Rpv_10_34 p_10_34 p_10_35 5.017838e-04
Rph_10_35 p_10_35 p_11_35 5.017838e-04
Rpv_10_35 p_10_35 p_10_36 5.017838e-04
Rph_10_36 p_10_36 p_11_36 5.017838e-04
Rpv_10_36 p_10_36 p_10_37 5.017838e-04
Rph_10_37 p_10_37 p_11_37 5.017838e-04
Rpv_10_37 p_10_37 p_10_38 5.017838e-04
Rph_10_38 p_10_38 p_11_38 5.017838e-04
Rpv_10_38 p_10_38 p_10_39 5.017838e-04
Rph_10_39 p_10_39 p_11_39 5.017838e-04
Rpv_10_39 p_10_39 p_10_40 5.017838e-04
Rph_10_40 p_10_40 p_11_40 5.017838e-04
Rpv_10_40 p_10_40 p_10_41 5.017838e-04
Rph_10_41 p_10_41 p_11_41 5.017838e-04
Rpv_10_41 p_10_41 p_10_42 5.017838e-04
Rph_10_42 p_10_42 p_11_42 5.017838e-04
Rpv_10_42 p_10_42 p_10_43 5.017838e-04
Rph_10_43 p_10_43 p_11_43 5.017838e-04
Rpv_10_43 p_10_43 p_10_44 5.017838e-04
Rph_10_44 p_10_44 p_11_44 5.017838e-04
Rpv_10_44 p_10_44 p_10_45 5.017838e-04
Rph_10_45 p_10_45 p_11_45 5.017838e-04
Rpv_10_45 p_10_45 p_10_46 5.017838e-04
Rph_10_46 p_10_46 p_11_46 5.017838e-04
Rpv_10_46 p_10_46 p_10_47 5.017838e-04
Rph_10_47 p_10_47 p_11_47 5.017838e-04
Rpv_10_47 p_10_47 p_10_48 5.017838e-04
Rph_10_48 p_10_48 p_11_48 5.017838e-04
Rpv_10_48 p_10_48 p_10_49 5.017838e-04
Rph_10_49 p_10_49 p_11_49 5.017838e-04
Rpv_10_49 p_10_49 p_10_50 5.017838e-04
Rph_10_50 p_10_50 p_11_50 5.017838e-04
Rpv_10_50 p_10_50 p_10_51 5.017838e-04
Rph_10_51 p_10_51 p_11_51 5.017838e-04
Rpv_10_51 p_10_51 p_10_52 5.017838e-04
Rph_10_52 p_10_52 p_11_52 5.017838e-04
Rpv_10_52 p_10_52 p_10_53 5.017838e-04
Rph_10_53 p_10_53 p_11_53 5.017838e-04
Rpv_10_53 p_10_53 p_10_54 5.017838e-04
Rph_10_54 p_10_54 p_11_54 5.017838e-04
Rpv_10_54 p_10_54 p_10_55 5.017838e-04
Rph_10_55 p_10_55 p_11_55 5.017838e-04
Rpv_10_55 p_10_55 p_10_56 5.017838e-04
Rph_10_56 p_10_56 p_11_56 5.017838e-04
Rpv_10_56 p_10_56 p_10_57 5.017838e-04
Rph_10_57 p_10_57 p_11_57 5.017838e-04
Rpv_10_57 p_10_57 p_10_58 5.017838e-04
Rph_10_58 p_10_58 p_11_58 5.017838e-04
Rpv_10_58 p_10_58 p_10_59 5.017838e-04
Rph_10_59 p_10_59 p_11_59 5.017838e-04
Rpv_10_59 p_10_59 p_10_60 5.017838e-04
Rph_10_60 p_10_60 p_11_60 5.017838e-04
Rpv_10_60 p_10_60 p_10_61 5.017838e-04
Rph_10_61 p_10_61 p_11_61 5.017838e-04
Rpv_10_61 p_10_61 p_10_62 5.017838e-04
Rph_10_62 p_10_62 p_11_62 5.017838e-04
Rpv_10_62 p_10_62 p_10_63 5.017838e-04
Rph_10_63 p_10_63 p_11_63 5.017838e-04
Rpv_10_63 p_10_63 p_10_64 5.017838e-04
Rph_10_64 p_10_64 p_11_64 5.017838e-04
Rpv_10_64 p_10_64 p_10_65 5.017838e-04
Rph_10_65 p_10_65 p_11_65 5.017838e-04
Rpv_10_65 p_10_65 p_10_66 5.017838e-04
Rph_10_66 p_10_66 p_11_66 5.017838e-04
Rpv_10_66 p_10_66 p_10_67 5.017838e-04
Rph_10_67 p_10_67 p_11_67 5.017838e-04
Rpv_10_67 p_10_67 p_10_68 5.017838e-04
Rph_10_68 p_10_68 p_11_68 5.017838e-04
Rpv_10_68 p_10_68 p_10_69 5.017838e-04
Rph_10_69 p_10_69 p_11_69 5.017838e-04
Rpv_10_69 p_10_69 p_10_70 5.017838e-04
Rph_10_70 p_10_70 p_11_70 5.017838e-04
Rpv_10_70 p_10_70 p_10_71 5.017838e-04
Rph_10_71 p_10_71 p_11_71 5.017838e-04
Rph_11_0 p_11_0 p_12_0 5.017838e-04
Rpv_11_0 p_11_0 p_11_1 5.017838e-04
Rph_11_1 p_11_1 p_12_1 5.017838e-04
Rpv_11_1 p_11_1 p_11_2 5.017838e-04
Rph_11_2 p_11_2 p_12_2 5.017838e-04
Rpv_11_2 p_11_2 p_11_3 5.017838e-04
Rph_11_3 p_11_3 p_12_3 5.017838e-04
Rpv_11_3 p_11_3 p_11_4 5.017838e-04
Rph_11_4 p_11_4 p_12_4 5.017838e-04
Rpv_11_4 p_11_4 p_11_5 5.017838e-04
Rph_11_5 p_11_5 p_12_5 5.017838e-04
Rpv_11_5 p_11_5 p_11_6 5.017838e-04
Rph_11_6 p_11_6 p_12_6 5.017838e-04
Rpv_11_6 p_11_6 p_11_7 5.017838e-04
Rph_11_7 p_11_7 p_12_7 5.017838e-04
Rpv_11_7 p_11_7 p_11_8 5.017838e-04
Rph_11_8 p_11_8 p_12_8 5.017838e-04
Rpv_11_8 p_11_8 p_11_9 5.017838e-04
Rph_11_9 p_11_9 p_12_9 5.017838e-04
Rpv_11_9 p_11_9 p_11_10 5.017838e-04
Rph_11_10 p_11_10 p_12_10 5.017838e-04
Rpv_11_10 p_11_10 p_11_11 5.017838e-04
Rph_11_11 p_11_11 p_12_11 5.017838e-04
Rpv_11_11 p_11_11 p_11_12 5.017838e-04
Rph_11_12 p_11_12 p_12_12 5.017838e-04
Rpv_11_12 p_11_12 p_11_13 5.017838e-04
Rph_11_13 p_11_13 p_12_13 5.017838e-04
Rpv_11_13 p_11_13 p_11_14 5.017838e-04
Rph_11_14 p_11_14 p_12_14 5.017838e-04
Rpv_11_14 p_11_14 p_11_15 5.017838e-04
Rph_11_15 p_11_15 p_12_15 5.017838e-04
Rpv_11_15 p_11_15 p_11_16 5.017838e-04
Rph_11_16 p_11_16 p_12_16 5.017838e-04
Rpv_11_16 p_11_16 p_11_17 5.017838e-04
Rph_11_17 p_11_17 p_12_17 5.017838e-04
Rpv_11_17 p_11_17 p_11_18 5.017838e-04
Rph_11_18 p_11_18 p_12_18 5.017838e-04
Rpv_11_18 p_11_18 p_11_19 5.017838e-04
Rph_11_19 p_11_19 p_12_19 5.017838e-04
Rpv_11_19 p_11_19 p_11_20 5.017838e-04
Rph_11_20 p_11_20 p_12_20 5.017838e-04
Rpv_11_20 p_11_20 p_11_21 5.017838e-04
Rph_11_21 p_11_21 p_12_21 5.017838e-04
Rpv_11_21 p_11_21 p_11_22 5.017838e-04
Rph_11_22 p_11_22 p_12_22 5.017838e-04
Rpv_11_22 p_11_22 p_11_23 5.017838e-04
Rph_11_23 p_11_23 p_12_23 5.017838e-04
Rpv_11_23 p_11_23 p_11_24 5.017838e-04
Rph_11_24 p_11_24 p_12_24 5.017838e-04
Rpv_11_24 p_11_24 p_11_25 5.017838e-04
Rph_11_25 p_11_25 p_12_25 5.017838e-04
Rpv_11_25 p_11_25 p_11_26 5.017838e-04
Rph_11_26 p_11_26 p_12_26 5.017838e-04
Rpv_11_26 p_11_26 p_11_27 5.017838e-04
Rph_11_27 p_11_27 p_12_27 5.017838e-04
Rpv_11_27 p_11_27 p_11_28 5.017838e-04
Rph_11_28 p_11_28 p_12_28 5.017838e-04
Rpv_11_28 p_11_28 p_11_29 5.017838e-04
Rph_11_29 p_11_29 p_12_29 5.017838e-04
Rpv_11_29 p_11_29 p_11_30 5.017838e-04
Rph_11_30 p_11_30 p_12_30 5.017838e-04
Rpv_11_30 p_11_30 p_11_31 5.017838e-04
Rph_11_31 p_11_31 p_12_31 5.017838e-04
Rpv_11_31 p_11_31 p_11_32 5.017838e-04
Rph_11_32 p_11_32 p_12_32 5.017838e-04
Rpv_11_32 p_11_32 p_11_33 5.017838e-04
Rph_11_33 p_11_33 p_12_33 5.017838e-04
Rpv_11_33 p_11_33 p_11_34 5.017838e-04
Rph_11_34 p_11_34 p_12_34 5.017838e-04
Rpv_11_34 p_11_34 p_11_35 5.017838e-04
Rph_11_35 p_11_35 p_12_35 5.017838e-04
Rpv_11_35 p_11_35 p_11_36 5.017838e-04
Rph_11_36 p_11_36 p_12_36 5.017838e-04
Rpv_11_36 p_11_36 p_11_37 5.017838e-04
Rph_11_37 p_11_37 p_12_37 5.017838e-04
Rpv_11_37 p_11_37 p_11_38 5.017838e-04
Rph_11_38 p_11_38 p_12_38 5.017838e-04
Rpv_11_38 p_11_38 p_11_39 5.017838e-04
Rph_11_39 p_11_39 p_12_39 5.017838e-04
Rpv_11_39 p_11_39 p_11_40 5.017838e-04
Rph_11_40 p_11_40 p_12_40 5.017838e-04
Rpv_11_40 p_11_40 p_11_41 5.017838e-04
Rph_11_41 p_11_41 p_12_41 5.017838e-04
Rpv_11_41 p_11_41 p_11_42 5.017838e-04
Rph_11_42 p_11_42 p_12_42 5.017838e-04
Rpv_11_42 p_11_42 p_11_43 5.017838e-04
Rph_11_43 p_11_43 p_12_43 5.017838e-04
Rpv_11_43 p_11_43 p_11_44 5.017838e-04
Rph_11_44 p_11_44 p_12_44 5.017838e-04
Rpv_11_44 p_11_44 p_11_45 5.017838e-04
Rph_11_45 p_11_45 p_12_45 5.017838e-04
Rpv_11_45 p_11_45 p_11_46 5.017838e-04
Rph_11_46 p_11_46 p_12_46 5.017838e-04
Rpv_11_46 p_11_46 p_11_47 5.017838e-04
Rph_11_47 p_11_47 p_12_47 5.017838e-04
Rpv_11_47 p_11_47 p_11_48 5.017838e-04
Rph_11_48 p_11_48 p_12_48 5.017838e-04
Rpv_11_48 p_11_48 p_11_49 5.017838e-04
Rph_11_49 p_11_49 p_12_49 5.017838e-04
Rpv_11_49 p_11_49 p_11_50 5.017838e-04
Rph_11_50 p_11_50 p_12_50 5.017838e-04
Rpv_11_50 p_11_50 p_11_51 5.017838e-04
Rph_11_51 p_11_51 p_12_51 5.017838e-04
Rpv_11_51 p_11_51 p_11_52 5.017838e-04
Rph_11_52 p_11_52 p_12_52 5.017838e-04
Rpv_11_52 p_11_52 p_11_53 5.017838e-04
Rph_11_53 p_11_53 p_12_53 5.017838e-04
Rpv_11_53 p_11_53 p_11_54 5.017838e-04
Rph_11_54 p_11_54 p_12_54 5.017838e-04
Rpv_11_54 p_11_54 p_11_55 5.017838e-04
Rph_11_55 p_11_55 p_12_55 5.017838e-04
Rpv_11_55 p_11_55 p_11_56 5.017838e-04
Rph_11_56 p_11_56 p_12_56 5.017838e-04
Rpv_11_56 p_11_56 p_11_57 5.017838e-04
Rph_11_57 p_11_57 p_12_57 5.017838e-04
Rpv_11_57 p_11_57 p_11_58 5.017838e-04
Rph_11_58 p_11_58 p_12_58 5.017838e-04
Rpv_11_58 p_11_58 p_11_59 5.017838e-04
Rph_11_59 p_11_59 p_12_59 5.017838e-04
Rpv_11_59 p_11_59 p_11_60 5.017838e-04
Rph_11_60 p_11_60 p_12_60 5.017838e-04
Rpv_11_60 p_11_60 p_11_61 5.017838e-04
Rph_11_61 p_11_61 p_12_61 5.017838e-04
Rpv_11_61 p_11_61 p_11_62 5.017838e-04
Rph_11_62 p_11_62 p_12_62 5.017838e-04
Rpv_11_62 p_11_62 p_11_63 5.017838e-04
Rph_11_63 p_11_63 p_12_63 5.017838e-04
Rpv_11_63 p_11_63 p_11_64 5.017838e-04
Rph_11_64 p_11_64 p_12_64 5.017838e-04
Rpv_11_64 p_11_64 p_11_65 5.017838e-04
Rph_11_65 p_11_65 p_12_65 5.017838e-04
Rpv_11_65 p_11_65 p_11_66 5.017838e-04
Rph_11_66 p_11_66 p_12_66 5.017838e-04
Rpv_11_66 p_11_66 p_11_67 5.017838e-04
Rph_11_67 p_11_67 p_12_67 5.017838e-04
Rpv_11_67 p_11_67 p_11_68 5.017838e-04
Rph_11_68 p_11_68 p_12_68 5.017838e-04
Rpv_11_68 p_11_68 p_11_69 5.017838e-04
Rph_11_69 p_11_69 p_12_69 5.017838e-04
Rpv_11_69 p_11_69 p_11_70 5.017838e-04
Rph_11_70 p_11_70 p_12_70 5.017838e-04
Rpv_11_70 p_11_70 p_11_71 5.017838e-04
Rph_11_71 p_11_71 p_12_71 5.017838e-04
Rph_12_0 p_12_0 p_13_0 5.017838e-04
Rpv_12_0 p_12_0 p_12_1 5.017838e-04
Rph_12_1 p_12_1 p_13_1 5.017838e-04
Rpv_12_1 p_12_1 p_12_2 5.017838e-04
Rph_12_2 p_12_2 p_13_2 5.017838e-04
Rpv_12_2 p_12_2 p_12_3 5.017838e-04
Rph_12_3 p_12_3 p_13_3 5.017838e-04
Rpv_12_3 p_12_3 p_12_4 5.017838e-04
Rph_12_4 p_12_4 p_13_4 5.017838e-04
Rpv_12_4 p_12_4 p_12_5 5.017838e-04
Rph_12_5 p_12_5 p_13_5 5.017838e-04
Rpv_12_5 p_12_5 p_12_6 5.017838e-04
Rph_12_6 p_12_6 p_13_6 5.017838e-04
Rpv_12_6 p_12_6 p_12_7 5.017838e-04
Rph_12_7 p_12_7 p_13_7 5.017838e-04
Rpv_12_7 p_12_7 p_12_8 5.017838e-04
Rph_12_8 p_12_8 p_13_8 5.017838e-04
Rpv_12_8 p_12_8 p_12_9 5.017838e-04
Rph_12_9 p_12_9 p_13_9 5.017838e-04
Rpv_12_9 p_12_9 p_12_10 5.017838e-04
Rph_12_10 p_12_10 p_13_10 5.017838e-04
Rpv_12_10 p_12_10 p_12_11 5.017838e-04
Rph_12_11 p_12_11 p_13_11 5.017838e-04
Rpv_12_11 p_12_11 p_12_12 5.017838e-04
Rph_12_12 p_12_12 p_13_12 5.017838e-04
Rpv_12_12 p_12_12 p_12_13 5.017838e-04
Rph_12_13 p_12_13 p_13_13 5.017838e-04
Rpv_12_13 p_12_13 p_12_14 5.017838e-04
Rph_12_14 p_12_14 p_13_14 5.017838e-04
Rpv_12_14 p_12_14 p_12_15 5.017838e-04
Rph_12_15 p_12_15 p_13_15 5.017838e-04
Rpv_12_15 p_12_15 p_12_16 5.017838e-04
Rph_12_16 p_12_16 p_13_16 5.017838e-04
Rpv_12_16 p_12_16 p_12_17 5.017838e-04
Rph_12_17 p_12_17 p_13_17 5.017838e-04
Rpv_12_17 p_12_17 p_12_18 5.017838e-04
Rph_12_18 p_12_18 p_13_18 5.017838e-04
Rpv_12_18 p_12_18 p_12_19 5.017838e-04
Rph_12_19 p_12_19 p_13_19 5.017838e-04
Rpv_12_19 p_12_19 p_12_20 5.017838e-04
Rph_12_20 p_12_20 p_13_20 5.017838e-04
Rpv_12_20 p_12_20 p_12_21 5.017838e-04
Rph_12_21 p_12_21 p_13_21 5.017838e-04
Rpv_12_21 p_12_21 p_12_22 5.017838e-04
Rph_12_22 p_12_22 p_13_22 5.017838e-04
Rpv_12_22 p_12_22 p_12_23 5.017838e-04
Rph_12_23 p_12_23 p_13_23 5.017838e-04
Rpv_12_23 p_12_23 p_12_24 5.017838e-04
Rph_12_24 p_12_24 p_13_24 5.017838e-04
Rpv_12_24 p_12_24 p_12_25 5.017838e-04
Rph_12_25 p_12_25 p_13_25 5.017838e-04
Rpv_12_25 p_12_25 p_12_26 5.017838e-04
Rph_12_26 p_12_26 p_13_26 5.017838e-04
Rpv_12_26 p_12_26 p_12_27 5.017838e-04
Rph_12_27 p_12_27 p_13_27 5.017838e-04
Rpv_12_27 p_12_27 p_12_28 5.017838e-04
Rph_12_28 p_12_28 p_13_28 5.017838e-04
Rpv_12_28 p_12_28 p_12_29 5.017838e-04
Rph_12_29 p_12_29 p_13_29 5.017838e-04
Rpv_12_29 p_12_29 p_12_30 5.017838e-04
Rph_12_30 p_12_30 p_13_30 5.017838e-04
Rpv_12_30 p_12_30 p_12_31 5.017838e-04
Rph_12_31 p_12_31 p_13_31 5.017838e-04
Rpv_12_31 p_12_31 p_12_32 5.017838e-04
Rph_12_32 p_12_32 p_13_32 5.017838e-04
Rpv_12_32 p_12_32 p_12_33 5.017838e-04
Rph_12_33 p_12_33 p_13_33 5.017838e-04
Rpv_12_33 p_12_33 p_12_34 5.017838e-04
Rph_12_34 p_12_34 p_13_34 5.017838e-04
Rpv_12_34 p_12_34 p_12_35 5.017838e-04
Rph_12_35 p_12_35 p_13_35 5.017838e-04
Rpv_12_35 p_12_35 p_12_36 5.017838e-04
Rph_12_36 p_12_36 p_13_36 5.017838e-04
Rpv_12_36 p_12_36 p_12_37 5.017838e-04
Rph_12_37 p_12_37 p_13_37 5.017838e-04
Rpv_12_37 p_12_37 p_12_38 5.017838e-04
Rph_12_38 p_12_38 p_13_38 5.017838e-04
Rpv_12_38 p_12_38 p_12_39 5.017838e-04
Rph_12_39 p_12_39 p_13_39 5.017838e-04
Rpv_12_39 p_12_39 p_12_40 5.017838e-04
Rph_12_40 p_12_40 p_13_40 5.017838e-04
Rpv_12_40 p_12_40 p_12_41 5.017838e-04
Rph_12_41 p_12_41 p_13_41 5.017838e-04
Rpv_12_41 p_12_41 p_12_42 5.017838e-04
Rph_12_42 p_12_42 p_13_42 5.017838e-04
Rpv_12_42 p_12_42 p_12_43 5.017838e-04
Rph_12_43 p_12_43 p_13_43 5.017838e-04
Rpv_12_43 p_12_43 p_12_44 5.017838e-04
Rph_12_44 p_12_44 p_13_44 5.017838e-04
Rpv_12_44 p_12_44 p_12_45 5.017838e-04
Rph_12_45 p_12_45 p_13_45 5.017838e-04
Rpv_12_45 p_12_45 p_12_46 5.017838e-04
Rph_12_46 p_12_46 p_13_46 5.017838e-04
Rpv_12_46 p_12_46 p_12_47 5.017838e-04
Rph_12_47 p_12_47 p_13_47 5.017838e-04
Rpv_12_47 p_12_47 p_12_48 5.017838e-04
Rph_12_48 p_12_48 p_13_48 5.017838e-04
Rpv_12_48 p_12_48 p_12_49 5.017838e-04
Rph_12_49 p_12_49 p_13_49 5.017838e-04
Rpv_12_49 p_12_49 p_12_50 5.017838e-04
Rph_12_50 p_12_50 p_13_50 5.017838e-04
Rpv_12_50 p_12_50 p_12_51 5.017838e-04
Rph_12_51 p_12_51 p_13_51 5.017838e-04
Rpv_12_51 p_12_51 p_12_52 5.017838e-04
Rph_12_52 p_12_52 p_13_52 5.017838e-04
Rpv_12_52 p_12_52 p_12_53 5.017838e-04
Rph_12_53 p_12_53 p_13_53 5.017838e-04
Rpv_12_53 p_12_53 p_12_54 5.017838e-04
Rph_12_54 p_12_54 p_13_54 5.017838e-04
Rpv_12_54 p_12_54 p_12_55 5.017838e-04
Rph_12_55 p_12_55 p_13_55 5.017838e-04
Rpv_12_55 p_12_55 p_12_56 5.017838e-04
Rph_12_56 p_12_56 p_13_56 5.017838e-04
Rpv_12_56 p_12_56 p_12_57 5.017838e-04
Rph_12_57 p_12_57 p_13_57 5.017838e-04
Rpv_12_57 p_12_57 p_12_58 5.017838e-04
Rph_12_58 p_12_58 p_13_58 5.017838e-04
Rpv_12_58 p_12_58 p_12_59 5.017838e-04
Rph_12_59 p_12_59 p_13_59 5.017838e-04
Rpv_12_59 p_12_59 p_12_60 5.017838e-04
Rph_12_60 p_12_60 p_13_60 5.017838e-04
Rpv_12_60 p_12_60 p_12_61 5.017838e-04
Rph_12_61 p_12_61 p_13_61 5.017838e-04
Rpv_12_61 p_12_61 p_12_62 5.017838e-04
Rph_12_62 p_12_62 p_13_62 5.017838e-04
Rpv_12_62 p_12_62 p_12_63 5.017838e-04
Rph_12_63 p_12_63 p_13_63 5.017838e-04
Rpv_12_63 p_12_63 p_12_64 5.017838e-04
Rph_12_64 p_12_64 p_13_64 5.017838e-04
Rpv_12_64 p_12_64 p_12_65 5.017838e-04
Rph_12_65 p_12_65 p_13_65 5.017838e-04
Rpv_12_65 p_12_65 p_12_66 5.017838e-04
Rph_12_66 p_12_66 p_13_66 5.017838e-04
Rpv_12_66 p_12_66 p_12_67 5.017838e-04
Rph_12_67 p_12_67 p_13_67 5.017838e-04
Rpv_12_67 p_12_67 p_12_68 5.017838e-04
Rph_12_68 p_12_68 p_13_68 5.017838e-04
Rpv_12_68 p_12_68 p_12_69 5.017838e-04
Rph_12_69 p_12_69 p_13_69 5.017838e-04
Rpv_12_69 p_12_69 p_12_70 5.017838e-04
Rph_12_70 p_12_70 p_13_70 5.017838e-04
Rpv_12_70 p_12_70 p_12_71 5.017838e-04
Rph_12_71 p_12_71 p_13_71 5.017838e-04
Rph_13_0 p_13_0 p_14_0 5.017838e-04
Rpv_13_0 p_13_0 p_13_1 5.017838e-04
Rph_13_1 p_13_1 p_14_1 5.017838e-04
Rpv_13_1 p_13_1 p_13_2 5.017838e-04
Rph_13_2 p_13_2 p_14_2 5.017838e-04
Rpv_13_2 p_13_2 p_13_3 5.017838e-04
Rph_13_3 p_13_3 p_14_3 5.017838e-04
Rpv_13_3 p_13_3 p_13_4 5.017838e-04
Rph_13_4 p_13_4 p_14_4 5.017838e-04
Rpv_13_4 p_13_4 p_13_5 5.017838e-04
Rph_13_5 p_13_5 p_14_5 5.017838e-04
Rpv_13_5 p_13_5 p_13_6 5.017838e-04
Rph_13_6 p_13_6 p_14_6 5.017838e-04
Rpv_13_6 p_13_6 p_13_7 5.017838e-04
Rph_13_7 p_13_7 p_14_7 5.017838e-04
Rpv_13_7 p_13_7 p_13_8 5.017838e-04
Rph_13_8 p_13_8 p_14_8 5.017838e-04
Rpv_13_8 p_13_8 p_13_9 5.017838e-04
Rph_13_9 p_13_9 p_14_9 5.017838e-04
Rpv_13_9 p_13_9 p_13_10 5.017838e-04
Rph_13_10 p_13_10 p_14_10 5.017838e-04
Rpv_13_10 p_13_10 p_13_11 5.017838e-04
Rph_13_11 p_13_11 p_14_11 5.017838e-04
Rpv_13_11 p_13_11 p_13_12 5.017838e-04
Rph_13_12 p_13_12 p_14_12 5.017838e-04
Rpv_13_12 p_13_12 p_13_13 5.017838e-04
Rph_13_13 p_13_13 p_14_13 5.017838e-04
Rpv_13_13 p_13_13 p_13_14 5.017838e-04
Rph_13_14 p_13_14 p_14_14 5.017838e-04
Rpv_13_14 p_13_14 p_13_15 5.017838e-04
Rph_13_15 p_13_15 p_14_15 5.017838e-04
Rpv_13_15 p_13_15 p_13_16 5.017838e-04
Rph_13_16 p_13_16 p_14_16 5.017838e-04
Rpv_13_16 p_13_16 p_13_17 5.017838e-04
Rph_13_17 p_13_17 p_14_17 5.017838e-04
Rpv_13_17 p_13_17 p_13_18 5.017838e-04
Rph_13_18 p_13_18 p_14_18 5.017838e-04
Rpv_13_18 p_13_18 p_13_19 5.017838e-04
Rph_13_19 p_13_19 p_14_19 5.017838e-04
Rpv_13_19 p_13_19 p_13_20 5.017838e-04
Rph_13_20 p_13_20 p_14_20 5.017838e-04
Rpv_13_20 p_13_20 p_13_21 5.017838e-04
Rph_13_21 p_13_21 p_14_21 5.017838e-04
Rpv_13_21 p_13_21 p_13_22 5.017838e-04
Rph_13_22 p_13_22 p_14_22 5.017838e-04
Rpv_13_22 p_13_22 p_13_23 5.017838e-04
Rph_13_23 p_13_23 p_14_23 5.017838e-04
Rpv_13_23 p_13_23 p_13_24 5.017838e-04
Rph_13_24 p_13_24 p_14_24 5.017838e-04
Rpv_13_24 p_13_24 p_13_25 5.017838e-04
Rph_13_25 p_13_25 p_14_25 5.017838e-04
Rpv_13_25 p_13_25 p_13_26 5.017838e-04
Rph_13_26 p_13_26 p_14_26 5.017838e-04
Rpv_13_26 p_13_26 p_13_27 5.017838e-04
Rph_13_27 p_13_27 p_14_27 5.017838e-04
Rpv_13_27 p_13_27 p_13_28 5.017838e-04
Rph_13_28 p_13_28 p_14_28 5.017838e-04
Rpv_13_28 p_13_28 p_13_29 5.017838e-04
Rph_13_29 p_13_29 p_14_29 5.017838e-04
Rpv_13_29 p_13_29 p_13_30 5.017838e-04
Rph_13_30 p_13_30 p_14_30 5.017838e-04
Rpv_13_30 p_13_30 p_13_31 5.017838e-04
Rph_13_31 p_13_31 p_14_31 5.017838e-04
Rpv_13_31 p_13_31 p_13_32 5.017838e-04
Rph_13_32 p_13_32 p_14_32 5.017838e-04
Rpv_13_32 p_13_32 p_13_33 5.017838e-04
Rph_13_33 p_13_33 p_14_33 5.017838e-04
Rpv_13_33 p_13_33 p_13_34 5.017838e-04
Rph_13_34 p_13_34 p_14_34 5.017838e-04
Rpv_13_34 p_13_34 p_13_35 5.017838e-04
Rph_13_35 p_13_35 p_14_35 5.017838e-04
Rpv_13_35 p_13_35 p_13_36 5.017838e-04
Rph_13_36 p_13_36 p_14_36 5.017838e-04
Rpv_13_36 p_13_36 p_13_37 5.017838e-04
Rph_13_37 p_13_37 p_14_37 5.017838e-04
Rpv_13_37 p_13_37 p_13_38 5.017838e-04
Rph_13_38 p_13_38 p_14_38 5.017838e-04
Rpv_13_38 p_13_38 p_13_39 5.017838e-04
Rph_13_39 p_13_39 p_14_39 5.017838e-04
Rpv_13_39 p_13_39 p_13_40 5.017838e-04
Rph_13_40 p_13_40 p_14_40 5.017838e-04
Rpv_13_40 p_13_40 p_13_41 5.017838e-04
Rph_13_41 p_13_41 p_14_41 5.017838e-04
Rpv_13_41 p_13_41 p_13_42 5.017838e-04
Rph_13_42 p_13_42 p_14_42 5.017838e-04
Rpv_13_42 p_13_42 p_13_43 5.017838e-04
Rph_13_43 p_13_43 p_14_43 5.017838e-04
Rpv_13_43 p_13_43 p_13_44 5.017838e-04
Rph_13_44 p_13_44 p_14_44 5.017838e-04
Rpv_13_44 p_13_44 p_13_45 5.017838e-04
Rph_13_45 p_13_45 p_14_45 5.017838e-04
Rpv_13_45 p_13_45 p_13_46 5.017838e-04
Rph_13_46 p_13_46 p_14_46 5.017838e-04
Rpv_13_46 p_13_46 p_13_47 5.017838e-04
Rph_13_47 p_13_47 p_14_47 5.017838e-04
Rpv_13_47 p_13_47 p_13_48 5.017838e-04
Rph_13_48 p_13_48 p_14_48 5.017838e-04
Rpv_13_48 p_13_48 p_13_49 5.017838e-04
Rph_13_49 p_13_49 p_14_49 5.017838e-04
Rpv_13_49 p_13_49 p_13_50 5.017838e-04
Rph_13_50 p_13_50 p_14_50 5.017838e-04
Rpv_13_50 p_13_50 p_13_51 5.017838e-04
Rph_13_51 p_13_51 p_14_51 5.017838e-04
Rpv_13_51 p_13_51 p_13_52 5.017838e-04
Rph_13_52 p_13_52 p_14_52 5.017838e-04
Rpv_13_52 p_13_52 p_13_53 5.017838e-04
Rph_13_53 p_13_53 p_14_53 5.017838e-04
Rpv_13_53 p_13_53 p_13_54 5.017838e-04
Rph_13_54 p_13_54 p_14_54 5.017838e-04
Rpv_13_54 p_13_54 p_13_55 5.017838e-04
Rph_13_55 p_13_55 p_14_55 5.017838e-04
Rpv_13_55 p_13_55 p_13_56 5.017838e-04
Rph_13_56 p_13_56 p_14_56 5.017838e-04
Rpv_13_56 p_13_56 p_13_57 5.017838e-04
Rph_13_57 p_13_57 p_14_57 5.017838e-04
Rpv_13_57 p_13_57 p_13_58 5.017838e-04
Rph_13_58 p_13_58 p_14_58 5.017838e-04
Rpv_13_58 p_13_58 p_13_59 5.017838e-04
Rph_13_59 p_13_59 p_14_59 5.017838e-04
Rpv_13_59 p_13_59 p_13_60 5.017838e-04
Rph_13_60 p_13_60 p_14_60 5.017838e-04
Rpv_13_60 p_13_60 p_13_61 5.017838e-04
Rph_13_61 p_13_61 p_14_61 5.017838e-04
Rpv_13_61 p_13_61 p_13_62 5.017838e-04
Rph_13_62 p_13_62 p_14_62 5.017838e-04
Rpv_13_62 p_13_62 p_13_63 5.017838e-04
Rph_13_63 p_13_63 p_14_63 5.017838e-04
Rpv_13_63 p_13_63 p_13_64 5.017838e-04
Rph_13_64 p_13_64 p_14_64 5.017838e-04
Rpv_13_64 p_13_64 p_13_65 5.017838e-04
Rph_13_65 p_13_65 p_14_65 5.017838e-04
Rpv_13_65 p_13_65 p_13_66 5.017838e-04
Rph_13_66 p_13_66 p_14_66 5.017838e-04
Rpv_13_66 p_13_66 p_13_67 5.017838e-04
Rph_13_67 p_13_67 p_14_67 5.017838e-04
Rpv_13_67 p_13_67 p_13_68 5.017838e-04
Rph_13_68 p_13_68 p_14_68 5.017838e-04
Rpv_13_68 p_13_68 p_13_69 5.017838e-04
Rph_13_69 p_13_69 p_14_69 5.017838e-04
Rpv_13_69 p_13_69 p_13_70 5.017838e-04
Rph_13_70 p_13_70 p_14_70 5.017838e-04
Rpv_13_70 p_13_70 p_13_71 5.017838e-04
Rph_13_71 p_13_71 p_14_71 5.017838e-04
Rph_14_0 p_14_0 p_15_0 5.017838e-04
Rpv_14_0 p_14_0 p_14_1 5.017838e-04
Rph_14_1 p_14_1 p_15_1 5.017838e-04
Rpv_14_1 p_14_1 p_14_2 5.017838e-04
Rph_14_2 p_14_2 p_15_2 5.017838e-04
Rpv_14_2 p_14_2 p_14_3 5.017838e-04
Rph_14_3 p_14_3 p_15_3 5.017838e-04
Rpv_14_3 p_14_3 p_14_4 5.017838e-04
Rph_14_4 p_14_4 p_15_4 5.017838e-04
Rpv_14_4 p_14_4 p_14_5 5.017838e-04
Rph_14_5 p_14_5 p_15_5 5.017838e-04
Rpv_14_5 p_14_5 p_14_6 5.017838e-04
Rph_14_6 p_14_6 p_15_6 5.017838e-04
Rpv_14_6 p_14_6 p_14_7 5.017838e-04
Rph_14_7 p_14_7 p_15_7 5.017838e-04
Rpv_14_7 p_14_7 p_14_8 5.017838e-04
Rph_14_8 p_14_8 p_15_8 5.017838e-04
Rpv_14_8 p_14_8 p_14_9 5.017838e-04
Rph_14_9 p_14_9 p_15_9 5.017838e-04
Rpv_14_9 p_14_9 p_14_10 5.017838e-04
Rph_14_10 p_14_10 p_15_10 5.017838e-04
Rpv_14_10 p_14_10 p_14_11 5.017838e-04
Rph_14_11 p_14_11 p_15_11 5.017838e-04
Rpv_14_11 p_14_11 p_14_12 5.017838e-04
Rph_14_12 p_14_12 p_15_12 5.017838e-04
Rpv_14_12 p_14_12 p_14_13 5.017838e-04
Rph_14_13 p_14_13 p_15_13 5.017838e-04
Rpv_14_13 p_14_13 p_14_14 5.017838e-04
Rph_14_14 p_14_14 p_15_14 5.017838e-04
Rpv_14_14 p_14_14 p_14_15 5.017838e-04
Rph_14_15 p_14_15 p_15_15 5.017838e-04
Rpv_14_15 p_14_15 p_14_16 5.017838e-04
Rph_14_16 p_14_16 p_15_16 5.017838e-04
Rpv_14_16 p_14_16 p_14_17 5.017838e-04
Rph_14_17 p_14_17 p_15_17 5.017838e-04
Rpv_14_17 p_14_17 p_14_18 5.017838e-04
Rph_14_18 p_14_18 p_15_18 5.017838e-04
Rpv_14_18 p_14_18 p_14_19 5.017838e-04
Rph_14_19 p_14_19 p_15_19 5.017838e-04
Rpv_14_19 p_14_19 p_14_20 5.017838e-04
Rph_14_20 p_14_20 p_15_20 5.017838e-04
Rpv_14_20 p_14_20 p_14_21 5.017838e-04
Rph_14_21 p_14_21 p_15_21 5.017838e-04
Rpv_14_21 p_14_21 p_14_22 5.017838e-04
Rph_14_22 p_14_22 p_15_22 5.017838e-04
Rpv_14_22 p_14_22 p_14_23 5.017838e-04
Rph_14_23 p_14_23 p_15_23 5.017838e-04
Rpv_14_23 p_14_23 p_14_24 5.017838e-04
Rph_14_24 p_14_24 p_15_24 5.017838e-04
Rpv_14_24 p_14_24 p_14_25 5.017838e-04
Rph_14_25 p_14_25 p_15_25 5.017838e-04
Rpv_14_25 p_14_25 p_14_26 5.017838e-04
Rph_14_26 p_14_26 p_15_26 5.017838e-04
Rpv_14_26 p_14_26 p_14_27 5.017838e-04
Rph_14_27 p_14_27 p_15_27 5.017838e-04
Rpv_14_27 p_14_27 p_14_28 5.017838e-04
Rph_14_28 p_14_28 p_15_28 5.017838e-04
Rpv_14_28 p_14_28 p_14_29 5.017838e-04
Rph_14_29 p_14_29 p_15_29 5.017838e-04
Rpv_14_29 p_14_29 p_14_30 5.017838e-04
Rph_14_30 p_14_30 p_15_30 5.017838e-04
Rpv_14_30 p_14_30 p_14_31 5.017838e-04
Rph_14_31 p_14_31 p_15_31 5.017838e-04
Rpv_14_31 p_14_31 p_14_32 5.017838e-04
Rph_14_32 p_14_32 p_15_32 5.017838e-04
Rpv_14_32 p_14_32 p_14_33 5.017838e-04
Rph_14_33 p_14_33 p_15_33 5.017838e-04
Rpv_14_33 p_14_33 p_14_34 5.017838e-04
Rph_14_34 p_14_34 p_15_34 5.017838e-04
Rpv_14_34 p_14_34 p_14_35 5.017838e-04
Rph_14_35 p_14_35 p_15_35 5.017838e-04
Rpv_14_35 p_14_35 p_14_36 5.017838e-04
Rph_14_36 p_14_36 p_15_36 5.017838e-04
Rpv_14_36 p_14_36 p_14_37 5.017838e-04
Rph_14_37 p_14_37 p_15_37 5.017838e-04
Rpv_14_37 p_14_37 p_14_38 5.017838e-04
Rph_14_38 p_14_38 p_15_38 5.017838e-04
Rpv_14_38 p_14_38 p_14_39 5.017838e-04
Rph_14_39 p_14_39 p_15_39 5.017838e-04
Rpv_14_39 p_14_39 p_14_40 5.017838e-04
Rph_14_40 p_14_40 p_15_40 5.017838e-04
Rpv_14_40 p_14_40 p_14_41 5.017838e-04
Rph_14_41 p_14_41 p_15_41 5.017838e-04
Rpv_14_41 p_14_41 p_14_42 5.017838e-04
Rph_14_42 p_14_42 p_15_42 5.017838e-04
Rpv_14_42 p_14_42 p_14_43 5.017838e-04
Rph_14_43 p_14_43 p_15_43 5.017838e-04
Rpv_14_43 p_14_43 p_14_44 5.017838e-04
Rph_14_44 p_14_44 p_15_44 5.017838e-04
Rpv_14_44 p_14_44 p_14_45 5.017838e-04
Rph_14_45 p_14_45 p_15_45 5.017838e-04
Rpv_14_45 p_14_45 p_14_46 5.017838e-04
Rph_14_46 p_14_46 p_15_46 5.017838e-04
Rpv_14_46 p_14_46 p_14_47 5.017838e-04
Rph_14_47 p_14_47 p_15_47 5.017838e-04
Rpv_14_47 p_14_47 p_14_48 5.017838e-04
Rph_14_48 p_14_48 p_15_48 5.017838e-04
Rpv_14_48 p_14_48 p_14_49 5.017838e-04
Rph_14_49 p_14_49 p_15_49 5.017838e-04
Rpv_14_49 p_14_49 p_14_50 5.017838e-04
Rph_14_50 p_14_50 p_15_50 5.017838e-04
Rpv_14_50 p_14_50 p_14_51 5.017838e-04
Rph_14_51 p_14_51 p_15_51 5.017838e-04
Rpv_14_51 p_14_51 p_14_52 5.017838e-04
Rph_14_52 p_14_52 p_15_52 5.017838e-04
Rpv_14_52 p_14_52 p_14_53 5.017838e-04
Rph_14_53 p_14_53 p_15_53 5.017838e-04
Rpv_14_53 p_14_53 p_14_54 5.017838e-04
Rph_14_54 p_14_54 p_15_54 5.017838e-04
Rpv_14_54 p_14_54 p_14_55 5.017838e-04
Rph_14_55 p_14_55 p_15_55 5.017838e-04
Rpv_14_55 p_14_55 p_14_56 5.017838e-04
Rph_14_56 p_14_56 p_15_56 5.017838e-04
Rpv_14_56 p_14_56 p_14_57 5.017838e-04
Rph_14_57 p_14_57 p_15_57 5.017838e-04
Rpv_14_57 p_14_57 p_14_58 5.017838e-04
Rph_14_58 p_14_58 p_15_58 5.017838e-04
Rpv_14_58 p_14_58 p_14_59 5.017838e-04
Rph_14_59 p_14_59 p_15_59 5.017838e-04
Rpv_14_59 p_14_59 p_14_60 5.017838e-04
Rph_14_60 p_14_60 p_15_60 5.017838e-04
Rpv_14_60 p_14_60 p_14_61 5.017838e-04
Rph_14_61 p_14_61 p_15_61 5.017838e-04
Rpv_14_61 p_14_61 p_14_62 5.017838e-04
Rph_14_62 p_14_62 p_15_62 5.017838e-04
Rpv_14_62 p_14_62 p_14_63 5.017838e-04
Rph_14_63 p_14_63 p_15_63 5.017838e-04
Rpv_14_63 p_14_63 p_14_64 5.017838e-04
Rph_14_64 p_14_64 p_15_64 5.017838e-04
Rpv_14_64 p_14_64 p_14_65 5.017838e-04
Rph_14_65 p_14_65 p_15_65 5.017838e-04
Rpv_14_65 p_14_65 p_14_66 5.017838e-04
Rph_14_66 p_14_66 p_15_66 5.017838e-04
Rpv_14_66 p_14_66 p_14_67 5.017838e-04
Rph_14_67 p_14_67 p_15_67 5.017838e-04
Rpv_14_67 p_14_67 p_14_68 5.017838e-04
Rph_14_68 p_14_68 p_15_68 5.017838e-04
Rpv_14_68 p_14_68 p_14_69 5.017838e-04
Rph_14_69 p_14_69 p_15_69 5.017838e-04
Rpv_14_69 p_14_69 p_14_70 5.017838e-04
Rph_14_70 p_14_70 p_15_70 5.017838e-04
Rpv_14_70 p_14_70 p_14_71 5.017838e-04
Rph_14_71 p_14_71 p_15_71 5.017838e-04
Rph_15_0 p_15_0 p_16_0 5.017838e-04
Rpv_15_0 p_15_0 p_15_1 5.017838e-04
Rph_15_1 p_15_1 p_16_1 5.017838e-04
Rpv_15_1 p_15_1 p_15_2 5.017838e-04
Rph_15_2 p_15_2 p_16_2 5.017838e-04
Rpv_15_2 p_15_2 p_15_3 5.017838e-04
Rph_15_3 p_15_3 p_16_3 5.017838e-04
Rpv_15_3 p_15_3 p_15_4 5.017838e-04
Rph_15_4 p_15_4 p_16_4 5.017838e-04
Rpv_15_4 p_15_4 p_15_5 5.017838e-04
Rph_15_5 p_15_5 p_16_5 5.017838e-04
Rpv_15_5 p_15_5 p_15_6 5.017838e-04
Rph_15_6 p_15_6 p_16_6 5.017838e-04
Rpv_15_6 p_15_6 p_15_7 5.017838e-04
Rph_15_7 p_15_7 p_16_7 5.017838e-04
Rpv_15_7 p_15_7 p_15_8 5.017838e-04
Rph_15_8 p_15_8 p_16_8 5.017838e-04
Rpv_15_8 p_15_8 p_15_9 5.017838e-04
Rph_15_9 p_15_9 p_16_9 5.017838e-04
Rpv_15_9 p_15_9 p_15_10 5.017838e-04
Rph_15_10 p_15_10 p_16_10 5.017838e-04
Rpv_15_10 p_15_10 p_15_11 5.017838e-04
Rph_15_11 p_15_11 p_16_11 5.017838e-04
Rpv_15_11 p_15_11 p_15_12 5.017838e-04
Rph_15_12 p_15_12 p_16_12 5.017838e-04
Rpv_15_12 p_15_12 p_15_13 5.017838e-04
Rph_15_13 p_15_13 p_16_13 5.017838e-04
Rpv_15_13 p_15_13 p_15_14 5.017838e-04
Rph_15_14 p_15_14 p_16_14 5.017838e-04
Rpv_15_14 p_15_14 p_15_15 5.017838e-04
Rph_15_15 p_15_15 p_16_15 5.017838e-04
Rpv_15_15 p_15_15 p_15_16 5.017838e-04
Rph_15_16 p_15_16 p_16_16 5.017838e-04
Rpv_15_16 p_15_16 p_15_17 5.017838e-04
Rph_15_17 p_15_17 p_16_17 5.017838e-04
Rpv_15_17 p_15_17 p_15_18 5.017838e-04
Rph_15_18 p_15_18 p_16_18 5.017838e-04
Rpv_15_18 p_15_18 p_15_19 5.017838e-04
Rph_15_19 p_15_19 p_16_19 5.017838e-04
Rpv_15_19 p_15_19 p_15_20 5.017838e-04
Rph_15_20 p_15_20 p_16_20 5.017838e-04
Rpv_15_20 p_15_20 p_15_21 5.017838e-04
Rph_15_21 p_15_21 p_16_21 5.017838e-04
Rpv_15_21 p_15_21 p_15_22 5.017838e-04
Rph_15_22 p_15_22 p_16_22 5.017838e-04
Rpv_15_22 p_15_22 p_15_23 5.017838e-04
Rph_15_23 p_15_23 p_16_23 5.017838e-04
Rpv_15_23 p_15_23 p_15_24 5.017838e-04
Rph_15_24 p_15_24 p_16_24 5.017838e-04
Rpv_15_24 p_15_24 p_15_25 5.017838e-04
Rph_15_25 p_15_25 p_16_25 5.017838e-04
Rpv_15_25 p_15_25 p_15_26 5.017838e-04
Rph_15_26 p_15_26 p_16_26 5.017838e-04
Rpv_15_26 p_15_26 p_15_27 5.017838e-04
Rph_15_27 p_15_27 p_16_27 5.017838e-04
Rpv_15_27 p_15_27 p_15_28 5.017838e-04
Rph_15_28 p_15_28 p_16_28 5.017838e-04
Rpv_15_28 p_15_28 p_15_29 5.017838e-04
Rph_15_29 p_15_29 p_16_29 5.017838e-04
Rpv_15_29 p_15_29 p_15_30 5.017838e-04
Rph_15_30 p_15_30 p_16_30 5.017838e-04
Rpv_15_30 p_15_30 p_15_31 5.017838e-04
Rph_15_31 p_15_31 p_16_31 5.017838e-04
Rpv_15_31 p_15_31 p_15_32 5.017838e-04
Rph_15_32 p_15_32 p_16_32 5.017838e-04
Rpv_15_32 p_15_32 p_15_33 5.017838e-04
Rph_15_33 p_15_33 p_16_33 5.017838e-04
Rpv_15_33 p_15_33 p_15_34 5.017838e-04
Rph_15_34 p_15_34 p_16_34 5.017838e-04
Rpv_15_34 p_15_34 p_15_35 5.017838e-04
Rph_15_35 p_15_35 p_16_35 5.017838e-04
Rpv_15_35 p_15_35 p_15_36 5.017838e-04
Rph_15_36 p_15_36 p_16_36 5.017838e-04
Rpv_15_36 p_15_36 p_15_37 5.017838e-04
Rph_15_37 p_15_37 p_16_37 5.017838e-04
Rpv_15_37 p_15_37 p_15_38 5.017838e-04
Rph_15_38 p_15_38 p_16_38 5.017838e-04
Rpv_15_38 p_15_38 p_15_39 5.017838e-04
Rph_15_39 p_15_39 p_16_39 5.017838e-04
Rpv_15_39 p_15_39 p_15_40 5.017838e-04
Rph_15_40 p_15_40 p_16_40 5.017838e-04
Rpv_15_40 p_15_40 p_15_41 5.017838e-04
Rph_15_41 p_15_41 p_16_41 5.017838e-04
Rpv_15_41 p_15_41 p_15_42 5.017838e-04
Rph_15_42 p_15_42 p_16_42 5.017838e-04
Rpv_15_42 p_15_42 p_15_43 5.017838e-04
Rph_15_43 p_15_43 p_16_43 5.017838e-04
Rpv_15_43 p_15_43 p_15_44 5.017838e-04
Rph_15_44 p_15_44 p_16_44 5.017838e-04
Rpv_15_44 p_15_44 p_15_45 5.017838e-04
Rph_15_45 p_15_45 p_16_45 5.017838e-04
Rpv_15_45 p_15_45 p_15_46 5.017838e-04
Rph_15_46 p_15_46 p_16_46 5.017838e-04
Rpv_15_46 p_15_46 p_15_47 5.017838e-04
Rph_15_47 p_15_47 p_16_47 5.017838e-04
Rpv_15_47 p_15_47 p_15_48 5.017838e-04
Rph_15_48 p_15_48 p_16_48 5.017838e-04
Rpv_15_48 p_15_48 p_15_49 5.017838e-04
Rph_15_49 p_15_49 p_16_49 5.017838e-04
Rpv_15_49 p_15_49 p_15_50 5.017838e-04
Rph_15_50 p_15_50 p_16_50 5.017838e-04
Rpv_15_50 p_15_50 p_15_51 5.017838e-04
Rph_15_51 p_15_51 p_16_51 5.017838e-04
Rpv_15_51 p_15_51 p_15_52 5.017838e-04
Rph_15_52 p_15_52 p_16_52 5.017838e-04
Rpv_15_52 p_15_52 p_15_53 5.017838e-04
Rph_15_53 p_15_53 p_16_53 5.017838e-04
Rpv_15_53 p_15_53 p_15_54 5.017838e-04
Rph_15_54 p_15_54 p_16_54 5.017838e-04
Rpv_15_54 p_15_54 p_15_55 5.017838e-04
Rph_15_55 p_15_55 p_16_55 5.017838e-04
Rpv_15_55 p_15_55 p_15_56 5.017838e-04
Rph_15_56 p_15_56 p_16_56 5.017838e-04
Rpv_15_56 p_15_56 p_15_57 5.017838e-04
Rph_15_57 p_15_57 p_16_57 5.017838e-04
Rpv_15_57 p_15_57 p_15_58 5.017838e-04
Rph_15_58 p_15_58 p_16_58 5.017838e-04
Rpv_15_58 p_15_58 p_15_59 5.017838e-04
Rph_15_59 p_15_59 p_16_59 5.017838e-04
Rpv_15_59 p_15_59 p_15_60 5.017838e-04
Rph_15_60 p_15_60 p_16_60 5.017838e-04
Rpv_15_60 p_15_60 p_15_61 5.017838e-04
Rph_15_61 p_15_61 p_16_61 5.017838e-04
Rpv_15_61 p_15_61 p_15_62 5.017838e-04
Rph_15_62 p_15_62 p_16_62 5.017838e-04
Rpv_15_62 p_15_62 p_15_63 5.017838e-04
Rph_15_63 p_15_63 p_16_63 5.017838e-04
Rpv_15_63 p_15_63 p_15_64 5.017838e-04
Rph_15_64 p_15_64 p_16_64 5.017838e-04
Rpv_15_64 p_15_64 p_15_65 5.017838e-04
Rph_15_65 p_15_65 p_16_65 5.017838e-04
Rpv_15_65 p_15_65 p_15_66 5.017838e-04
Rph_15_66 p_15_66 p_16_66 5.017838e-04
Rpv_15_66 p_15_66 p_15_67 5.017838e-04
Rph_15_67 p_15_67 p_16_67 5.017838e-04
Rpv_15_67 p_15_67 p_15_68 5.017838e-04
Rph_15_68 p_15_68 p_16_68 5.017838e-04
Rpv_15_68 p_15_68 p_15_69 5.017838e-04
Rph_15_69 p_15_69 p_16_69 5.017838e-04
Rpv_15_69 p_15_69 p_15_70 5.017838e-04
Rph_15_70 p_15_70 p_16_70 5.017838e-04
Rpv_15_70 p_15_70 p_15_71 5.017838e-04
Rph_15_71 p_15_71 p_16_71 5.017838e-04
Rph_16_0 p_16_0 p_17_0 5.017838e-04
Rpv_16_0 p_16_0 p_16_1 5.017838e-04
Rph_16_1 p_16_1 p_17_1 5.017838e-04
Rpv_16_1 p_16_1 p_16_2 5.017838e-04
Rph_16_2 p_16_2 p_17_2 5.017838e-04
Rpv_16_2 p_16_2 p_16_3 5.017838e-04
Rph_16_3 p_16_3 p_17_3 5.017838e-04
Rpv_16_3 p_16_3 p_16_4 5.017838e-04
Rph_16_4 p_16_4 p_17_4 5.017838e-04
Rpv_16_4 p_16_4 p_16_5 5.017838e-04
Rph_16_5 p_16_5 p_17_5 5.017838e-04
Rpv_16_5 p_16_5 p_16_6 5.017838e-04
Rph_16_6 p_16_6 p_17_6 5.017838e-04
Rpv_16_6 p_16_6 p_16_7 5.017838e-04
Rph_16_7 p_16_7 p_17_7 5.017838e-04
Rpv_16_7 p_16_7 p_16_8 5.017838e-04
Rph_16_8 p_16_8 p_17_8 5.017838e-04
Rpv_16_8 p_16_8 p_16_9 5.017838e-04
Rph_16_9 p_16_9 p_17_9 5.017838e-04
Rpv_16_9 p_16_9 p_16_10 5.017838e-04
Rph_16_10 p_16_10 p_17_10 5.017838e-04
Rpv_16_10 p_16_10 p_16_11 5.017838e-04
Rph_16_11 p_16_11 p_17_11 5.017838e-04
Rpv_16_11 p_16_11 p_16_12 5.017838e-04
Rph_16_12 p_16_12 p_17_12 5.017838e-04
Rpv_16_12 p_16_12 p_16_13 5.017838e-04
Rph_16_13 p_16_13 p_17_13 5.017838e-04
Rpv_16_13 p_16_13 p_16_14 5.017838e-04
Rph_16_14 p_16_14 p_17_14 5.017838e-04
Rpv_16_14 p_16_14 p_16_15 5.017838e-04
Rph_16_15 p_16_15 p_17_15 5.017838e-04
Rpv_16_15 p_16_15 p_16_16 5.017838e-04
Rph_16_16 p_16_16 p_17_16 5.017838e-04
Rpv_16_16 p_16_16 p_16_17 5.017838e-04
Rph_16_17 p_16_17 p_17_17 5.017838e-04
Rpv_16_17 p_16_17 p_16_18 5.017838e-04
Rph_16_18 p_16_18 p_17_18 5.017838e-04
Rpv_16_18 p_16_18 p_16_19 5.017838e-04
Rph_16_19 p_16_19 p_17_19 5.017838e-04
Rpv_16_19 p_16_19 p_16_20 5.017838e-04
Rph_16_20 p_16_20 p_17_20 5.017838e-04
Rpv_16_20 p_16_20 p_16_21 5.017838e-04
Rph_16_21 p_16_21 p_17_21 5.017838e-04
Rpv_16_21 p_16_21 p_16_22 5.017838e-04
Rph_16_22 p_16_22 p_17_22 5.017838e-04
Rpv_16_22 p_16_22 p_16_23 5.017838e-04
Rph_16_23 p_16_23 p_17_23 5.017838e-04
Rpv_16_23 p_16_23 p_16_24 5.017838e-04
Rph_16_24 p_16_24 p_17_24 5.017838e-04
Rpv_16_24 p_16_24 p_16_25 5.017838e-04
Rph_16_25 p_16_25 p_17_25 5.017838e-04
Rpv_16_25 p_16_25 p_16_26 5.017838e-04
Rph_16_26 p_16_26 p_17_26 5.017838e-04
Rpv_16_26 p_16_26 p_16_27 5.017838e-04
Rph_16_27 p_16_27 p_17_27 5.017838e-04
Rpv_16_27 p_16_27 p_16_28 5.017838e-04
Rph_16_28 p_16_28 p_17_28 5.017838e-04
Rpv_16_28 p_16_28 p_16_29 5.017838e-04
Rph_16_29 p_16_29 p_17_29 5.017838e-04
Rpv_16_29 p_16_29 p_16_30 5.017838e-04
Rph_16_30 p_16_30 p_17_30 5.017838e-04
Rpv_16_30 p_16_30 p_16_31 5.017838e-04
Rph_16_31 p_16_31 p_17_31 5.017838e-04
Rpv_16_31 p_16_31 p_16_32 5.017838e-04
Rph_16_32 p_16_32 p_17_32 5.017838e-04
Rpv_16_32 p_16_32 p_16_33 5.017838e-04
Rph_16_33 p_16_33 p_17_33 5.017838e-04
Rpv_16_33 p_16_33 p_16_34 5.017838e-04
Rph_16_34 p_16_34 p_17_34 5.017838e-04
Rpv_16_34 p_16_34 p_16_35 5.017838e-04
Rph_16_35 p_16_35 p_17_35 5.017838e-04
Rpv_16_35 p_16_35 p_16_36 5.017838e-04
Rph_16_36 p_16_36 p_17_36 5.017838e-04
Rpv_16_36 p_16_36 p_16_37 5.017838e-04
Rph_16_37 p_16_37 p_17_37 5.017838e-04
Rpv_16_37 p_16_37 p_16_38 5.017838e-04
Rph_16_38 p_16_38 p_17_38 5.017838e-04
Rpv_16_38 p_16_38 p_16_39 5.017838e-04
Rph_16_39 p_16_39 p_17_39 5.017838e-04
Rpv_16_39 p_16_39 p_16_40 5.017838e-04
Rph_16_40 p_16_40 p_17_40 5.017838e-04
Rpv_16_40 p_16_40 p_16_41 5.017838e-04
Rph_16_41 p_16_41 p_17_41 5.017838e-04
Rpv_16_41 p_16_41 p_16_42 5.017838e-04
Rph_16_42 p_16_42 p_17_42 5.017838e-04
Rpv_16_42 p_16_42 p_16_43 5.017838e-04
Rph_16_43 p_16_43 p_17_43 5.017838e-04
Rpv_16_43 p_16_43 p_16_44 5.017838e-04
Rph_16_44 p_16_44 p_17_44 5.017838e-04
Rpv_16_44 p_16_44 p_16_45 5.017838e-04
Rph_16_45 p_16_45 p_17_45 5.017838e-04
Rpv_16_45 p_16_45 p_16_46 5.017838e-04
Rph_16_46 p_16_46 p_17_46 5.017838e-04
Rpv_16_46 p_16_46 p_16_47 5.017838e-04
Rph_16_47 p_16_47 p_17_47 5.017838e-04
Rpv_16_47 p_16_47 p_16_48 5.017838e-04
Rph_16_48 p_16_48 p_17_48 5.017838e-04
Rpv_16_48 p_16_48 p_16_49 5.017838e-04
Rph_16_49 p_16_49 p_17_49 5.017838e-04
Rpv_16_49 p_16_49 p_16_50 5.017838e-04
Rph_16_50 p_16_50 p_17_50 5.017838e-04
Rpv_16_50 p_16_50 p_16_51 5.017838e-04
Rph_16_51 p_16_51 p_17_51 5.017838e-04
Rpv_16_51 p_16_51 p_16_52 5.017838e-04
Rph_16_52 p_16_52 p_17_52 5.017838e-04
Rpv_16_52 p_16_52 p_16_53 5.017838e-04
Rph_16_53 p_16_53 p_17_53 5.017838e-04
Rpv_16_53 p_16_53 p_16_54 5.017838e-04
Rph_16_54 p_16_54 p_17_54 5.017838e-04
Rpv_16_54 p_16_54 p_16_55 5.017838e-04
Rph_16_55 p_16_55 p_17_55 5.017838e-04
Rpv_16_55 p_16_55 p_16_56 5.017838e-04
Rph_16_56 p_16_56 p_17_56 5.017838e-04
Rpv_16_56 p_16_56 p_16_57 5.017838e-04
Rph_16_57 p_16_57 p_17_57 5.017838e-04
Rpv_16_57 p_16_57 p_16_58 5.017838e-04
Rph_16_58 p_16_58 p_17_58 5.017838e-04
Rpv_16_58 p_16_58 p_16_59 5.017838e-04
Rph_16_59 p_16_59 p_17_59 5.017838e-04
Rpv_16_59 p_16_59 p_16_60 5.017838e-04
Rph_16_60 p_16_60 p_17_60 5.017838e-04
Rpv_16_60 p_16_60 p_16_61 5.017838e-04
Rph_16_61 p_16_61 p_17_61 5.017838e-04
Rpv_16_61 p_16_61 p_16_62 5.017838e-04
Rph_16_62 p_16_62 p_17_62 5.017838e-04
Rpv_16_62 p_16_62 p_16_63 5.017838e-04
Rph_16_63 p_16_63 p_17_63 5.017838e-04
Rpv_16_63 p_16_63 p_16_64 5.017838e-04
Rph_16_64 p_16_64 p_17_64 5.017838e-04
Rpv_16_64 p_16_64 p_16_65 5.017838e-04
Rph_16_65 p_16_65 p_17_65 5.017838e-04
Rpv_16_65 p_16_65 p_16_66 5.017838e-04
Rph_16_66 p_16_66 p_17_66 5.017838e-04
Rpv_16_66 p_16_66 p_16_67 5.017838e-04
Rph_16_67 p_16_67 p_17_67 5.017838e-04
Rpv_16_67 p_16_67 p_16_68 5.017838e-04
Rph_16_68 p_16_68 p_17_68 5.017838e-04
Rpv_16_68 p_16_68 p_16_69 5.017838e-04
Rph_16_69 p_16_69 p_17_69 5.017838e-04
Rpv_16_69 p_16_69 p_16_70 5.017838e-04
Rph_16_70 p_16_70 p_17_70 5.017838e-04
Rpv_16_70 p_16_70 p_16_71 5.017838e-04
Rph_16_71 p_16_71 p_17_71 5.017838e-04
Rph_17_0 p_17_0 p_18_0 5.017838e-04
Rpv_17_0 p_17_0 p_17_1 5.017838e-04
Rph_17_1 p_17_1 p_18_1 5.017838e-04
Rpv_17_1 p_17_1 p_17_2 5.017838e-04
Rph_17_2 p_17_2 p_18_2 5.017838e-04
Rpv_17_2 p_17_2 p_17_3 5.017838e-04
Rph_17_3 p_17_3 p_18_3 5.017838e-04
Rpv_17_3 p_17_3 p_17_4 5.017838e-04
Rph_17_4 p_17_4 p_18_4 5.017838e-04
Rpv_17_4 p_17_4 p_17_5 5.017838e-04
Rph_17_5 p_17_5 p_18_5 5.017838e-04
Rpv_17_5 p_17_5 p_17_6 5.017838e-04
Rph_17_6 p_17_6 p_18_6 5.017838e-04
Rpv_17_6 p_17_6 p_17_7 5.017838e-04
Rph_17_7 p_17_7 p_18_7 5.017838e-04
Rpv_17_7 p_17_7 p_17_8 5.017838e-04
Rph_17_8 p_17_8 p_18_8 5.017838e-04
Rpv_17_8 p_17_8 p_17_9 5.017838e-04
Rph_17_9 p_17_9 p_18_9 5.017838e-04
Rpv_17_9 p_17_9 p_17_10 5.017838e-04
Rph_17_10 p_17_10 p_18_10 5.017838e-04
Rpv_17_10 p_17_10 p_17_11 5.017838e-04
Rph_17_11 p_17_11 p_18_11 5.017838e-04
Rpv_17_11 p_17_11 p_17_12 5.017838e-04
Rph_17_12 p_17_12 p_18_12 5.017838e-04
Rpv_17_12 p_17_12 p_17_13 5.017838e-04
Rph_17_13 p_17_13 p_18_13 5.017838e-04
Rpv_17_13 p_17_13 p_17_14 5.017838e-04
Rph_17_14 p_17_14 p_18_14 5.017838e-04
Rpv_17_14 p_17_14 p_17_15 5.017838e-04
Rph_17_15 p_17_15 p_18_15 5.017838e-04
Rpv_17_15 p_17_15 p_17_16 5.017838e-04
Rph_17_16 p_17_16 p_18_16 5.017838e-04
Rpv_17_16 p_17_16 p_17_17 5.017838e-04
Rph_17_17 p_17_17 p_18_17 5.017838e-04
Rpv_17_17 p_17_17 p_17_18 5.017838e-04
Rph_17_18 p_17_18 p_18_18 5.017838e-04
Rpv_17_18 p_17_18 p_17_19 5.017838e-04
Rph_17_19 p_17_19 p_18_19 5.017838e-04
Rpv_17_19 p_17_19 p_17_20 5.017838e-04
Rph_17_20 p_17_20 p_18_20 5.017838e-04
Rpv_17_20 p_17_20 p_17_21 5.017838e-04
Rph_17_21 p_17_21 p_18_21 5.017838e-04
Rpv_17_21 p_17_21 p_17_22 5.017838e-04
Rph_17_22 p_17_22 p_18_22 5.017838e-04
Rpv_17_22 p_17_22 p_17_23 5.017838e-04
Rph_17_23 p_17_23 p_18_23 5.017838e-04
Rpv_17_23 p_17_23 p_17_24 5.017838e-04
Rph_17_24 p_17_24 p_18_24 5.017838e-04
Rpv_17_24 p_17_24 p_17_25 5.017838e-04
Rph_17_25 p_17_25 p_18_25 5.017838e-04
Rpv_17_25 p_17_25 p_17_26 5.017838e-04
Rph_17_26 p_17_26 p_18_26 5.017838e-04
Rpv_17_26 p_17_26 p_17_27 5.017838e-04
Rph_17_27 p_17_27 p_18_27 5.017838e-04
Rpv_17_27 p_17_27 p_17_28 5.017838e-04
Rph_17_28 p_17_28 p_18_28 5.017838e-04
Rpv_17_28 p_17_28 p_17_29 5.017838e-04
Rph_17_29 p_17_29 p_18_29 5.017838e-04
Rpv_17_29 p_17_29 p_17_30 5.017838e-04
Rph_17_30 p_17_30 p_18_30 5.017838e-04
Rpv_17_30 p_17_30 p_17_31 5.017838e-04
Rph_17_31 p_17_31 p_18_31 5.017838e-04
Rpv_17_31 p_17_31 p_17_32 5.017838e-04
Rph_17_32 p_17_32 p_18_32 5.017838e-04
Rpv_17_32 p_17_32 p_17_33 5.017838e-04
Rph_17_33 p_17_33 p_18_33 5.017838e-04
Rpv_17_33 p_17_33 p_17_34 5.017838e-04
Rph_17_34 p_17_34 p_18_34 5.017838e-04
Rpv_17_34 p_17_34 p_17_35 5.017838e-04
Rph_17_35 p_17_35 p_18_35 5.017838e-04
Rpv_17_35 p_17_35 p_17_36 5.017838e-04
Rph_17_36 p_17_36 p_18_36 5.017838e-04
Rpv_17_36 p_17_36 p_17_37 5.017838e-04
Rph_17_37 p_17_37 p_18_37 5.017838e-04
Rpv_17_37 p_17_37 p_17_38 5.017838e-04
Rph_17_38 p_17_38 p_18_38 5.017838e-04
Rpv_17_38 p_17_38 p_17_39 5.017838e-04
Rph_17_39 p_17_39 p_18_39 5.017838e-04
Rpv_17_39 p_17_39 p_17_40 5.017838e-04
Rph_17_40 p_17_40 p_18_40 5.017838e-04
Rpv_17_40 p_17_40 p_17_41 5.017838e-04
Rph_17_41 p_17_41 p_18_41 5.017838e-04
Rpv_17_41 p_17_41 p_17_42 5.017838e-04
Rph_17_42 p_17_42 p_18_42 5.017838e-04
Rpv_17_42 p_17_42 p_17_43 5.017838e-04
Rph_17_43 p_17_43 p_18_43 5.017838e-04
Rpv_17_43 p_17_43 p_17_44 5.017838e-04
Rph_17_44 p_17_44 p_18_44 5.017838e-04
Rpv_17_44 p_17_44 p_17_45 5.017838e-04
Rph_17_45 p_17_45 p_18_45 5.017838e-04
Rpv_17_45 p_17_45 p_17_46 5.017838e-04
Rph_17_46 p_17_46 p_18_46 5.017838e-04
Rpv_17_46 p_17_46 p_17_47 5.017838e-04
Rph_17_47 p_17_47 p_18_47 5.017838e-04
Rpv_17_47 p_17_47 p_17_48 5.017838e-04
Rph_17_48 p_17_48 p_18_48 5.017838e-04
Rpv_17_48 p_17_48 p_17_49 5.017838e-04
Rph_17_49 p_17_49 p_18_49 5.017838e-04
Rpv_17_49 p_17_49 p_17_50 5.017838e-04
Rph_17_50 p_17_50 p_18_50 5.017838e-04
Rpv_17_50 p_17_50 p_17_51 5.017838e-04
Rph_17_51 p_17_51 p_18_51 5.017838e-04
Rpv_17_51 p_17_51 p_17_52 5.017838e-04
Rph_17_52 p_17_52 p_18_52 5.017838e-04
Rpv_17_52 p_17_52 p_17_53 5.017838e-04
Rph_17_53 p_17_53 p_18_53 5.017838e-04
Rpv_17_53 p_17_53 p_17_54 5.017838e-04
Rph_17_54 p_17_54 p_18_54 5.017838e-04
Rpv_17_54 p_17_54 p_17_55 5.017838e-04
Rph_17_55 p_17_55 p_18_55 5.017838e-04
Rpv_17_55 p_17_55 p_17_56 5.017838e-04
Rph_17_56 p_17_56 p_18_56 5.017838e-04
Rpv_17_56 p_17_56 p_17_57 5.017838e-04
Rph_17_57 p_17_57 p_18_57 5.017838e-04
Rpv_17_57 p_17_57 p_17_58 5.017838e-04
Rph_17_58 p_17_58 p_18_58 5.017838e-04
Rpv_17_58 p_17_58 p_17_59 5.017838e-04
Rph_17_59 p_17_59 p_18_59 5.017838e-04
Rpv_17_59 p_17_59 p_17_60 5.017838e-04
Rph_17_60 p_17_60 p_18_60 5.017838e-04
Rpv_17_60 p_17_60 p_17_61 5.017838e-04
Rph_17_61 p_17_61 p_18_61 5.017838e-04
Rpv_17_61 p_17_61 p_17_62 5.017838e-04
Rph_17_62 p_17_62 p_18_62 5.017838e-04
Rpv_17_62 p_17_62 p_17_63 5.017838e-04
Rph_17_63 p_17_63 p_18_63 5.017838e-04
Rpv_17_63 p_17_63 p_17_64 5.017838e-04
Rph_17_64 p_17_64 p_18_64 5.017838e-04
Rpv_17_64 p_17_64 p_17_65 5.017838e-04
Rph_17_65 p_17_65 p_18_65 5.017838e-04
Rpv_17_65 p_17_65 p_17_66 5.017838e-04
Rph_17_66 p_17_66 p_18_66 5.017838e-04
Rpv_17_66 p_17_66 p_17_67 5.017838e-04
Rph_17_67 p_17_67 p_18_67 5.017838e-04
Rpv_17_67 p_17_67 p_17_68 5.017838e-04
Rph_17_68 p_17_68 p_18_68 5.017838e-04
Rpv_17_68 p_17_68 p_17_69 5.017838e-04
Rph_17_69 p_17_69 p_18_69 5.017838e-04
Rpv_17_69 p_17_69 p_17_70 5.017838e-04
Rph_17_70 p_17_70 p_18_70 5.017838e-04
Rpv_17_70 p_17_70 p_17_71 5.017838e-04
Rph_17_71 p_17_71 p_18_71 5.017838e-04
Rph_18_0 p_18_0 p_19_0 5.017838e-04
Rpv_18_0 p_18_0 p_18_1 5.017838e-04
Rph_18_1 p_18_1 p_19_1 5.017838e-04
Rpv_18_1 p_18_1 p_18_2 5.017838e-04
Rph_18_2 p_18_2 p_19_2 5.017838e-04
Rpv_18_2 p_18_2 p_18_3 5.017838e-04
Rph_18_3 p_18_3 p_19_3 5.017838e-04
Rpv_18_3 p_18_3 p_18_4 5.017838e-04
Rph_18_4 p_18_4 p_19_4 5.017838e-04
Rpv_18_4 p_18_4 p_18_5 5.017838e-04
Rph_18_5 p_18_5 p_19_5 5.017838e-04
Rpv_18_5 p_18_5 p_18_6 5.017838e-04
Rph_18_6 p_18_6 p_19_6 5.017838e-04
Rpv_18_6 p_18_6 p_18_7 5.017838e-04
Rph_18_7 p_18_7 p_19_7 5.017838e-04
Rpv_18_7 p_18_7 p_18_8 5.017838e-04
Rph_18_8 p_18_8 p_19_8 5.017838e-04
Rpv_18_8 p_18_8 p_18_9 5.017838e-04
Rph_18_9 p_18_9 p_19_9 5.017838e-04
Rpv_18_9 p_18_9 p_18_10 5.017838e-04
Rph_18_10 p_18_10 p_19_10 5.017838e-04
Rpv_18_10 p_18_10 p_18_11 5.017838e-04
Rph_18_11 p_18_11 p_19_11 5.017838e-04
Rpv_18_11 p_18_11 p_18_12 5.017838e-04
Rph_18_12 p_18_12 p_19_12 5.017838e-04
Rpv_18_12 p_18_12 p_18_13 5.017838e-04
Rph_18_13 p_18_13 p_19_13 5.017838e-04
Rpv_18_13 p_18_13 p_18_14 5.017838e-04
Rph_18_14 p_18_14 p_19_14 5.017838e-04
Rpv_18_14 p_18_14 p_18_15 5.017838e-04
Rph_18_15 p_18_15 p_19_15 5.017838e-04
Rpv_18_15 p_18_15 p_18_16 5.017838e-04
Rph_18_16 p_18_16 p_19_16 5.017838e-04
Rpv_18_16 p_18_16 p_18_17 5.017838e-04
Rph_18_17 p_18_17 p_19_17 5.017838e-04
Rpv_18_17 p_18_17 p_18_18 5.017838e-04
Rph_18_18 p_18_18 p_19_18 5.017838e-04
Rpv_18_18 p_18_18 p_18_19 5.017838e-04
Rph_18_19 p_18_19 p_19_19 5.017838e-04
Rpv_18_19 p_18_19 p_18_20 5.017838e-04
Rph_18_20 p_18_20 p_19_20 5.017838e-04
Rpv_18_20 p_18_20 p_18_21 5.017838e-04
Rph_18_21 p_18_21 p_19_21 5.017838e-04
Rpv_18_21 p_18_21 p_18_22 5.017838e-04
Rph_18_22 p_18_22 p_19_22 5.017838e-04
Rpv_18_22 p_18_22 p_18_23 5.017838e-04
Rph_18_23 p_18_23 p_19_23 5.017838e-04
Rpv_18_23 p_18_23 p_18_24 5.017838e-04
Rph_18_24 p_18_24 p_19_24 5.017838e-04
Rpv_18_24 p_18_24 p_18_25 5.017838e-04
Rph_18_25 p_18_25 p_19_25 5.017838e-04
Rpv_18_25 p_18_25 p_18_26 5.017838e-04
Rph_18_26 p_18_26 p_19_26 5.017838e-04
Rpv_18_26 p_18_26 p_18_27 5.017838e-04
Rph_18_27 p_18_27 p_19_27 5.017838e-04
Rpv_18_27 p_18_27 p_18_28 5.017838e-04
Rph_18_28 p_18_28 p_19_28 5.017838e-04
Rpv_18_28 p_18_28 p_18_29 5.017838e-04
Rph_18_29 p_18_29 p_19_29 5.017838e-04
Rpv_18_29 p_18_29 p_18_30 5.017838e-04
Rph_18_30 p_18_30 p_19_30 5.017838e-04
Rpv_18_30 p_18_30 p_18_31 5.017838e-04
Rph_18_31 p_18_31 p_19_31 5.017838e-04
Rpv_18_31 p_18_31 p_18_32 5.017838e-04
Rph_18_32 p_18_32 p_19_32 5.017838e-04
Rpv_18_32 p_18_32 p_18_33 5.017838e-04
Rph_18_33 p_18_33 p_19_33 5.017838e-04
Rpv_18_33 p_18_33 p_18_34 5.017838e-04
Rph_18_34 p_18_34 p_19_34 5.017838e-04
Rpv_18_34 p_18_34 p_18_35 5.017838e-04
Rph_18_35 p_18_35 p_19_35 5.017838e-04
Rpv_18_35 p_18_35 p_18_36 5.017838e-04
Rph_18_36 p_18_36 p_19_36 5.017838e-04
Rpv_18_36 p_18_36 p_18_37 5.017838e-04
Rph_18_37 p_18_37 p_19_37 5.017838e-04
Rpv_18_37 p_18_37 p_18_38 5.017838e-04
Rph_18_38 p_18_38 p_19_38 5.017838e-04
Rpv_18_38 p_18_38 p_18_39 5.017838e-04
Rph_18_39 p_18_39 p_19_39 5.017838e-04
Rpv_18_39 p_18_39 p_18_40 5.017838e-04
Rph_18_40 p_18_40 p_19_40 5.017838e-04
Rpv_18_40 p_18_40 p_18_41 5.017838e-04
Rph_18_41 p_18_41 p_19_41 5.017838e-04
Rpv_18_41 p_18_41 p_18_42 5.017838e-04
Rph_18_42 p_18_42 p_19_42 5.017838e-04
Rpv_18_42 p_18_42 p_18_43 5.017838e-04
Rph_18_43 p_18_43 p_19_43 5.017838e-04
Rpv_18_43 p_18_43 p_18_44 5.017838e-04
Rph_18_44 p_18_44 p_19_44 5.017838e-04
Rpv_18_44 p_18_44 p_18_45 5.017838e-04
Rph_18_45 p_18_45 p_19_45 5.017838e-04
Rpv_18_45 p_18_45 p_18_46 5.017838e-04
Rph_18_46 p_18_46 p_19_46 5.017838e-04
Rpv_18_46 p_18_46 p_18_47 5.017838e-04
Rph_18_47 p_18_47 p_19_47 5.017838e-04
Rpv_18_47 p_18_47 p_18_48 5.017838e-04
Rph_18_48 p_18_48 p_19_48 5.017838e-04
Rpv_18_48 p_18_48 p_18_49 5.017838e-04
Rph_18_49 p_18_49 p_19_49 5.017838e-04
Rpv_18_49 p_18_49 p_18_50 5.017838e-04
Rph_18_50 p_18_50 p_19_50 5.017838e-04
Rpv_18_50 p_18_50 p_18_51 5.017838e-04
Rph_18_51 p_18_51 p_19_51 5.017838e-04
Rpv_18_51 p_18_51 p_18_52 5.017838e-04
Rph_18_52 p_18_52 p_19_52 5.017838e-04
Rpv_18_52 p_18_52 p_18_53 5.017838e-04
Rph_18_53 p_18_53 p_19_53 5.017838e-04
Rpv_18_53 p_18_53 p_18_54 5.017838e-04
Rph_18_54 p_18_54 p_19_54 5.017838e-04
Rpv_18_54 p_18_54 p_18_55 5.017838e-04
Rph_18_55 p_18_55 p_19_55 5.017838e-04
Rpv_18_55 p_18_55 p_18_56 5.017838e-04
Rph_18_56 p_18_56 p_19_56 5.017838e-04
Rpv_18_56 p_18_56 p_18_57 5.017838e-04
Rph_18_57 p_18_57 p_19_57 5.017838e-04
Rpv_18_57 p_18_57 p_18_58 5.017838e-04
Rph_18_58 p_18_58 p_19_58 5.017838e-04
Rpv_18_58 p_18_58 p_18_59 5.017838e-04
Rph_18_59 p_18_59 p_19_59 5.017838e-04
Rpv_18_59 p_18_59 p_18_60 5.017838e-04
Rph_18_60 p_18_60 p_19_60 5.017838e-04
Rpv_18_60 p_18_60 p_18_61 5.017838e-04
Rph_18_61 p_18_61 p_19_61 5.017838e-04
Rpv_18_61 p_18_61 p_18_62 5.017838e-04
Rph_18_62 p_18_62 p_19_62 5.017838e-04
Rpv_18_62 p_18_62 p_18_63 5.017838e-04
Rph_18_63 p_18_63 p_19_63 5.017838e-04
Rpv_18_63 p_18_63 p_18_64 5.017838e-04
Rph_18_64 p_18_64 p_19_64 5.017838e-04
Rpv_18_64 p_18_64 p_18_65 5.017838e-04
Rph_18_65 p_18_65 p_19_65 5.017838e-04
Rpv_18_65 p_18_65 p_18_66 5.017838e-04
Rph_18_66 p_18_66 p_19_66 5.017838e-04
Rpv_18_66 p_18_66 p_18_67 5.017838e-04
Rph_18_67 p_18_67 p_19_67 5.017838e-04
Rpv_18_67 p_18_67 p_18_68 5.017838e-04
Rph_18_68 p_18_68 p_19_68 5.017838e-04
Rpv_18_68 p_18_68 p_18_69 5.017838e-04
Rph_18_69 p_18_69 p_19_69 5.017838e-04
Rpv_18_69 p_18_69 p_18_70 5.017838e-04
Rph_18_70 p_18_70 p_19_70 5.017838e-04
Rpv_18_70 p_18_70 p_18_71 5.017838e-04
Rph_18_71 p_18_71 p_19_71 5.017838e-04
Rph_19_0 p_19_0 p_20_0 5.017838e-04
Rpv_19_0 p_19_0 p_19_1 5.017838e-04
Rph_19_1 p_19_1 p_20_1 5.017838e-04
Rpv_19_1 p_19_1 p_19_2 5.017838e-04
Rph_19_2 p_19_2 p_20_2 5.017838e-04
Rpv_19_2 p_19_2 p_19_3 5.017838e-04
Rph_19_3 p_19_3 p_20_3 5.017838e-04
Rpv_19_3 p_19_3 p_19_4 5.017838e-04
Rph_19_4 p_19_4 p_20_4 5.017838e-04
Rpv_19_4 p_19_4 p_19_5 5.017838e-04
Rph_19_5 p_19_5 p_20_5 5.017838e-04
Rpv_19_5 p_19_5 p_19_6 5.017838e-04
Rph_19_6 p_19_6 p_20_6 5.017838e-04
Rpv_19_6 p_19_6 p_19_7 5.017838e-04
Rph_19_7 p_19_7 p_20_7 5.017838e-04
Rpv_19_7 p_19_7 p_19_8 5.017838e-04
Rph_19_8 p_19_8 p_20_8 5.017838e-04
Rpv_19_8 p_19_8 p_19_9 5.017838e-04
Rph_19_9 p_19_9 p_20_9 5.017838e-04
Rpv_19_9 p_19_9 p_19_10 5.017838e-04
Rph_19_10 p_19_10 p_20_10 5.017838e-04
Rpv_19_10 p_19_10 p_19_11 5.017838e-04
Rph_19_11 p_19_11 p_20_11 5.017838e-04
Rpv_19_11 p_19_11 p_19_12 5.017838e-04
Rph_19_12 p_19_12 p_20_12 5.017838e-04
Rpv_19_12 p_19_12 p_19_13 5.017838e-04
Rph_19_13 p_19_13 p_20_13 5.017838e-04
Rpv_19_13 p_19_13 p_19_14 5.017838e-04
Rph_19_14 p_19_14 p_20_14 5.017838e-04
Rpv_19_14 p_19_14 p_19_15 5.017838e-04
Rph_19_15 p_19_15 p_20_15 5.017838e-04
Rpv_19_15 p_19_15 p_19_16 5.017838e-04
Rph_19_16 p_19_16 p_20_16 5.017838e-04
Rpv_19_16 p_19_16 p_19_17 5.017838e-04
Rph_19_17 p_19_17 p_20_17 5.017838e-04
Rpv_19_17 p_19_17 p_19_18 5.017838e-04
Rph_19_18 p_19_18 p_20_18 5.017838e-04
Rpv_19_18 p_19_18 p_19_19 5.017838e-04
Rph_19_19 p_19_19 p_20_19 5.017838e-04
Rpv_19_19 p_19_19 p_19_20 5.017838e-04
Rph_19_20 p_19_20 p_20_20 5.017838e-04
Rpv_19_20 p_19_20 p_19_21 5.017838e-04
Rph_19_21 p_19_21 p_20_21 5.017838e-04
Rpv_19_21 p_19_21 p_19_22 5.017838e-04
Rph_19_22 p_19_22 p_20_22 5.017838e-04
Rpv_19_22 p_19_22 p_19_23 5.017838e-04
Rph_19_23 p_19_23 p_20_23 5.017838e-04
Rpv_19_23 p_19_23 p_19_24 5.017838e-04
Rph_19_24 p_19_24 p_20_24 5.017838e-04
Rpv_19_24 p_19_24 p_19_25 5.017838e-04
Rph_19_25 p_19_25 p_20_25 5.017838e-04
Rpv_19_25 p_19_25 p_19_26 5.017838e-04
Rph_19_26 p_19_26 p_20_26 5.017838e-04
Rpv_19_26 p_19_26 p_19_27 5.017838e-04
Rph_19_27 p_19_27 p_20_27 5.017838e-04
Rpv_19_27 p_19_27 p_19_28 5.017838e-04
Rph_19_28 p_19_28 p_20_28 5.017838e-04
Rpv_19_28 p_19_28 p_19_29 5.017838e-04
Rph_19_29 p_19_29 p_20_29 5.017838e-04
Rpv_19_29 p_19_29 p_19_30 5.017838e-04
Rph_19_30 p_19_30 p_20_30 5.017838e-04
Rpv_19_30 p_19_30 p_19_31 5.017838e-04
Rph_19_31 p_19_31 p_20_31 5.017838e-04
Rpv_19_31 p_19_31 p_19_32 5.017838e-04
Rph_19_32 p_19_32 p_20_32 5.017838e-04
Rpv_19_32 p_19_32 p_19_33 5.017838e-04
Rph_19_33 p_19_33 p_20_33 5.017838e-04
Rpv_19_33 p_19_33 p_19_34 5.017838e-04
Rph_19_34 p_19_34 p_20_34 5.017838e-04
Rpv_19_34 p_19_34 p_19_35 5.017838e-04
Rph_19_35 p_19_35 p_20_35 5.017838e-04
Rpv_19_35 p_19_35 p_19_36 5.017838e-04
Rph_19_36 p_19_36 p_20_36 5.017838e-04
Rpv_19_36 p_19_36 p_19_37 5.017838e-04
Rph_19_37 p_19_37 p_20_37 5.017838e-04
Rpv_19_37 p_19_37 p_19_38 5.017838e-04
Rph_19_38 p_19_38 p_20_38 5.017838e-04
Rpv_19_38 p_19_38 p_19_39 5.017838e-04
Rph_19_39 p_19_39 p_20_39 5.017838e-04
Rpv_19_39 p_19_39 p_19_40 5.017838e-04
Rph_19_40 p_19_40 p_20_40 5.017838e-04
Rpv_19_40 p_19_40 p_19_41 5.017838e-04
Rph_19_41 p_19_41 p_20_41 5.017838e-04
Rpv_19_41 p_19_41 p_19_42 5.017838e-04
Rph_19_42 p_19_42 p_20_42 5.017838e-04
Rpv_19_42 p_19_42 p_19_43 5.017838e-04
Rph_19_43 p_19_43 p_20_43 5.017838e-04
Rpv_19_43 p_19_43 p_19_44 5.017838e-04
Rph_19_44 p_19_44 p_20_44 5.017838e-04
Rpv_19_44 p_19_44 p_19_45 5.017838e-04
Rph_19_45 p_19_45 p_20_45 5.017838e-04
Rpv_19_45 p_19_45 p_19_46 5.017838e-04
Rph_19_46 p_19_46 p_20_46 5.017838e-04
Rpv_19_46 p_19_46 p_19_47 5.017838e-04
Rph_19_47 p_19_47 p_20_47 5.017838e-04
Rpv_19_47 p_19_47 p_19_48 5.017838e-04
Rph_19_48 p_19_48 p_20_48 5.017838e-04
Rpv_19_48 p_19_48 p_19_49 5.017838e-04
Rph_19_49 p_19_49 p_20_49 5.017838e-04
Rpv_19_49 p_19_49 p_19_50 5.017838e-04
Rph_19_50 p_19_50 p_20_50 5.017838e-04
Rpv_19_50 p_19_50 p_19_51 5.017838e-04
Rph_19_51 p_19_51 p_20_51 5.017838e-04
Rpv_19_51 p_19_51 p_19_52 5.017838e-04
Rph_19_52 p_19_52 p_20_52 5.017838e-04
Rpv_19_52 p_19_52 p_19_53 5.017838e-04
Rph_19_53 p_19_53 p_20_53 5.017838e-04
Rpv_19_53 p_19_53 p_19_54 5.017838e-04
Rph_19_54 p_19_54 p_20_54 5.017838e-04
Rpv_19_54 p_19_54 p_19_55 5.017838e-04
Rph_19_55 p_19_55 p_20_55 5.017838e-04
Rpv_19_55 p_19_55 p_19_56 5.017838e-04
Rph_19_56 p_19_56 p_20_56 5.017838e-04
Rpv_19_56 p_19_56 p_19_57 5.017838e-04
Rph_19_57 p_19_57 p_20_57 5.017838e-04
Rpv_19_57 p_19_57 p_19_58 5.017838e-04
Rph_19_58 p_19_58 p_20_58 5.017838e-04
Rpv_19_58 p_19_58 p_19_59 5.017838e-04
Rph_19_59 p_19_59 p_20_59 5.017838e-04
Rpv_19_59 p_19_59 p_19_60 5.017838e-04
Rph_19_60 p_19_60 p_20_60 5.017838e-04
Rpv_19_60 p_19_60 p_19_61 5.017838e-04
Rph_19_61 p_19_61 p_20_61 5.017838e-04
Rpv_19_61 p_19_61 p_19_62 5.017838e-04
Rph_19_62 p_19_62 p_20_62 5.017838e-04
Rpv_19_62 p_19_62 p_19_63 5.017838e-04
Rph_19_63 p_19_63 p_20_63 5.017838e-04
Rpv_19_63 p_19_63 p_19_64 5.017838e-04
Rph_19_64 p_19_64 p_20_64 5.017838e-04
Rpv_19_64 p_19_64 p_19_65 5.017838e-04
Rph_19_65 p_19_65 p_20_65 5.017838e-04
Rpv_19_65 p_19_65 p_19_66 5.017838e-04
Rph_19_66 p_19_66 p_20_66 5.017838e-04
Rpv_19_66 p_19_66 p_19_67 5.017838e-04
Rph_19_67 p_19_67 p_20_67 5.017838e-04
Rpv_19_67 p_19_67 p_19_68 5.017838e-04
Rph_19_68 p_19_68 p_20_68 5.017838e-04
Rpv_19_68 p_19_68 p_19_69 5.017838e-04
Rph_19_69 p_19_69 p_20_69 5.017838e-04
Rpv_19_69 p_19_69 p_19_70 5.017838e-04
Rph_19_70 p_19_70 p_20_70 5.017838e-04
Rpv_19_70 p_19_70 p_19_71 5.017838e-04
Rph_19_71 p_19_71 p_20_71 5.017838e-04
Rph_20_0 p_20_0 p_21_0 5.017838e-04
Rpv_20_0 p_20_0 p_20_1 5.017838e-04
Rph_20_1 p_20_1 p_21_1 5.017838e-04
Rpv_20_1 p_20_1 p_20_2 5.017838e-04
Rph_20_2 p_20_2 p_21_2 5.017838e-04
Rpv_20_2 p_20_2 p_20_3 5.017838e-04
Rph_20_3 p_20_3 p_21_3 5.017838e-04
Rpv_20_3 p_20_3 p_20_4 5.017838e-04
Rph_20_4 p_20_4 p_21_4 5.017838e-04
Rpv_20_4 p_20_4 p_20_5 5.017838e-04
Rph_20_5 p_20_5 p_21_5 5.017838e-04
Rpv_20_5 p_20_5 p_20_6 5.017838e-04
Rph_20_6 p_20_6 p_21_6 5.017838e-04
Rpv_20_6 p_20_6 p_20_7 5.017838e-04
Rph_20_7 p_20_7 p_21_7 5.017838e-04
Rpv_20_7 p_20_7 p_20_8 5.017838e-04
Rph_20_8 p_20_8 p_21_8 5.017838e-04
Rpv_20_8 p_20_8 p_20_9 5.017838e-04
Rph_20_9 p_20_9 p_21_9 5.017838e-04
Rpv_20_9 p_20_9 p_20_10 5.017838e-04
Rph_20_10 p_20_10 p_21_10 5.017838e-04
Rpv_20_10 p_20_10 p_20_11 5.017838e-04
Rph_20_11 p_20_11 p_21_11 5.017838e-04
Rpv_20_11 p_20_11 p_20_12 5.017838e-04
Rph_20_12 p_20_12 p_21_12 5.017838e-04
Rpv_20_12 p_20_12 p_20_13 5.017838e-04
Rph_20_13 p_20_13 p_21_13 5.017838e-04
Rpv_20_13 p_20_13 p_20_14 5.017838e-04
Rph_20_14 p_20_14 p_21_14 5.017838e-04
Rpv_20_14 p_20_14 p_20_15 5.017838e-04
Rph_20_15 p_20_15 p_21_15 5.017838e-04
Rpv_20_15 p_20_15 p_20_16 5.017838e-04
Rph_20_16 p_20_16 p_21_16 5.017838e-04
Rpv_20_16 p_20_16 p_20_17 5.017838e-04
Rph_20_17 p_20_17 p_21_17 5.017838e-04
Rpv_20_17 p_20_17 p_20_18 5.017838e-04
Rph_20_18 p_20_18 p_21_18 5.017838e-04
Rpv_20_18 p_20_18 p_20_19 5.017838e-04
Rph_20_19 p_20_19 p_21_19 5.017838e-04
Rpv_20_19 p_20_19 p_20_20 5.017838e-04
Rph_20_20 p_20_20 p_21_20 5.017838e-04
Rpv_20_20 p_20_20 p_20_21 5.017838e-04
Rph_20_21 p_20_21 p_21_21 5.017838e-04
Rpv_20_21 p_20_21 p_20_22 5.017838e-04
Rph_20_22 p_20_22 p_21_22 5.017838e-04
Rpv_20_22 p_20_22 p_20_23 5.017838e-04
Rph_20_23 p_20_23 p_21_23 5.017838e-04
Rpv_20_23 p_20_23 p_20_24 5.017838e-04
Rph_20_24 p_20_24 p_21_24 5.017838e-04
Rpv_20_24 p_20_24 p_20_25 5.017838e-04
Rph_20_25 p_20_25 p_21_25 5.017838e-04
Rpv_20_25 p_20_25 p_20_26 5.017838e-04
Rph_20_26 p_20_26 p_21_26 5.017838e-04
Rpv_20_26 p_20_26 p_20_27 5.017838e-04
Rph_20_27 p_20_27 p_21_27 5.017838e-04
Rpv_20_27 p_20_27 p_20_28 5.017838e-04
Rph_20_28 p_20_28 p_21_28 5.017838e-04
Rpv_20_28 p_20_28 p_20_29 5.017838e-04
Rph_20_29 p_20_29 p_21_29 5.017838e-04
Rpv_20_29 p_20_29 p_20_30 5.017838e-04
Rph_20_30 p_20_30 p_21_30 5.017838e-04
Rpv_20_30 p_20_30 p_20_31 5.017838e-04
Rph_20_31 p_20_31 p_21_31 5.017838e-04
Rpv_20_31 p_20_31 p_20_32 5.017838e-04
Rph_20_32 p_20_32 p_21_32 5.017838e-04
Rpv_20_32 p_20_32 p_20_33 5.017838e-04
Rph_20_33 p_20_33 p_21_33 5.017838e-04
Rpv_20_33 p_20_33 p_20_34 5.017838e-04
Rph_20_34 p_20_34 p_21_34 5.017838e-04
Rpv_20_34 p_20_34 p_20_35 5.017838e-04
Rph_20_35 p_20_35 p_21_35 5.017838e-04
Rpv_20_35 p_20_35 p_20_36 5.017838e-04
Rph_20_36 p_20_36 p_21_36 5.017838e-04
Rpv_20_36 p_20_36 p_20_37 5.017838e-04
Rph_20_37 p_20_37 p_21_37 5.017838e-04
Rpv_20_37 p_20_37 p_20_38 5.017838e-04
Rph_20_38 p_20_38 p_21_38 5.017838e-04
Rpv_20_38 p_20_38 p_20_39 5.017838e-04
Rph_20_39 p_20_39 p_21_39 5.017838e-04
Rpv_20_39 p_20_39 p_20_40 5.017838e-04
Rph_20_40 p_20_40 p_21_40 5.017838e-04
Rpv_20_40 p_20_40 p_20_41 5.017838e-04
Rph_20_41 p_20_41 p_21_41 5.017838e-04
Rpv_20_41 p_20_41 p_20_42 5.017838e-04
Rph_20_42 p_20_42 p_21_42 5.017838e-04
Rpv_20_42 p_20_42 p_20_43 5.017838e-04
Rph_20_43 p_20_43 p_21_43 5.017838e-04
Rpv_20_43 p_20_43 p_20_44 5.017838e-04
Rph_20_44 p_20_44 p_21_44 5.017838e-04
Rpv_20_44 p_20_44 p_20_45 5.017838e-04
Rph_20_45 p_20_45 p_21_45 5.017838e-04
Rpv_20_45 p_20_45 p_20_46 5.017838e-04
Rph_20_46 p_20_46 p_21_46 5.017838e-04
Rpv_20_46 p_20_46 p_20_47 5.017838e-04
Rph_20_47 p_20_47 p_21_47 5.017838e-04
Rpv_20_47 p_20_47 p_20_48 5.017838e-04
Rph_20_48 p_20_48 p_21_48 5.017838e-04
Rpv_20_48 p_20_48 p_20_49 5.017838e-04
Rph_20_49 p_20_49 p_21_49 5.017838e-04
Rpv_20_49 p_20_49 p_20_50 5.017838e-04
Rph_20_50 p_20_50 p_21_50 5.017838e-04
Rpv_20_50 p_20_50 p_20_51 5.017838e-04
Rph_20_51 p_20_51 p_21_51 5.017838e-04
Rpv_20_51 p_20_51 p_20_52 5.017838e-04
Rph_20_52 p_20_52 p_21_52 5.017838e-04
Rpv_20_52 p_20_52 p_20_53 5.017838e-04
Rph_20_53 p_20_53 p_21_53 5.017838e-04
Rpv_20_53 p_20_53 p_20_54 5.017838e-04
Rph_20_54 p_20_54 p_21_54 5.017838e-04
Rpv_20_54 p_20_54 p_20_55 5.017838e-04
Rph_20_55 p_20_55 p_21_55 5.017838e-04
Rpv_20_55 p_20_55 p_20_56 5.017838e-04
Rph_20_56 p_20_56 p_21_56 5.017838e-04
Rpv_20_56 p_20_56 p_20_57 5.017838e-04
Rph_20_57 p_20_57 p_21_57 5.017838e-04
Rpv_20_57 p_20_57 p_20_58 5.017838e-04
Rph_20_58 p_20_58 p_21_58 5.017838e-04
Rpv_20_58 p_20_58 p_20_59 5.017838e-04
Rph_20_59 p_20_59 p_21_59 5.017838e-04
Rpv_20_59 p_20_59 p_20_60 5.017838e-04
Rph_20_60 p_20_60 p_21_60 5.017838e-04
Rpv_20_60 p_20_60 p_20_61 5.017838e-04
Rph_20_61 p_20_61 p_21_61 5.017838e-04
Rpv_20_61 p_20_61 p_20_62 5.017838e-04
Rph_20_62 p_20_62 p_21_62 5.017838e-04
Rpv_20_62 p_20_62 p_20_63 5.017838e-04
Rph_20_63 p_20_63 p_21_63 5.017838e-04
Rpv_20_63 p_20_63 p_20_64 5.017838e-04
Rph_20_64 p_20_64 p_21_64 5.017838e-04
Rpv_20_64 p_20_64 p_20_65 5.017838e-04
Rph_20_65 p_20_65 p_21_65 5.017838e-04
Rpv_20_65 p_20_65 p_20_66 5.017838e-04
Rph_20_66 p_20_66 p_21_66 5.017838e-04
Rpv_20_66 p_20_66 p_20_67 5.017838e-04
Rph_20_67 p_20_67 p_21_67 5.017838e-04
Rpv_20_67 p_20_67 p_20_68 5.017838e-04
Rph_20_68 p_20_68 p_21_68 5.017838e-04
Rpv_20_68 p_20_68 p_20_69 5.017838e-04
Rph_20_69 p_20_69 p_21_69 5.017838e-04
Rpv_20_69 p_20_69 p_20_70 5.017838e-04
Rph_20_70 p_20_70 p_21_70 5.017838e-04
Rpv_20_70 p_20_70 p_20_71 5.017838e-04
Rph_20_71 p_20_71 p_21_71 5.017838e-04
Rph_21_0 p_21_0 p_22_0 5.017838e-04
Rpv_21_0 p_21_0 p_21_1 5.017838e-04
Rph_21_1 p_21_1 p_22_1 5.017838e-04
Rpv_21_1 p_21_1 p_21_2 5.017838e-04
Rph_21_2 p_21_2 p_22_2 5.017838e-04
Rpv_21_2 p_21_2 p_21_3 5.017838e-04
Rph_21_3 p_21_3 p_22_3 5.017838e-04
Rpv_21_3 p_21_3 p_21_4 5.017838e-04
Rph_21_4 p_21_4 p_22_4 5.017838e-04
Rpv_21_4 p_21_4 p_21_5 5.017838e-04
Rph_21_5 p_21_5 p_22_5 5.017838e-04
Rpv_21_5 p_21_5 p_21_6 5.017838e-04
Rph_21_6 p_21_6 p_22_6 5.017838e-04
Rpv_21_6 p_21_6 p_21_7 5.017838e-04
Rph_21_7 p_21_7 p_22_7 5.017838e-04
Rpv_21_7 p_21_7 p_21_8 5.017838e-04
Rph_21_8 p_21_8 p_22_8 5.017838e-04
Rpv_21_8 p_21_8 p_21_9 5.017838e-04
Rph_21_9 p_21_9 p_22_9 5.017838e-04
Rpv_21_9 p_21_9 p_21_10 5.017838e-04
Rph_21_10 p_21_10 p_22_10 5.017838e-04
Rpv_21_10 p_21_10 p_21_11 5.017838e-04
Rph_21_11 p_21_11 p_22_11 5.017838e-04
Rpv_21_11 p_21_11 p_21_12 5.017838e-04
Rph_21_12 p_21_12 p_22_12 5.017838e-04
Rpv_21_12 p_21_12 p_21_13 5.017838e-04
Rph_21_13 p_21_13 p_22_13 5.017838e-04
Rpv_21_13 p_21_13 p_21_14 5.017838e-04
Rph_21_14 p_21_14 p_22_14 5.017838e-04
Rpv_21_14 p_21_14 p_21_15 5.017838e-04
Rph_21_15 p_21_15 p_22_15 5.017838e-04
Rpv_21_15 p_21_15 p_21_16 5.017838e-04
Rph_21_16 p_21_16 p_22_16 5.017838e-04
Rpv_21_16 p_21_16 p_21_17 5.017838e-04
Rph_21_17 p_21_17 p_22_17 5.017838e-04
Rpv_21_17 p_21_17 p_21_18 5.017838e-04
Rph_21_18 p_21_18 p_22_18 5.017838e-04
Rpv_21_18 p_21_18 p_21_19 5.017838e-04
Rph_21_19 p_21_19 p_22_19 5.017838e-04
Rpv_21_19 p_21_19 p_21_20 5.017838e-04
Rph_21_20 p_21_20 p_22_20 5.017838e-04
Rpv_21_20 p_21_20 p_21_21 5.017838e-04
Rph_21_21 p_21_21 p_22_21 5.017838e-04
Rpv_21_21 p_21_21 p_21_22 5.017838e-04
Rph_21_22 p_21_22 p_22_22 5.017838e-04
Rpv_21_22 p_21_22 p_21_23 5.017838e-04
Rph_21_23 p_21_23 p_22_23 5.017838e-04
Rpv_21_23 p_21_23 p_21_24 5.017838e-04
Rph_21_24 p_21_24 p_22_24 5.017838e-04
Rpv_21_24 p_21_24 p_21_25 5.017838e-04
Rph_21_25 p_21_25 p_22_25 5.017838e-04
Rpv_21_25 p_21_25 p_21_26 5.017838e-04
Rph_21_26 p_21_26 p_22_26 5.017838e-04
Rpv_21_26 p_21_26 p_21_27 5.017838e-04
Rph_21_27 p_21_27 p_22_27 5.017838e-04
Rpv_21_27 p_21_27 p_21_28 5.017838e-04
Rph_21_28 p_21_28 p_22_28 5.017838e-04
Rpv_21_28 p_21_28 p_21_29 5.017838e-04
Rph_21_29 p_21_29 p_22_29 5.017838e-04
Rpv_21_29 p_21_29 p_21_30 5.017838e-04
Rph_21_30 p_21_30 p_22_30 5.017838e-04
Rpv_21_30 p_21_30 p_21_31 5.017838e-04
Rph_21_31 p_21_31 p_22_31 5.017838e-04
Rpv_21_31 p_21_31 p_21_32 5.017838e-04
Rph_21_32 p_21_32 p_22_32 5.017838e-04
Rpv_21_32 p_21_32 p_21_33 5.017838e-04
Rph_21_33 p_21_33 p_22_33 5.017838e-04
Rpv_21_33 p_21_33 p_21_34 5.017838e-04
Rph_21_34 p_21_34 p_22_34 5.017838e-04
Rpv_21_34 p_21_34 p_21_35 5.017838e-04
Rph_21_35 p_21_35 p_22_35 5.017838e-04
Rpv_21_35 p_21_35 p_21_36 5.017838e-04
Rph_21_36 p_21_36 p_22_36 5.017838e-04
Rpv_21_36 p_21_36 p_21_37 5.017838e-04
Rph_21_37 p_21_37 p_22_37 5.017838e-04
Rpv_21_37 p_21_37 p_21_38 5.017838e-04
Rph_21_38 p_21_38 p_22_38 5.017838e-04
Rpv_21_38 p_21_38 p_21_39 5.017838e-04
Rph_21_39 p_21_39 p_22_39 5.017838e-04
Rpv_21_39 p_21_39 p_21_40 5.017838e-04
Rph_21_40 p_21_40 p_22_40 5.017838e-04
Rpv_21_40 p_21_40 p_21_41 5.017838e-04
Rph_21_41 p_21_41 p_22_41 5.017838e-04
Rpv_21_41 p_21_41 p_21_42 5.017838e-04
Rph_21_42 p_21_42 p_22_42 5.017838e-04
Rpv_21_42 p_21_42 p_21_43 5.017838e-04
Rph_21_43 p_21_43 p_22_43 5.017838e-04
Rpv_21_43 p_21_43 p_21_44 5.017838e-04
Rph_21_44 p_21_44 p_22_44 5.017838e-04
Rpv_21_44 p_21_44 p_21_45 5.017838e-04
Rph_21_45 p_21_45 p_22_45 5.017838e-04
Rpv_21_45 p_21_45 p_21_46 5.017838e-04
Rph_21_46 p_21_46 p_22_46 5.017838e-04
Rpv_21_46 p_21_46 p_21_47 5.017838e-04
Rph_21_47 p_21_47 p_22_47 5.017838e-04
Rpv_21_47 p_21_47 p_21_48 5.017838e-04
Rph_21_48 p_21_48 p_22_48 5.017838e-04
Rpv_21_48 p_21_48 p_21_49 5.017838e-04
Rph_21_49 p_21_49 p_22_49 5.017838e-04
Rpv_21_49 p_21_49 p_21_50 5.017838e-04
Rph_21_50 p_21_50 p_22_50 5.017838e-04
Rpv_21_50 p_21_50 p_21_51 5.017838e-04
Rph_21_51 p_21_51 p_22_51 5.017838e-04
Rpv_21_51 p_21_51 p_21_52 5.017838e-04
Rph_21_52 p_21_52 p_22_52 5.017838e-04
Rpv_21_52 p_21_52 p_21_53 5.017838e-04
Rph_21_53 p_21_53 p_22_53 5.017838e-04
Rpv_21_53 p_21_53 p_21_54 5.017838e-04
Rph_21_54 p_21_54 p_22_54 5.017838e-04
Rpv_21_54 p_21_54 p_21_55 5.017838e-04
Rph_21_55 p_21_55 p_22_55 5.017838e-04
Rpv_21_55 p_21_55 p_21_56 5.017838e-04
Rph_21_56 p_21_56 p_22_56 5.017838e-04
Rpv_21_56 p_21_56 p_21_57 5.017838e-04
Rph_21_57 p_21_57 p_22_57 5.017838e-04
Rpv_21_57 p_21_57 p_21_58 5.017838e-04
Rph_21_58 p_21_58 p_22_58 5.017838e-04
Rpv_21_58 p_21_58 p_21_59 5.017838e-04
Rph_21_59 p_21_59 p_22_59 5.017838e-04
Rpv_21_59 p_21_59 p_21_60 5.017838e-04
Rph_21_60 p_21_60 p_22_60 5.017838e-04
Rpv_21_60 p_21_60 p_21_61 5.017838e-04
Rph_21_61 p_21_61 p_22_61 5.017838e-04
Rpv_21_61 p_21_61 p_21_62 5.017838e-04
Rph_21_62 p_21_62 p_22_62 5.017838e-04
Rpv_21_62 p_21_62 p_21_63 5.017838e-04
Rph_21_63 p_21_63 p_22_63 5.017838e-04
Rpv_21_63 p_21_63 p_21_64 5.017838e-04
Rph_21_64 p_21_64 p_22_64 5.017838e-04
Rpv_21_64 p_21_64 p_21_65 5.017838e-04
Rph_21_65 p_21_65 p_22_65 5.017838e-04
Rpv_21_65 p_21_65 p_21_66 5.017838e-04
Rph_21_66 p_21_66 p_22_66 5.017838e-04
Rpv_21_66 p_21_66 p_21_67 5.017838e-04
Rph_21_67 p_21_67 p_22_67 5.017838e-04
Rpv_21_67 p_21_67 p_21_68 5.017838e-04
Rph_21_68 p_21_68 p_22_68 5.017838e-04
Rpv_21_68 p_21_68 p_21_69 5.017838e-04
Rph_21_69 p_21_69 p_22_69 5.017838e-04
Rpv_21_69 p_21_69 p_21_70 5.017838e-04
Rph_21_70 p_21_70 p_22_70 5.017838e-04
Rpv_21_70 p_21_70 p_21_71 5.017838e-04
Rph_21_71 p_21_71 p_22_71 5.017838e-04
Rph_22_0 p_22_0 p_23_0 5.017838e-04
Rpv_22_0 p_22_0 p_22_1 5.017838e-04
Rph_22_1 p_22_1 p_23_1 5.017838e-04
Rpv_22_1 p_22_1 p_22_2 5.017838e-04
Rph_22_2 p_22_2 p_23_2 5.017838e-04
Rpv_22_2 p_22_2 p_22_3 5.017838e-04
Rph_22_3 p_22_3 p_23_3 5.017838e-04
Rpv_22_3 p_22_3 p_22_4 5.017838e-04
Rph_22_4 p_22_4 p_23_4 5.017838e-04
Rpv_22_4 p_22_4 p_22_5 5.017838e-04
Rph_22_5 p_22_5 p_23_5 5.017838e-04
Rpv_22_5 p_22_5 p_22_6 5.017838e-04
Rph_22_6 p_22_6 p_23_6 5.017838e-04
Rpv_22_6 p_22_6 p_22_7 5.017838e-04
Rph_22_7 p_22_7 p_23_7 5.017838e-04
Rpv_22_7 p_22_7 p_22_8 5.017838e-04
Rph_22_8 p_22_8 p_23_8 5.017838e-04
Rpv_22_8 p_22_8 p_22_9 5.017838e-04
Rph_22_9 p_22_9 p_23_9 5.017838e-04
Rpv_22_9 p_22_9 p_22_10 5.017838e-04
Rph_22_10 p_22_10 p_23_10 5.017838e-04
Rpv_22_10 p_22_10 p_22_11 5.017838e-04
Rph_22_11 p_22_11 p_23_11 5.017838e-04
Rpv_22_11 p_22_11 p_22_12 5.017838e-04
Rph_22_12 p_22_12 p_23_12 5.017838e-04
Rpv_22_12 p_22_12 p_22_13 5.017838e-04
Rph_22_13 p_22_13 p_23_13 5.017838e-04
Rpv_22_13 p_22_13 p_22_14 5.017838e-04
Rph_22_14 p_22_14 p_23_14 5.017838e-04
Rpv_22_14 p_22_14 p_22_15 5.017838e-04
Rph_22_15 p_22_15 p_23_15 5.017838e-04
Rpv_22_15 p_22_15 p_22_16 5.017838e-04
Rph_22_16 p_22_16 p_23_16 5.017838e-04
Rpv_22_16 p_22_16 p_22_17 5.017838e-04
Rph_22_17 p_22_17 p_23_17 5.017838e-04
Rpv_22_17 p_22_17 p_22_18 5.017838e-04
Rph_22_18 p_22_18 p_23_18 5.017838e-04
Rpv_22_18 p_22_18 p_22_19 5.017838e-04
Rph_22_19 p_22_19 p_23_19 5.017838e-04
Rpv_22_19 p_22_19 p_22_20 5.017838e-04
Rph_22_20 p_22_20 p_23_20 5.017838e-04
Rpv_22_20 p_22_20 p_22_21 5.017838e-04
Rph_22_21 p_22_21 p_23_21 5.017838e-04
Rpv_22_21 p_22_21 p_22_22 5.017838e-04
Rph_22_22 p_22_22 p_23_22 5.017838e-04
Rpv_22_22 p_22_22 p_22_23 5.017838e-04
Rph_22_23 p_22_23 p_23_23 5.017838e-04
Rpv_22_23 p_22_23 p_22_24 5.017838e-04
Rph_22_24 p_22_24 p_23_24 5.017838e-04
Rpv_22_24 p_22_24 p_22_25 5.017838e-04
Rph_22_25 p_22_25 p_23_25 5.017838e-04
Rpv_22_25 p_22_25 p_22_26 5.017838e-04
Rph_22_26 p_22_26 p_23_26 5.017838e-04
Rpv_22_26 p_22_26 p_22_27 5.017838e-04
Rph_22_27 p_22_27 p_23_27 5.017838e-04
Rpv_22_27 p_22_27 p_22_28 5.017838e-04
Rph_22_28 p_22_28 p_23_28 5.017838e-04
Rpv_22_28 p_22_28 p_22_29 5.017838e-04
Rph_22_29 p_22_29 p_23_29 5.017838e-04
Rpv_22_29 p_22_29 p_22_30 5.017838e-04
Rph_22_30 p_22_30 p_23_30 5.017838e-04
Rpv_22_30 p_22_30 p_22_31 5.017838e-04
Rph_22_31 p_22_31 p_23_31 5.017838e-04
Rpv_22_31 p_22_31 p_22_32 5.017838e-04
Rph_22_32 p_22_32 p_23_32 5.017838e-04
Rpv_22_32 p_22_32 p_22_33 5.017838e-04
Rph_22_33 p_22_33 p_23_33 5.017838e-04
Rpv_22_33 p_22_33 p_22_34 5.017838e-04
Rph_22_34 p_22_34 p_23_34 5.017838e-04
Rpv_22_34 p_22_34 p_22_35 5.017838e-04
Rph_22_35 p_22_35 p_23_35 5.017838e-04
Rpv_22_35 p_22_35 p_22_36 5.017838e-04
Rph_22_36 p_22_36 p_23_36 5.017838e-04
Rpv_22_36 p_22_36 p_22_37 5.017838e-04
Rph_22_37 p_22_37 p_23_37 5.017838e-04
Rpv_22_37 p_22_37 p_22_38 5.017838e-04
Rph_22_38 p_22_38 p_23_38 5.017838e-04
Rpv_22_38 p_22_38 p_22_39 5.017838e-04
Rph_22_39 p_22_39 p_23_39 5.017838e-04
Rpv_22_39 p_22_39 p_22_40 5.017838e-04
Rph_22_40 p_22_40 p_23_40 5.017838e-04
Rpv_22_40 p_22_40 p_22_41 5.017838e-04
Rph_22_41 p_22_41 p_23_41 5.017838e-04
Rpv_22_41 p_22_41 p_22_42 5.017838e-04
Rph_22_42 p_22_42 p_23_42 5.017838e-04
Rpv_22_42 p_22_42 p_22_43 5.017838e-04
Rph_22_43 p_22_43 p_23_43 5.017838e-04
Rpv_22_43 p_22_43 p_22_44 5.017838e-04
Rph_22_44 p_22_44 p_23_44 5.017838e-04
Rpv_22_44 p_22_44 p_22_45 5.017838e-04
Rph_22_45 p_22_45 p_23_45 5.017838e-04
Rpv_22_45 p_22_45 p_22_46 5.017838e-04
Rph_22_46 p_22_46 p_23_46 5.017838e-04
Rpv_22_46 p_22_46 p_22_47 5.017838e-04
Rph_22_47 p_22_47 p_23_47 5.017838e-04
Rpv_22_47 p_22_47 p_22_48 5.017838e-04
Rph_22_48 p_22_48 p_23_48 5.017838e-04
Rpv_22_48 p_22_48 p_22_49 5.017838e-04
Rph_22_49 p_22_49 p_23_49 5.017838e-04
Rpv_22_49 p_22_49 p_22_50 5.017838e-04
Rph_22_50 p_22_50 p_23_50 5.017838e-04
Rpv_22_50 p_22_50 p_22_51 5.017838e-04
Rph_22_51 p_22_51 p_23_51 5.017838e-04
Rpv_22_51 p_22_51 p_22_52 5.017838e-04
Rph_22_52 p_22_52 p_23_52 5.017838e-04
Rpv_22_52 p_22_52 p_22_53 5.017838e-04
Rph_22_53 p_22_53 p_23_53 5.017838e-04
Rpv_22_53 p_22_53 p_22_54 5.017838e-04
Rph_22_54 p_22_54 p_23_54 5.017838e-04
Rpv_22_54 p_22_54 p_22_55 5.017838e-04
Rph_22_55 p_22_55 p_23_55 5.017838e-04
Rpv_22_55 p_22_55 p_22_56 5.017838e-04
Rph_22_56 p_22_56 p_23_56 5.017838e-04
Rpv_22_56 p_22_56 p_22_57 5.017838e-04
Rph_22_57 p_22_57 p_23_57 5.017838e-04
Rpv_22_57 p_22_57 p_22_58 5.017838e-04
Rph_22_58 p_22_58 p_23_58 5.017838e-04
Rpv_22_58 p_22_58 p_22_59 5.017838e-04
Rph_22_59 p_22_59 p_23_59 5.017838e-04
Rpv_22_59 p_22_59 p_22_60 5.017838e-04
Rph_22_60 p_22_60 p_23_60 5.017838e-04
Rpv_22_60 p_22_60 p_22_61 5.017838e-04
Rph_22_61 p_22_61 p_23_61 5.017838e-04
Rpv_22_61 p_22_61 p_22_62 5.017838e-04
Rph_22_62 p_22_62 p_23_62 5.017838e-04
Rpv_22_62 p_22_62 p_22_63 5.017838e-04
Rph_22_63 p_22_63 p_23_63 5.017838e-04
Rpv_22_63 p_22_63 p_22_64 5.017838e-04
Rph_22_64 p_22_64 p_23_64 5.017838e-04
Rpv_22_64 p_22_64 p_22_65 5.017838e-04
Rph_22_65 p_22_65 p_23_65 5.017838e-04
Rpv_22_65 p_22_65 p_22_66 5.017838e-04
Rph_22_66 p_22_66 p_23_66 5.017838e-04
Rpv_22_66 p_22_66 p_22_67 5.017838e-04
Rph_22_67 p_22_67 p_23_67 5.017838e-04
Rpv_22_67 p_22_67 p_22_68 5.017838e-04
Rph_22_68 p_22_68 p_23_68 5.017838e-04
Rpv_22_68 p_22_68 p_22_69 5.017838e-04
Rph_22_69 p_22_69 p_23_69 5.017838e-04
Rpv_22_69 p_22_69 p_22_70 5.017838e-04
Rph_22_70 p_22_70 p_23_70 5.017838e-04
Rpv_22_70 p_22_70 p_22_71 5.017838e-04
Rph_22_71 p_22_71 p_23_71 5.017838e-04
Rph_23_0 p_23_0 p_24_0 5.017838e-04
Rpv_23_0 p_23_0 p_23_1 5.017838e-04
Rph_23_1 p_23_1 p_24_1 5.017838e-04
Rpv_23_1 p_23_1 p_23_2 5.017838e-04
Rph_23_2 p_23_2 p_24_2 5.017838e-04
Rpv_23_2 p_23_2 p_23_3 5.017838e-04
Rph_23_3 p_23_3 p_24_3 5.017838e-04
Rpv_23_3 p_23_3 p_23_4 5.017838e-04
Rph_23_4 p_23_4 p_24_4 5.017838e-04
Rpv_23_4 p_23_4 p_23_5 5.017838e-04
Rph_23_5 p_23_5 p_24_5 5.017838e-04
Rpv_23_5 p_23_5 p_23_6 5.017838e-04
Rph_23_6 p_23_6 p_24_6 5.017838e-04
Rpv_23_6 p_23_6 p_23_7 5.017838e-04
Rph_23_7 p_23_7 p_24_7 5.017838e-04
Rpv_23_7 p_23_7 p_23_8 5.017838e-04
Rph_23_8 p_23_8 p_24_8 5.017838e-04
Rpv_23_8 p_23_8 p_23_9 5.017838e-04
Rph_23_9 p_23_9 p_24_9 5.017838e-04
Rpv_23_9 p_23_9 p_23_10 5.017838e-04
Rph_23_10 p_23_10 p_24_10 5.017838e-04
Rpv_23_10 p_23_10 p_23_11 5.017838e-04
Rph_23_11 p_23_11 p_24_11 5.017838e-04
Rpv_23_11 p_23_11 p_23_12 5.017838e-04
Rph_23_12 p_23_12 p_24_12 5.017838e-04
Rpv_23_12 p_23_12 p_23_13 5.017838e-04
Rph_23_13 p_23_13 p_24_13 5.017838e-04
Rpv_23_13 p_23_13 p_23_14 5.017838e-04
Rph_23_14 p_23_14 p_24_14 5.017838e-04
Rpv_23_14 p_23_14 p_23_15 5.017838e-04
Rph_23_15 p_23_15 p_24_15 5.017838e-04
Rpv_23_15 p_23_15 p_23_16 5.017838e-04
Rph_23_16 p_23_16 p_24_16 5.017838e-04
Rpv_23_16 p_23_16 p_23_17 5.017838e-04
Rph_23_17 p_23_17 p_24_17 5.017838e-04
Rpv_23_17 p_23_17 p_23_18 5.017838e-04
Rph_23_18 p_23_18 p_24_18 5.017838e-04
Rpv_23_18 p_23_18 p_23_19 5.017838e-04
Rph_23_19 p_23_19 p_24_19 5.017838e-04
Rpv_23_19 p_23_19 p_23_20 5.017838e-04
Rph_23_20 p_23_20 p_24_20 5.017838e-04
Rpv_23_20 p_23_20 p_23_21 5.017838e-04
Rph_23_21 p_23_21 p_24_21 5.017838e-04
Rpv_23_21 p_23_21 p_23_22 5.017838e-04
Rph_23_22 p_23_22 p_24_22 5.017838e-04
Rpv_23_22 p_23_22 p_23_23 5.017838e-04
Rph_23_23 p_23_23 p_24_23 5.017838e-04
Rpv_23_23 p_23_23 p_23_24 5.017838e-04
Rph_23_24 p_23_24 p_24_24 5.017838e-04
Rpv_23_24 p_23_24 p_23_25 5.017838e-04
Rph_23_25 p_23_25 p_24_25 5.017838e-04
Rpv_23_25 p_23_25 p_23_26 5.017838e-04
Rph_23_26 p_23_26 p_24_26 5.017838e-04
Rpv_23_26 p_23_26 p_23_27 5.017838e-04
Rph_23_27 p_23_27 p_24_27 5.017838e-04
Rpv_23_27 p_23_27 p_23_28 5.017838e-04
Rph_23_28 p_23_28 p_24_28 5.017838e-04
Rpv_23_28 p_23_28 p_23_29 5.017838e-04
Rph_23_29 p_23_29 p_24_29 5.017838e-04
Rpv_23_29 p_23_29 p_23_30 5.017838e-04
Rph_23_30 p_23_30 p_24_30 5.017838e-04
Rpv_23_30 p_23_30 p_23_31 5.017838e-04
Rph_23_31 p_23_31 p_24_31 5.017838e-04
Rpv_23_31 p_23_31 p_23_32 5.017838e-04
Rph_23_32 p_23_32 p_24_32 5.017838e-04
Rpv_23_32 p_23_32 p_23_33 5.017838e-04
Rph_23_33 p_23_33 p_24_33 5.017838e-04
Rpv_23_33 p_23_33 p_23_34 5.017838e-04
Rph_23_34 p_23_34 p_24_34 5.017838e-04
Rpv_23_34 p_23_34 p_23_35 5.017838e-04
Rph_23_35 p_23_35 p_24_35 5.017838e-04
Rpv_23_35 p_23_35 p_23_36 5.017838e-04
Rph_23_36 p_23_36 p_24_36 5.017838e-04
Rpv_23_36 p_23_36 p_23_37 5.017838e-04
Rph_23_37 p_23_37 p_24_37 5.017838e-04
Rpv_23_37 p_23_37 p_23_38 5.017838e-04
Rph_23_38 p_23_38 p_24_38 5.017838e-04
Rpv_23_38 p_23_38 p_23_39 5.017838e-04
Rph_23_39 p_23_39 p_24_39 5.017838e-04
Rpv_23_39 p_23_39 p_23_40 5.017838e-04
Rph_23_40 p_23_40 p_24_40 5.017838e-04
Rpv_23_40 p_23_40 p_23_41 5.017838e-04
Rph_23_41 p_23_41 p_24_41 5.017838e-04
Rpv_23_41 p_23_41 p_23_42 5.017838e-04
Rph_23_42 p_23_42 p_24_42 5.017838e-04
Rpv_23_42 p_23_42 p_23_43 5.017838e-04
Rph_23_43 p_23_43 p_24_43 5.017838e-04
Rpv_23_43 p_23_43 p_23_44 5.017838e-04
Rph_23_44 p_23_44 p_24_44 5.017838e-04
Rpv_23_44 p_23_44 p_23_45 5.017838e-04
Rph_23_45 p_23_45 p_24_45 5.017838e-04
Rpv_23_45 p_23_45 p_23_46 5.017838e-04
Rph_23_46 p_23_46 p_24_46 5.017838e-04
Rpv_23_46 p_23_46 p_23_47 5.017838e-04
Rph_23_47 p_23_47 p_24_47 5.017838e-04
Rpv_23_47 p_23_47 p_23_48 5.017838e-04
Rph_23_48 p_23_48 p_24_48 5.017838e-04
Rpv_23_48 p_23_48 p_23_49 5.017838e-04
Rph_23_49 p_23_49 p_24_49 5.017838e-04
Rpv_23_49 p_23_49 p_23_50 5.017838e-04
Rph_23_50 p_23_50 p_24_50 5.017838e-04
Rpv_23_50 p_23_50 p_23_51 5.017838e-04
Rph_23_51 p_23_51 p_24_51 5.017838e-04
Rpv_23_51 p_23_51 p_23_52 5.017838e-04
Rph_23_52 p_23_52 p_24_52 5.017838e-04
Rpv_23_52 p_23_52 p_23_53 5.017838e-04
Rph_23_53 p_23_53 p_24_53 5.017838e-04
Rpv_23_53 p_23_53 p_23_54 5.017838e-04
Rph_23_54 p_23_54 p_24_54 5.017838e-04
Rpv_23_54 p_23_54 p_23_55 5.017838e-04
Rph_23_55 p_23_55 p_24_55 5.017838e-04
Rpv_23_55 p_23_55 p_23_56 5.017838e-04
Rph_23_56 p_23_56 p_24_56 5.017838e-04
Rpv_23_56 p_23_56 p_23_57 5.017838e-04
Rph_23_57 p_23_57 p_24_57 5.017838e-04
Rpv_23_57 p_23_57 p_23_58 5.017838e-04
Rph_23_58 p_23_58 p_24_58 5.017838e-04
Rpv_23_58 p_23_58 p_23_59 5.017838e-04
Rph_23_59 p_23_59 p_24_59 5.017838e-04
Rpv_23_59 p_23_59 p_23_60 5.017838e-04
Rph_23_60 p_23_60 p_24_60 5.017838e-04
Rpv_23_60 p_23_60 p_23_61 5.017838e-04
Rph_23_61 p_23_61 p_24_61 5.017838e-04
Rpv_23_61 p_23_61 p_23_62 5.017838e-04
Rph_23_62 p_23_62 p_24_62 5.017838e-04
Rpv_23_62 p_23_62 p_23_63 5.017838e-04
Rph_23_63 p_23_63 p_24_63 5.017838e-04
Rpv_23_63 p_23_63 p_23_64 5.017838e-04
Rph_23_64 p_23_64 p_24_64 5.017838e-04
Rpv_23_64 p_23_64 p_23_65 5.017838e-04
Rph_23_65 p_23_65 p_24_65 5.017838e-04
Rpv_23_65 p_23_65 p_23_66 5.017838e-04
Rph_23_66 p_23_66 p_24_66 5.017838e-04
Rpv_23_66 p_23_66 p_23_67 5.017838e-04
Rph_23_67 p_23_67 p_24_67 5.017838e-04
Rpv_23_67 p_23_67 p_23_68 5.017838e-04
Rph_23_68 p_23_68 p_24_68 5.017838e-04
Rpv_23_68 p_23_68 p_23_69 5.017838e-04
Rph_23_69 p_23_69 p_24_69 5.017838e-04
Rpv_23_69 p_23_69 p_23_70 5.017838e-04
Rph_23_70 p_23_70 p_24_70 5.017838e-04
Rpv_23_70 p_23_70 p_23_71 5.017838e-04
Rph_23_71 p_23_71 p_24_71 5.017838e-04
Rph_24_0 p_24_0 p_25_0 5.017838e-04
Rpv_24_0 p_24_0 p_24_1 5.017838e-04
Rph_24_1 p_24_1 p_25_1 5.017838e-04
Rpv_24_1 p_24_1 p_24_2 5.017838e-04
Rph_24_2 p_24_2 p_25_2 5.017838e-04
Rpv_24_2 p_24_2 p_24_3 5.017838e-04
Rph_24_3 p_24_3 p_25_3 5.017838e-04
Rpv_24_3 p_24_3 p_24_4 5.017838e-04
Rph_24_4 p_24_4 p_25_4 5.017838e-04
Rpv_24_4 p_24_4 p_24_5 5.017838e-04
Rph_24_5 p_24_5 p_25_5 5.017838e-04
Rpv_24_5 p_24_5 p_24_6 5.017838e-04
Rph_24_6 p_24_6 p_25_6 5.017838e-04
Rpv_24_6 p_24_6 p_24_7 5.017838e-04
Rph_24_7 p_24_7 p_25_7 5.017838e-04
Rpv_24_7 p_24_7 p_24_8 5.017838e-04
Rph_24_8 p_24_8 p_25_8 5.017838e-04
Rpv_24_8 p_24_8 p_24_9 5.017838e-04
Rph_24_9 p_24_9 p_25_9 5.017838e-04
Rpv_24_9 p_24_9 p_24_10 5.017838e-04
Rph_24_10 p_24_10 p_25_10 5.017838e-04
Rpv_24_10 p_24_10 p_24_11 5.017838e-04
Rph_24_11 p_24_11 p_25_11 5.017838e-04
Rpv_24_11 p_24_11 p_24_12 5.017838e-04
Rph_24_12 p_24_12 p_25_12 5.017838e-04
Rpv_24_12 p_24_12 p_24_13 5.017838e-04
Rph_24_13 p_24_13 p_25_13 5.017838e-04
Rpv_24_13 p_24_13 p_24_14 5.017838e-04
Rph_24_14 p_24_14 p_25_14 5.017838e-04
Rpv_24_14 p_24_14 p_24_15 5.017838e-04
Rph_24_15 p_24_15 p_25_15 5.017838e-04
Rpv_24_15 p_24_15 p_24_16 5.017838e-04
Rph_24_16 p_24_16 p_25_16 5.017838e-04
Rpv_24_16 p_24_16 p_24_17 5.017838e-04
Rph_24_17 p_24_17 p_25_17 5.017838e-04
Rpv_24_17 p_24_17 p_24_18 5.017838e-04
Rph_24_18 p_24_18 p_25_18 5.017838e-04
Rpv_24_18 p_24_18 p_24_19 5.017838e-04
Rph_24_19 p_24_19 p_25_19 5.017838e-04
Rpv_24_19 p_24_19 p_24_20 5.017838e-04
Rph_24_20 p_24_20 p_25_20 5.017838e-04
Rpv_24_20 p_24_20 p_24_21 5.017838e-04
Rph_24_21 p_24_21 p_25_21 5.017838e-04
Rpv_24_21 p_24_21 p_24_22 5.017838e-04
Rph_24_22 p_24_22 p_25_22 5.017838e-04
Rpv_24_22 p_24_22 p_24_23 5.017838e-04
Rph_24_23 p_24_23 p_25_23 5.017838e-04
Rpv_24_23 p_24_23 p_24_24 5.017838e-04
Rph_24_24 p_24_24 p_25_24 5.017838e-04
Rpv_24_24 p_24_24 p_24_25 5.017838e-04
Rph_24_25 p_24_25 p_25_25 5.017838e-04
Rpv_24_25 p_24_25 p_24_26 5.017838e-04
Rph_24_26 p_24_26 p_25_26 5.017838e-04
Rpv_24_26 p_24_26 p_24_27 5.017838e-04
Rph_24_27 p_24_27 p_25_27 5.017838e-04
Rpv_24_27 p_24_27 p_24_28 5.017838e-04
Rph_24_28 p_24_28 p_25_28 5.017838e-04
Rpv_24_28 p_24_28 p_24_29 5.017838e-04
Rph_24_29 p_24_29 p_25_29 5.017838e-04
Rpv_24_29 p_24_29 p_24_30 5.017838e-04
Rph_24_30 p_24_30 p_25_30 5.017838e-04
Rpv_24_30 p_24_30 p_24_31 5.017838e-04
Rph_24_31 p_24_31 p_25_31 5.017838e-04
Rpv_24_31 p_24_31 p_24_32 5.017838e-04
Rph_24_32 p_24_32 p_25_32 5.017838e-04
Rpv_24_32 p_24_32 p_24_33 5.017838e-04
Rph_24_33 p_24_33 p_25_33 5.017838e-04
Rpv_24_33 p_24_33 p_24_34 5.017838e-04
Rph_24_34 p_24_34 p_25_34 5.017838e-04
Rpv_24_34 p_24_34 p_24_35 5.017838e-04
Rph_24_35 p_24_35 p_25_35 5.017838e-04
Rpv_24_35 p_24_35 p_24_36 5.017838e-04
Rph_24_36 p_24_36 p_25_36 5.017838e-04
Rpv_24_36 p_24_36 p_24_37 5.017838e-04
Rph_24_37 p_24_37 p_25_37 5.017838e-04
Rpv_24_37 p_24_37 p_24_38 5.017838e-04
Rph_24_38 p_24_38 p_25_38 5.017838e-04
Rpv_24_38 p_24_38 p_24_39 5.017838e-04
Rph_24_39 p_24_39 p_25_39 5.017838e-04
Rpv_24_39 p_24_39 p_24_40 5.017838e-04
Rph_24_40 p_24_40 p_25_40 5.017838e-04
Rpv_24_40 p_24_40 p_24_41 5.017838e-04
Rph_24_41 p_24_41 p_25_41 5.017838e-04
Rpv_24_41 p_24_41 p_24_42 5.017838e-04
Rph_24_42 p_24_42 p_25_42 5.017838e-04
Rpv_24_42 p_24_42 p_24_43 5.017838e-04
Rph_24_43 p_24_43 p_25_43 5.017838e-04
Rpv_24_43 p_24_43 p_24_44 5.017838e-04
Rph_24_44 p_24_44 p_25_44 5.017838e-04
Rpv_24_44 p_24_44 p_24_45 5.017838e-04
Rph_24_45 p_24_45 p_25_45 5.017838e-04
Rpv_24_45 p_24_45 p_24_46 5.017838e-04
Rph_24_46 p_24_46 p_25_46 5.017838e-04
Rpv_24_46 p_24_46 p_24_47 5.017838e-04
Rph_24_47 p_24_47 p_25_47 5.017838e-04
Rpv_24_47 p_24_47 p_24_48 5.017838e-04
Rph_24_48 p_24_48 p_25_48 5.017838e-04
Rpv_24_48 p_24_48 p_24_49 5.017838e-04
Rph_24_49 p_24_49 p_25_49 5.017838e-04
Rpv_24_49 p_24_49 p_24_50 5.017838e-04
Rph_24_50 p_24_50 p_25_50 5.017838e-04
Rpv_24_50 p_24_50 p_24_51 5.017838e-04
Rph_24_51 p_24_51 p_25_51 5.017838e-04
Rpv_24_51 p_24_51 p_24_52 5.017838e-04
Rph_24_52 p_24_52 p_25_52 5.017838e-04
Rpv_24_52 p_24_52 p_24_53 5.017838e-04
Rph_24_53 p_24_53 p_25_53 5.017838e-04
Rpv_24_53 p_24_53 p_24_54 5.017838e-04
Rph_24_54 p_24_54 p_25_54 5.017838e-04
Rpv_24_54 p_24_54 p_24_55 5.017838e-04
Rph_24_55 p_24_55 p_25_55 5.017838e-04
Rpv_24_55 p_24_55 p_24_56 5.017838e-04
Rph_24_56 p_24_56 p_25_56 5.017838e-04
Rpv_24_56 p_24_56 p_24_57 5.017838e-04
Rph_24_57 p_24_57 p_25_57 5.017838e-04
Rpv_24_57 p_24_57 p_24_58 5.017838e-04
Rph_24_58 p_24_58 p_25_58 5.017838e-04
Rpv_24_58 p_24_58 p_24_59 5.017838e-04
Rph_24_59 p_24_59 p_25_59 5.017838e-04
Rpv_24_59 p_24_59 p_24_60 5.017838e-04
Rph_24_60 p_24_60 p_25_60 5.017838e-04
Rpv_24_60 p_24_60 p_24_61 5.017838e-04
Rph_24_61 p_24_61 p_25_61 5.017838e-04
Rpv_24_61 p_24_61 p_24_62 5.017838e-04
Rph_24_62 p_24_62 p_25_62 5.017838e-04
Rpv_24_62 p_24_62 p_24_63 5.017838e-04
Rph_24_63 p_24_63 p_25_63 5.017838e-04
Rpv_24_63 p_24_63 p_24_64 5.017838e-04
Rph_24_64 p_24_64 p_25_64 5.017838e-04
Rpv_24_64 p_24_64 p_24_65 5.017838e-04
Rph_24_65 p_24_65 p_25_65 5.017838e-04
Rpv_24_65 p_24_65 p_24_66 5.017838e-04
Rph_24_66 p_24_66 p_25_66 5.017838e-04
Rpv_24_66 p_24_66 p_24_67 5.017838e-04
Rph_24_67 p_24_67 p_25_67 5.017838e-04
Rpv_24_67 p_24_67 p_24_68 5.017838e-04
Rph_24_68 p_24_68 p_25_68 5.017838e-04
Rpv_24_68 p_24_68 p_24_69 5.017838e-04
Rph_24_69 p_24_69 p_25_69 5.017838e-04
Rpv_24_69 p_24_69 p_24_70 5.017838e-04
Rph_24_70 p_24_70 p_25_70 5.017838e-04
Rpv_24_70 p_24_70 p_24_71 5.017838e-04
Rph_24_71 p_24_71 p_25_71 5.017838e-04
Rph_25_0 p_25_0 p_26_0 5.017838e-04
Rpv_25_0 p_25_0 p_25_1 5.017838e-04
Rph_25_1 p_25_1 p_26_1 5.017838e-04
Rpv_25_1 p_25_1 p_25_2 5.017838e-04
Rph_25_2 p_25_2 p_26_2 5.017838e-04
Rpv_25_2 p_25_2 p_25_3 5.017838e-04
Rph_25_3 p_25_3 p_26_3 5.017838e-04
Rpv_25_3 p_25_3 p_25_4 5.017838e-04
Rph_25_4 p_25_4 p_26_4 5.017838e-04
Rpv_25_4 p_25_4 p_25_5 5.017838e-04
Rph_25_5 p_25_5 p_26_5 5.017838e-04
Rpv_25_5 p_25_5 p_25_6 5.017838e-04
Rph_25_6 p_25_6 p_26_6 5.017838e-04
Rpv_25_6 p_25_6 p_25_7 5.017838e-04
Rph_25_7 p_25_7 p_26_7 5.017838e-04
Rpv_25_7 p_25_7 p_25_8 5.017838e-04
Rph_25_8 p_25_8 p_26_8 5.017838e-04
Rpv_25_8 p_25_8 p_25_9 5.017838e-04
Rph_25_9 p_25_9 p_26_9 5.017838e-04
Rpv_25_9 p_25_9 p_25_10 5.017838e-04
Rph_25_10 p_25_10 p_26_10 5.017838e-04
Rpv_25_10 p_25_10 p_25_11 5.017838e-04
Rph_25_11 p_25_11 p_26_11 5.017838e-04
Rpv_25_11 p_25_11 p_25_12 5.017838e-04
Rph_25_12 p_25_12 p_26_12 5.017838e-04
Rpv_25_12 p_25_12 p_25_13 5.017838e-04
Rph_25_13 p_25_13 p_26_13 5.017838e-04
Rpv_25_13 p_25_13 p_25_14 5.017838e-04
Rph_25_14 p_25_14 p_26_14 5.017838e-04
Rpv_25_14 p_25_14 p_25_15 5.017838e-04
Rph_25_15 p_25_15 p_26_15 5.017838e-04
Rpv_25_15 p_25_15 p_25_16 5.017838e-04
Rph_25_16 p_25_16 p_26_16 5.017838e-04
Rpv_25_16 p_25_16 p_25_17 5.017838e-04
Rph_25_17 p_25_17 p_26_17 5.017838e-04
Rpv_25_17 p_25_17 p_25_18 5.017838e-04
Rph_25_18 p_25_18 p_26_18 5.017838e-04
Rpv_25_18 p_25_18 p_25_19 5.017838e-04
Rph_25_19 p_25_19 p_26_19 5.017838e-04
Rpv_25_19 p_25_19 p_25_20 5.017838e-04
Rph_25_20 p_25_20 p_26_20 5.017838e-04
Rpv_25_20 p_25_20 p_25_21 5.017838e-04
Rph_25_21 p_25_21 p_26_21 5.017838e-04
Rpv_25_21 p_25_21 p_25_22 5.017838e-04
Rph_25_22 p_25_22 p_26_22 5.017838e-04
Rpv_25_22 p_25_22 p_25_23 5.017838e-04
Rph_25_23 p_25_23 p_26_23 5.017838e-04
Rpv_25_23 p_25_23 p_25_24 5.017838e-04
Rph_25_24 p_25_24 p_26_24 5.017838e-04
Rpv_25_24 p_25_24 p_25_25 5.017838e-04
Rph_25_25 p_25_25 p_26_25 5.017838e-04
Rpv_25_25 p_25_25 p_25_26 5.017838e-04
Rph_25_26 p_25_26 p_26_26 5.017838e-04
Rpv_25_26 p_25_26 p_25_27 5.017838e-04
Rph_25_27 p_25_27 p_26_27 5.017838e-04
Rpv_25_27 p_25_27 p_25_28 5.017838e-04
Rph_25_28 p_25_28 p_26_28 5.017838e-04
Rpv_25_28 p_25_28 p_25_29 5.017838e-04
Rph_25_29 p_25_29 p_26_29 5.017838e-04
Rpv_25_29 p_25_29 p_25_30 5.017838e-04
Rph_25_30 p_25_30 p_26_30 5.017838e-04
Rpv_25_30 p_25_30 p_25_31 5.017838e-04
Rph_25_31 p_25_31 p_26_31 5.017838e-04
Rpv_25_31 p_25_31 p_25_32 5.017838e-04
Rph_25_32 p_25_32 p_26_32 5.017838e-04
Rpv_25_32 p_25_32 p_25_33 5.017838e-04
Rph_25_33 p_25_33 p_26_33 5.017838e-04
Rpv_25_33 p_25_33 p_25_34 5.017838e-04
Rph_25_34 p_25_34 p_26_34 5.017838e-04
Rpv_25_34 p_25_34 p_25_35 5.017838e-04
Rph_25_35 p_25_35 p_26_35 5.017838e-04
Rpv_25_35 p_25_35 p_25_36 5.017838e-04
Rph_25_36 p_25_36 p_26_36 5.017838e-04
Rpv_25_36 p_25_36 p_25_37 5.017838e-04
Rph_25_37 p_25_37 p_26_37 5.017838e-04
Rpv_25_37 p_25_37 p_25_38 5.017838e-04
Rph_25_38 p_25_38 p_26_38 5.017838e-04
Rpv_25_38 p_25_38 p_25_39 5.017838e-04
Rph_25_39 p_25_39 p_26_39 5.017838e-04
Rpv_25_39 p_25_39 p_25_40 5.017838e-04
Rph_25_40 p_25_40 p_26_40 5.017838e-04
Rpv_25_40 p_25_40 p_25_41 5.017838e-04
Rph_25_41 p_25_41 p_26_41 5.017838e-04
Rpv_25_41 p_25_41 p_25_42 5.017838e-04
Rph_25_42 p_25_42 p_26_42 5.017838e-04
Rpv_25_42 p_25_42 p_25_43 5.017838e-04
Rph_25_43 p_25_43 p_26_43 5.017838e-04
Rpv_25_43 p_25_43 p_25_44 5.017838e-04
Rph_25_44 p_25_44 p_26_44 5.017838e-04
Rpv_25_44 p_25_44 p_25_45 5.017838e-04
Rph_25_45 p_25_45 p_26_45 5.017838e-04
Rpv_25_45 p_25_45 p_25_46 5.017838e-04
Rph_25_46 p_25_46 p_26_46 5.017838e-04
Rpv_25_46 p_25_46 p_25_47 5.017838e-04
Rph_25_47 p_25_47 p_26_47 5.017838e-04
Rpv_25_47 p_25_47 p_25_48 5.017838e-04
Rph_25_48 p_25_48 p_26_48 5.017838e-04
Rpv_25_48 p_25_48 p_25_49 5.017838e-04
Rph_25_49 p_25_49 p_26_49 5.017838e-04
Rpv_25_49 p_25_49 p_25_50 5.017838e-04
Rph_25_50 p_25_50 p_26_50 5.017838e-04
Rpv_25_50 p_25_50 p_25_51 5.017838e-04
Rph_25_51 p_25_51 p_26_51 5.017838e-04
Rpv_25_51 p_25_51 p_25_52 5.017838e-04
Rph_25_52 p_25_52 p_26_52 5.017838e-04
Rpv_25_52 p_25_52 p_25_53 5.017838e-04
Rph_25_53 p_25_53 p_26_53 5.017838e-04
Rpv_25_53 p_25_53 p_25_54 5.017838e-04
Rph_25_54 p_25_54 p_26_54 5.017838e-04
Rpv_25_54 p_25_54 p_25_55 5.017838e-04
Rph_25_55 p_25_55 p_26_55 5.017838e-04
Rpv_25_55 p_25_55 p_25_56 5.017838e-04
Rph_25_56 p_25_56 p_26_56 5.017838e-04
Rpv_25_56 p_25_56 p_25_57 5.017838e-04
Rph_25_57 p_25_57 p_26_57 5.017838e-04
Rpv_25_57 p_25_57 p_25_58 5.017838e-04
Rph_25_58 p_25_58 p_26_58 5.017838e-04
Rpv_25_58 p_25_58 p_25_59 5.017838e-04
Rph_25_59 p_25_59 p_26_59 5.017838e-04
Rpv_25_59 p_25_59 p_25_60 5.017838e-04
Rph_25_60 p_25_60 p_26_60 5.017838e-04
Rpv_25_60 p_25_60 p_25_61 5.017838e-04
Rph_25_61 p_25_61 p_26_61 5.017838e-04
Rpv_25_61 p_25_61 p_25_62 5.017838e-04
Rph_25_62 p_25_62 p_26_62 5.017838e-04
Rpv_25_62 p_25_62 p_25_63 5.017838e-04
Rph_25_63 p_25_63 p_26_63 5.017838e-04
Rpv_25_63 p_25_63 p_25_64 5.017838e-04
Rph_25_64 p_25_64 p_26_64 5.017838e-04
Rpv_25_64 p_25_64 p_25_65 5.017838e-04
Rph_25_65 p_25_65 p_26_65 5.017838e-04
Rpv_25_65 p_25_65 p_25_66 5.017838e-04
Rph_25_66 p_25_66 p_26_66 5.017838e-04
Rpv_25_66 p_25_66 p_25_67 5.017838e-04
Rph_25_67 p_25_67 p_26_67 5.017838e-04
Rpv_25_67 p_25_67 p_25_68 5.017838e-04
Rph_25_68 p_25_68 p_26_68 5.017838e-04
Rpv_25_68 p_25_68 p_25_69 5.017838e-04
Rph_25_69 p_25_69 p_26_69 5.017838e-04
Rpv_25_69 p_25_69 p_25_70 5.017838e-04
Rph_25_70 p_25_70 p_26_70 5.017838e-04
Rpv_25_70 p_25_70 p_25_71 5.017838e-04
Rph_25_71 p_25_71 p_26_71 5.017838e-04
Rph_26_0 p_26_0 p_27_0 5.017838e-04
Rpv_26_0 p_26_0 p_26_1 5.017838e-04
Rph_26_1 p_26_1 p_27_1 5.017838e-04
Rpv_26_1 p_26_1 p_26_2 5.017838e-04
Rph_26_2 p_26_2 p_27_2 5.017838e-04
Rpv_26_2 p_26_2 p_26_3 5.017838e-04
Rph_26_3 p_26_3 p_27_3 5.017838e-04
Rpv_26_3 p_26_3 p_26_4 5.017838e-04
Rph_26_4 p_26_4 p_27_4 5.017838e-04
Rpv_26_4 p_26_4 p_26_5 5.017838e-04
Rph_26_5 p_26_5 p_27_5 5.017838e-04
Rpv_26_5 p_26_5 p_26_6 5.017838e-04
Rph_26_6 p_26_6 p_27_6 5.017838e-04
Rpv_26_6 p_26_6 p_26_7 5.017838e-04
Rph_26_7 p_26_7 p_27_7 5.017838e-04
Rpv_26_7 p_26_7 p_26_8 5.017838e-04
Rph_26_8 p_26_8 p_27_8 5.017838e-04
Rpv_26_8 p_26_8 p_26_9 5.017838e-04
Rph_26_9 p_26_9 p_27_9 5.017838e-04
Rpv_26_9 p_26_9 p_26_10 5.017838e-04
Rph_26_10 p_26_10 p_27_10 5.017838e-04
Rpv_26_10 p_26_10 p_26_11 5.017838e-04
Rph_26_11 p_26_11 p_27_11 5.017838e-04
Rpv_26_11 p_26_11 p_26_12 5.017838e-04
Rph_26_12 p_26_12 p_27_12 5.017838e-04
Rpv_26_12 p_26_12 p_26_13 5.017838e-04
Rph_26_13 p_26_13 p_27_13 5.017838e-04
Rpv_26_13 p_26_13 p_26_14 5.017838e-04
Rph_26_14 p_26_14 p_27_14 5.017838e-04
Rpv_26_14 p_26_14 p_26_15 5.017838e-04
Rph_26_15 p_26_15 p_27_15 5.017838e-04
Rpv_26_15 p_26_15 p_26_16 5.017838e-04
Rph_26_16 p_26_16 p_27_16 5.017838e-04
Rpv_26_16 p_26_16 p_26_17 5.017838e-04
Rph_26_17 p_26_17 p_27_17 5.017838e-04
Rpv_26_17 p_26_17 p_26_18 5.017838e-04
Rph_26_18 p_26_18 p_27_18 5.017838e-04
Rpv_26_18 p_26_18 p_26_19 5.017838e-04
Rph_26_19 p_26_19 p_27_19 5.017838e-04
Rpv_26_19 p_26_19 p_26_20 5.017838e-04
Rph_26_20 p_26_20 p_27_20 5.017838e-04
Rpv_26_20 p_26_20 p_26_21 5.017838e-04
Rph_26_21 p_26_21 p_27_21 5.017838e-04
Rpv_26_21 p_26_21 p_26_22 5.017838e-04
Rph_26_22 p_26_22 p_27_22 5.017838e-04
Rpv_26_22 p_26_22 p_26_23 5.017838e-04
Rph_26_23 p_26_23 p_27_23 5.017838e-04
Rpv_26_23 p_26_23 p_26_24 5.017838e-04
Rph_26_24 p_26_24 p_27_24 5.017838e-04
Rpv_26_24 p_26_24 p_26_25 5.017838e-04
Rph_26_25 p_26_25 p_27_25 5.017838e-04
Rpv_26_25 p_26_25 p_26_26 5.017838e-04
Rph_26_26 p_26_26 p_27_26 5.017838e-04
Rpv_26_26 p_26_26 p_26_27 5.017838e-04
Rph_26_27 p_26_27 p_27_27 5.017838e-04
Rpv_26_27 p_26_27 p_26_28 5.017838e-04
Rph_26_28 p_26_28 p_27_28 5.017838e-04
Rpv_26_28 p_26_28 p_26_29 5.017838e-04
Rph_26_29 p_26_29 p_27_29 5.017838e-04
Rpv_26_29 p_26_29 p_26_30 5.017838e-04
Rph_26_30 p_26_30 p_27_30 5.017838e-04
Rpv_26_30 p_26_30 p_26_31 5.017838e-04
Rph_26_31 p_26_31 p_27_31 5.017838e-04
Rpv_26_31 p_26_31 p_26_32 5.017838e-04
Rph_26_32 p_26_32 p_27_32 5.017838e-04
Rpv_26_32 p_26_32 p_26_33 5.017838e-04
Rph_26_33 p_26_33 p_27_33 5.017838e-04
Rpv_26_33 p_26_33 p_26_34 5.017838e-04
Rph_26_34 p_26_34 p_27_34 5.017838e-04
Rpv_26_34 p_26_34 p_26_35 5.017838e-04
Rph_26_35 p_26_35 p_27_35 5.017838e-04
Rpv_26_35 p_26_35 p_26_36 5.017838e-04
Rph_26_36 p_26_36 p_27_36 5.017838e-04
Rpv_26_36 p_26_36 p_26_37 5.017838e-04
Rph_26_37 p_26_37 p_27_37 5.017838e-04
Rpv_26_37 p_26_37 p_26_38 5.017838e-04
Rph_26_38 p_26_38 p_27_38 5.017838e-04
Rpv_26_38 p_26_38 p_26_39 5.017838e-04
Rph_26_39 p_26_39 p_27_39 5.017838e-04
Rpv_26_39 p_26_39 p_26_40 5.017838e-04
Rph_26_40 p_26_40 p_27_40 5.017838e-04
Rpv_26_40 p_26_40 p_26_41 5.017838e-04
Rph_26_41 p_26_41 p_27_41 5.017838e-04
Rpv_26_41 p_26_41 p_26_42 5.017838e-04
Rph_26_42 p_26_42 p_27_42 5.017838e-04
Rpv_26_42 p_26_42 p_26_43 5.017838e-04
Rph_26_43 p_26_43 p_27_43 5.017838e-04
Rpv_26_43 p_26_43 p_26_44 5.017838e-04
Rph_26_44 p_26_44 p_27_44 5.017838e-04
Rpv_26_44 p_26_44 p_26_45 5.017838e-04
Rph_26_45 p_26_45 p_27_45 5.017838e-04
Rpv_26_45 p_26_45 p_26_46 5.017838e-04
Rph_26_46 p_26_46 p_27_46 5.017838e-04
Rpv_26_46 p_26_46 p_26_47 5.017838e-04
Rph_26_47 p_26_47 p_27_47 5.017838e-04
Rpv_26_47 p_26_47 p_26_48 5.017838e-04
Rph_26_48 p_26_48 p_27_48 5.017838e-04
Rpv_26_48 p_26_48 p_26_49 5.017838e-04
Rph_26_49 p_26_49 p_27_49 5.017838e-04
Rpv_26_49 p_26_49 p_26_50 5.017838e-04
Rph_26_50 p_26_50 p_27_50 5.017838e-04
Rpv_26_50 p_26_50 p_26_51 5.017838e-04
Rph_26_51 p_26_51 p_27_51 5.017838e-04
Rpv_26_51 p_26_51 p_26_52 5.017838e-04
Rph_26_52 p_26_52 p_27_52 5.017838e-04
Rpv_26_52 p_26_52 p_26_53 5.017838e-04
Rph_26_53 p_26_53 p_27_53 5.017838e-04
Rpv_26_53 p_26_53 p_26_54 5.017838e-04
Rph_26_54 p_26_54 p_27_54 5.017838e-04
Rpv_26_54 p_26_54 p_26_55 5.017838e-04
Rph_26_55 p_26_55 p_27_55 5.017838e-04
Rpv_26_55 p_26_55 p_26_56 5.017838e-04
Rph_26_56 p_26_56 p_27_56 5.017838e-04
Rpv_26_56 p_26_56 p_26_57 5.017838e-04
Rph_26_57 p_26_57 p_27_57 5.017838e-04
Rpv_26_57 p_26_57 p_26_58 5.017838e-04
Rph_26_58 p_26_58 p_27_58 5.017838e-04
Rpv_26_58 p_26_58 p_26_59 5.017838e-04
Rph_26_59 p_26_59 p_27_59 5.017838e-04
Rpv_26_59 p_26_59 p_26_60 5.017838e-04
Rph_26_60 p_26_60 p_27_60 5.017838e-04
Rpv_26_60 p_26_60 p_26_61 5.017838e-04
Rph_26_61 p_26_61 p_27_61 5.017838e-04
Rpv_26_61 p_26_61 p_26_62 5.017838e-04
Rph_26_62 p_26_62 p_27_62 5.017838e-04
Rpv_26_62 p_26_62 p_26_63 5.017838e-04
Rph_26_63 p_26_63 p_27_63 5.017838e-04
Rpv_26_63 p_26_63 p_26_64 5.017838e-04
Rph_26_64 p_26_64 p_27_64 5.017838e-04
Rpv_26_64 p_26_64 p_26_65 5.017838e-04
Rph_26_65 p_26_65 p_27_65 5.017838e-04
Rpv_26_65 p_26_65 p_26_66 5.017838e-04
Rph_26_66 p_26_66 p_27_66 5.017838e-04
Rpv_26_66 p_26_66 p_26_67 5.017838e-04
Rph_26_67 p_26_67 p_27_67 5.017838e-04
Rpv_26_67 p_26_67 p_26_68 5.017838e-04
Rph_26_68 p_26_68 p_27_68 5.017838e-04
Rpv_26_68 p_26_68 p_26_69 5.017838e-04
Rph_26_69 p_26_69 p_27_69 5.017838e-04
Rpv_26_69 p_26_69 p_26_70 5.017838e-04
Rph_26_70 p_26_70 p_27_70 5.017838e-04
Rpv_26_70 p_26_70 p_26_71 5.017838e-04
Rph_26_71 p_26_71 p_27_71 5.017838e-04
Rph_27_0 p_27_0 p_28_0 5.017838e-04
Rpv_27_0 p_27_0 p_27_1 5.017838e-04
Rph_27_1 p_27_1 p_28_1 5.017838e-04
Rpv_27_1 p_27_1 p_27_2 5.017838e-04
Rph_27_2 p_27_2 p_28_2 5.017838e-04
Rpv_27_2 p_27_2 p_27_3 5.017838e-04
Rph_27_3 p_27_3 p_28_3 5.017838e-04
Rpv_27_3 p_27_3 p_27_4 5.017838e-04
Rph_27_4 p_27_4 p_28_4 5.017838e-04
Rpv_27_4 p_27_4 p_27_5 5.017838e-04
Rph_27_5 p_27_5 p_28_5 5.017838e-04
Rpv_27_5 p_27_5 p_27_6 5.017838e-04
Rph_27_6 p_27_6 p_28_6 5.017838e-04
Rpv_27_6 p_27_6 p_27_7 5.017838e-04
Rph_27_7 p_27_7 p_28_7 5.017838e-04
Rpv_27_7 p_27_7 p_27_8 5.017838e-04
Rph_27_8 p_27_8 p_28_8 5.017838e-04
Rpv_27_8 p_27_8 p_27_9 5.017838e-04
Rph_27_9 p_27_9 p_28_9 5.017838e-04
Rpv_27_9 p_27_9 p_27_10 5.017838e-04
Rph_27_10 p_27_10 p_28_10 5.017838e-04
Rpv_27_10 p_27_10 p_27_11 5.017838e-04
Rph_27_11 p_27_11 p_28_11 5.017838e-04
Rpv_27_11 p_27_11 p_27_12 5.017838e-04
Rph_27_12 p_27_12 p_28_12 5.017838e-04
Rpv_27_12 p_27_12 p_27_13 5.017838e-04
Rph_27_13 p_27_13 p_28_13 5.017838e-04
Rpv_27_13 p_27_13 p_27_14 5.017838e-04
Rph_27_14 p_27_14 p_28_14 5.017838e-04
Rpv_27_14 p_27_14 p_27_15 5.017838e-04
Rph_27_15 p_27_15 p_28_15 5.017838e-04
Rpv_27_15 p_27_15 p_27_16 5.017838e-04
Rph_27_16 p_27_16 p_28_16 5.017838e-04
Rpv_27_16 p_27_16 p_27_17 5.017838e-04
Rph_27_17 p_27_17 p_28_17 5.017838e-04
Rpv_27_17 p_27_17 p_27_18 5.017838e-04
Rph_27_18 p_27_18 p_28_18 5.017838e-04
Rpv_27_18 p_27_18 p_27_19 5.017838e-04
Rph_27_19 p_27_19 p_28_19 5.017838e-04
Rpv_27_19 p_27_19 p_27_20 5.017838e-04
Rph_27_20 p_27_20 p_28_20 5.017838e-04
Rpv_27_20 p_27_20 p_27_21 5.017838e-04
Rph_27_21 p_27_21 p_28_21 5.017838e-04
Rpv_27_21 p_27_21 p_27_22 5.017838e-04
Rph_27_22 p_27_22 p_28_22 5.017838e-04
Rpv_27_22 p_27_22 p_27_23 5.017838e-04
Rph_27_23 p_27_23 p_28_23 5.017838e-04
Rpv_27_23 p_27_23 p_27_24 5.017838e-04
Rph_27_24 p_27_24 p_28_24 5.017838e-04
Rpv_27_24 p_27_24 p_27_25 5.017838e-04
Rph_27_25 p_27_25 p_28_25 5.017838e-04
Rpv_27_25 p_27_25 p_27_26 5.017838e-04
Rph_27_26 p_27_26 p_28_26 5.017838e-04
Rpv_27_26 p_27_26 p_27_27 5.017838e-04
Rph_27_27 p_27_27 p_28_27 5.017838e-04
Rpv_27_27 p_27_27 p_27_28 5.017838e-04
Rph_27_28 p_27_28 p_28_28 5.017838e-04
Rpv_27_28 p_27_28 p_27_29 5.017838e-04
Rph_27_29 p_27_29 p_28_29 5.017838e-04
Rpv_27_29 p_27_29 p_27_30 5.017838e-04
Rph_27_30 p_27_30 p_28_30 5.017838e-04
Rpv_27_30 p_27_30 p_27_31 5.017838e-04
Rph_27_31 p_27_31 p_28_31 5.017838e-04
Rpv_27_31 p_27_31 p_27_32 5.017838e-04
Rph_27_32 p_27_32 p_28_32 5.017838e-04
Rpv_27_32 p_27_32 p_27_33 5.017838e-04
Rph_27_33 p_27_33 p_28_33 5.017838e-04
Rpv_27_33 p_27_33 p_27_34 5.017838e-04
Rph_27_34 p_27_34 p_28_34 5.017838e-04
Rpv_27_34 p_27_34 p_27_35 5.017838e-04
Rph_27_35 p_27_35 p_28_35 5.017838e-04
Rpv_27_35 p_27_35 p_27_36 5.017838e-04
Rph_27_36 p_27_36 p_28_36 5.017838e-04
Rpv_27_36 p_27_36 p_27_37 5.017838e-04
Rph_27_37 p_27_37 p_28_37 5.017838e-04
Rpv_27_37 p_27_37 p_27_38 5.017838e-04
Rph_27_38 p_27_38 p_28_38 5.017838e-04
Rpv_27_38 p_27_38 p_27_39 5.017838e-04
Rph_27_39 p_27_39 p_28_39 5.017838e-04
Rpv_27_39 p_27_39 p_27_40 5.017838e-04
Rph_27_40 p_27_40 p_28_40 5.017838e-04
Rpv_27_40 p_27_40 p_27_41 5.017838e-04
Rph_27_41 p_27_41 p_28_41 5.017838e-04
Rpv_27_41 p_27_41 p_27_42 5.017838e-04
Rph_27_42 p_27_42 p_28_42 5.017838e-04
Rpv_27_42 p_27_42 p_27_43 5.017838e-04
Rph_27_43 p_27_43 p_28_43 5.017838e-04
Rpv_27_43 p_27_43 p_27_44 5.017838e-04
Rph_27_44 p_27_44 p_28_44 5.017838e-04
Rpv_27_44 p_27_44 p_27_45 5.017838e-04
Rph_27_45 p_27_45 p_28_45 5.017838e-04
Rpv_27_45 p_27_45 p_27_46 5.017838e-04
Rph_27_46 p_27_46 p_28_46 5.017838e-04
Rpv_27_46 p_27_46 p_27_47 5.017838e-04
Rph_27_47 p_27_47 p_28_47 5.017838e-04
Rpv_27_47 p_27_47 p_27_48 5.017838e-04
Rph_27_48 p_27_48 p_28_48 5.017838e-04
Rpv_27_48 p_27_48 p_27_49 5.017838e-04
Rph_27_49 p_27_49 p_28_49 5.017838e-04
Rpv_27_49 p_27_49 p_27_50 5.017838e-04
Rph_27_50 p_27_50 p_28_50 5.017838e-04
Rpv_27_50 p_27_50 p_27_51 5.017838e-04
Rph_27_51 p_27_51 p_28_51 5.017838e-04
Rpv_27_51 p_27_51 p_27_52 5.017838e-04
Rph_27_52 p_27_52 p_28_52 5.017838e-04
Rpv_27_52 p_27_52 p_27_53 5.017838e-04
Rph_27_53 p_27_53 p_28_53 5.017838e-04
Rpv_27_53 p_27_53 p_27_54 5.017838e-04
Rph_27_54 p_27_54 p_28_54 5.017838e-04
Rpv_27_54 p_27_54 p_27_55 5.017838e-04
Rph_27_55 p_27_55 p_28_55 5.017838e-04
Rpv_27_55 p_27_55 p_27_56 5.017838e-04
Rph_27_56 p_27_56 p_28_56 5.017838e-04
Rpv_27_56 p_27_56 p_27_57 5.017838e-04
Rph_27_57 p_27_57 p_28_57 5.017838e-04
Rpv_27_57 p_27_57 p_27_58 5.017838e-04
Rph_27_58 p_27_58 p_28_58 5.017838e-04
Rpv_27_58 p_27_58 p_27_59 5.017838e-04
Rph_27_59 p_27_59 p_28_59 5.017838e-04
Rpv_27_59 p_27_59 p_27_60 5.017838e-04
Rph_27_60 p_27_60 p_28_60 5.017838e-04
Rpv_27_60 p_27_60 p_27_61 5.017838e-04
Rph_27_61 p_27_61 p_28_61 5.017838e-04
Rpv_27_61 p_27_61 p_27_62 5.017838e-04
Rph_27_62 p_27_62 p_28_62 5.017838e-04
Rpv_27_62 p_27_62 p_27_63 5.017838e-04
Rph_27_63 p_27_63 p_28_63 5.017838e-04
Rpv_27_63 p_27_63 p_27_64 5.017838e-04
Rph_27_64 p_27_64 p_28_64 5.017838e-04
Rpv_27_64 p_27_64 p_27_65 5.017838e-04
Rph_27_65 p_27_65 p_28_65 5.017838e-04
Rpv_27_65 p_27_65 p_27_66 5.017838e-04
Rph_27_66 p_27_66 p_28_66 5.017838e-04
Rpv_27_66 p_27_66 p_27_67 5.017838e-04
Rph_27_67 p_27_67 p_28_67 5.017838e-04
Rpv_27_67 p_27_67 p_27_68 5.017838e-04
Rph_27_68 p_27_68 p_28_68 5.017838e-04
Rpv_27_68 p_27_68 p_27_69 5.017838e-04
Rph_27_69 p_27_69 p_28_69 5.017838e-04
Rpv_27_69 p_27_69 p_27_70 5.017838e-04
Rph_27_70 p_27_70 p_28_70 5.017838e-04
Rpv_27_70 p_27_70 p_27_71 5.017838e-04
Rph_27_71 p_27_71 p_28_71 5.017838e-04
Rph_28_0 p_28_0 p_29_0 5.017838e-04
Rpv_28_0 p_28_0 p_28_1 5.017838e-04
Rph_28_1 p_28_1 p_29_1 5.017838e-04
Rpv_28_1 p_28_1 p_28_2 5.017838e-04
Rph_28_2 p_28_2 p_29_2 5.017838e-04
Rpv_28_2 p_28_2 p_28_3 5.017838e-04
Rph_28_3 p_28_3 p_29_3 5.017838e-04
Rpv_28_3 p_28_3 p_28_4 5.017838e-04
Rph_28_4 p_28_4 p_29_4 5.017838e-04
Rpv_28_4 p_28_4 p_28_5 5.017838e-04
Rph_28_5 p_28_5 p_29_5 5.017838e-04
Rpv_28_5 p_28_5 p_28_6 5.017838e-04
Rph_28_6 p_28_6 p_29_6 5.017838e-04
Rpv_28_6 p_28_6 p_28_7 5.017838e-04
Rph_28_7 p_28_7 p_29_7 5.017838e-04
Rpv_28_7 p_28_7 p_28_8 5.017838e-04
Rph_28_8 p_28_8 p_29_8 5.017838e-04
Rpv_28_8 p_28_8 p_28_9 5.017838e-04
Rph_28_9 p_28_9 p_29_9 5.017838e-04
Rpv_28_9 p_28_9 p_28_10 5.017838e-04
Rph_28_10 p_28_10 p_29_10 5.017838e-04
Rpv_28_10 p_28_10 p_28_11 5.017838e-04
Rph_28_11 p_28_11 p_29_11 5.017838e-04
Rpv_28_11 p_28_11 p_28_12 5.017838e-04
Rph_28_12 p_28_12 p_29_12 5.017838e-04
Rpv_28_12 p_28_12 p_28_13 5.017838e-04
Rph_28_13 p_28_13 p_29_13 5.017838e-04
Rpv_28_13 p_28_13 p_28_14 5.017838e-04
Rph_28_14 p_28_14 p_29_14 5.017838e-04
Rpv_28_14 p_28_14 p_28_15 5.017838e-04
Rph_28_15 p_28_15 p_29_15 5.017838e-04
Rpv_28_15 p_28_15 p_28_16 5.017838e-04
Rph_28_16 p_28_16 p_29_16 5.017838e-04
Rpv_28_16 p_28_16 p_28_17 5.017838e-04
Rph_28_17 p_28_17 p_29_17 5.017838e-04
Rpv_28_17 p_28_17 p_28_18 5.017838e-04
Rph_28_18 p_28_18 p_29_18 5.017838e-04
Rpv_28_18 p_28_18 p_28_19 5.017838e-04
Rph_28_19 p_28_19 p_29_19 5.017838e-04
Rpv_28_19 p_28_19 p_28_20 5.017838e-04
Rph_28_20 p_28_20 p_29_20 5.017838e-04
Rpv_28_20 p_28_20 p_28_21 5.017838e-04
Rph_28_21 p_28_21 p_29_21 5.017838e-04
Rpv_28_21 p_28_21 p_28_22 5.017838e-04
Rph_28_22 p_28_22 p_29_22 5.017838e-04
Rpv_28_22 p_28_22 p_28_23 5.017838e-04
Rph_28_23 p_28_23 p_29_23 5.017838e-04
Rpv_28_23 p_28_23 p_28_24 5.017838e-04
Rph_28_24 p_28_24 p_29_24 5.017838e-04
Rpv_28_24 p_28_24 p_28_25 5.017838e-04
Rph_28_25 p_28_25 p_29_25 5.017838e-04
Rpv_28_25 p_28_25 p_28_26 5.017838e-04
Rph_28_26 p_28_26 p_29_26 5.017838e-04
Rpv_28_26 p_28_26 p_28_27 5.017838e-04
Rph_28_27 p_28_27 p_29_27 5.017838e-04
Rpv_28_27 p_28_27 p_28_28 5.017838e-04
Rph_28_28 p_28_28 p_29_28 5.017838e-04
Rpv_28_28 p_28_28 p_28_29 5.017838e-04
Rph_28_29 p_28_29 p_29_29 5.017838e-04
Rpv_28_29 p_28_29 p_28_30 5.017838e-04
Rph_28_30 p_28_30 p_29_30 5.017838e-04
Rpv_28_30 p_28_30 p_28_31 5.017838e-04
Rph_28_31 p_28_31 p_29_31 5.017838e-04
Rpv_28_31 p_28_31 p_28_32 5.017838e-04
Rph_28_32 p_28_32 p_29_32 5.017838e-04
Rpv_28_32 p_28_32 p_28_33 5.017838e-04
Rph_28_33 p_28_33 p_29_33 5.017838e-04
Rpv_28_33 p_28_33 p_28_34 5.017838e-04
Rph_28_34 p_28_34 p_29_34 5.017838e-04
Rpv_28_34 p_28_34 p_28_35 5.017838e-04
Rph_28_35 p_28_35 p_29_35 5.017838e-04
Rpv_28_35 p_28_35 p_28_36 5.017838e-04
Rph_28_36 p_28_36 p_29_36 5.017838e-04
Rpv_28_36 p_28_36 p_28_37 5.017838e-04
Rph_28_37 p_28_37 p_29_37 5.017838e-04
Rpv_28_37 p_28_37 p_28_38 5.017838e-04
Rph_28_38 p_28_38 p_29_38 5.017838e-04
Rpv_28_38 p_28_38 p_28_39 5.017838e-04
Rph_28_39 p_28_39 p_29_39 5.017838e-04
Rpv_28_39 p_28_39 p_28_40 5.017838e-04
Rph_28_40 p_28_40 p_29_40 5.017838e-04
Rpv_28_40 p_28_40 p_28_41 5.017838e-04
Rph_28_41 p_28_41 p_29_41 5.017838e-04
Rpv_28_41 p_28_41 p_28_42 5.017838e-04
Rph_28_42 p_28_42 p_29_42 5.017838e-04
Rpv_28_42 p_28_42 p_28_43 5.017838e-04
Rph_28_43 p_28_43 p_29_43 5.017838e-04
Rpv_28_43 p_28_43 p_28_44 5.017838e-04
Rph_28_44 p_28_44 p_29_44 5.017838e-04
Rpv_28_44 p_28_44 p_28_45 5.017838e-04
Rph_28_45 p_28_45 p_29_45 5.017838e-04
Rpv_28_45 p_28_45 p_28_46 5.017838e-04
Rph_28_46 p_28_46 p_29_46 5.017838e-04
Rpv_28_46 p_28_46 p_28_47 5.017838e-04
Rph_28_47 p_28_47 p_29_47 5.017838e-04
Rpv_28_47 p_28_47 p_28_48 5.017838e-04
Rph_28_48 p_28_48 p_29_48 5.017838e-04
Rpv_28_48 p_28_48 p_28_49 5.017838e-04
Rph_28_49 p_28_49 p_29_49 5.017838e-04
Rpv_28_49 p_28_49 p_28_50 5.017838e-04
Rph_28_50 p_28_50 p_29_50 5.017838e-04
Rpv_28_50 p_28_50 p_28_51 5.017838e-04
Rph_28_51 p_28_51 p_29_51 5.017838e-04
Rpv_28_51 p_28_51 p_28_52 5.017838e-04
Rph_28_52 p_28_52 p_29_52 5.017838e-04
Rpv_28_52 p_28_52 p_28_53 5.017838e-04
Rph_28_53 p_28_53 p_29_53 5.017838e-04
Rpv_28_53 p_28_53 p_28_54 5.017838e-04
Rph_28_54 p_28_54 p_29_54 5.017838e-04
Rpv_28_54 p_28_54 p_28_55 5.017838e-04
Rph_28_55 p_28_55 p_29_55 5.017838e-04
Rpv_28_55 p_28_55 p_28_56 5.017838e-04
Rph_28_56 p_28_56 p_29_56 5.017838e-04
Rpv_28_56 p_28_56 p_28_57 5.017838e-04
Rph_28_57 p_28_57 p_29_57 5.017838e-04
Rpv_28_57 p_28_57 p_28_58 5.017838e-04
Rph_28_58 p_28_58 p_29_58 5.017838e-04
Rpv_28_58 p_28_58 p_28_59 5.017838e-04
Rph_28_59 p_28_59 p_29_59 5.017838e-04
Rpv_28_59 p_28_59 p_28_60 5.017838e-04
Rph_28_60 p_28_60 p_29_60 5.017838e-04
Rpv_28_60 p_28_60 p_28_61 5.017838e-04
Rph_28_61 p_28_61 p_29_61 5.017838e-04
Rpv_28_61 p_28_61 p_28_62 5.017838e-04
Rph_28_62 p_28_62 p_29_62 5.017838e-04
Rpv_28_62 p_28_62 p_28_63 5.017838e-04
Rph_28_63 p_28_63 p_29_63 5.017838e-04
Rpv_28_63 p_28_63 p_28_64 5.017838e-04
Rph_28_64 p_28_64 p_29_64 5.017838e-04
Rpv_28_64 p_28_64 p_28_65 5.017838e-04
Rph_28_65 p_28_65 p_29_65 5.017838e-04
Rpv_28_65 p_28_65 p_28_66 5.017838e-04
Rph_28_66 p_28_66 p_29_66 5.017838e-04
Rpv_28_66 p_28_66 p_28_67 5.017838e-04
Rph_28_67 p_28_67 p_29_67 5.017838e-04
Rpv_28_67 p_28_67 p_28_68 5.017838e-04
Rph_28_68 p_28_68 p_29_68 5.017838e-04
Rpv_28_68 p_28_68 p_28_69 5.017838e-04
Rph_28_69 p_28_69 p_29_69 5.017838e-04
Rpv_28_69 p_28_69 p_28_70 5.017838e-04
Rph_28_70 p_28_70 p_29_70 5.017838e-04
Rpv_28_70 p_28_70 p_28_71 5.017838e-04
Rph_28_71 p_28_71 p_29_71 5.017838e-04
Rph_29_0 p_29_0 p_30_0 5.017838e-04
Rpv_29_0 p_29_0 p_29_1 5.017838e-04
Rph_29_1 p_29_1 p_30_1 5.017838e-04
Rpv_29_1 p_29_1 p_29_2 5.017838e-04
Rph_29_2 p_29_2 p_30_2 5.017838e-04
Rpv_29_2 p_29_2 p_29_3 5.017838e-04
Rph_29_3 p_29_3 p_30_3 5.017838e-04
Rpv_29_3 p_29_3 p_29_4 5.017838e-04
Rph_29_4 p_29_4 p_30_4 5.017838e-04
Rpv_29_4 p_29_4 p_29_5 5.017838e-04
Rph_29_5 p_29_5 p_30_5 5.017838e-04
Rpv_29_5 p_29_5 p_29_6 5.017838e-04
Rph_29_6 p_29_6 p_30_6 5.017838e-04
Rpv_29_6 p_29_6 p_29_7 5.017838e-04
Rph_29_7 p_29_7 p_30_7 5.017838e-04
Rpv_29_7 p_29_7 p_29_8 5.017838e-04
Rph_29_8 p_29_8 p_30_8 5.017838e-04
Rpv_29_8 p_29_8 p_29_9 5.017838e-04
Rph_29_9 p_29_9 p_30_9 5.017838e-04
Rpv_29_9 p_29_9 p_29_10 5.017838e-04
Rph_29_10 p_29_10 p_30_10 5.017838e-04
Rpv_29_10 p_29_10 p_29_11 5.017838e-04
Rph_29_11 p_29_11 p_30_11 5.017838e-04
Rpv_29_11 p_29_11 p_29_12 5.017838e-04
Rph_29_12 p_29_12 p_30_12 5.017838e-04
Rpv_29_12 p_29_12 p_29_13 5.017838e-04
Rph_29_13 p_29_13 p_30_13 5.017838e-04
Rpv_29_13 p_29_13 p_29_14 5.017838e-04
Rph_29_14 p_29_14 p_30_14 5.017838e-04
Rpv_29_14 p_29_14 p_29_15 5.017838e-04
Rph_29_15 p_29_15 p_30_15 5.017838e-04
Rpv_29_15 p_29_15 p_29_16 5.017838e-04
Rph_29_16 p_29_16 p_30_16 5.017838e-04
Rpv_29_16 p_29_16 p_29_17 5.017838e-04
Rph_29_17 p_29_17 p_30_17 5.017838e-04
Rpv_29_17 p_29_17 p_29_18 5.017838e-04
Rph_29_18 p_29_18 p_30_18 5.017838e-04
Rpv_29_18 p_29_18 p_29_19 5.017838e-04
Rph_29_19 p_29_19 p_30_19 5.017838e-04
Rpv_29_19 p_29_19 p_29_20 5.017838e-04
Rph_29_20 p_29_20 p_30_20 5.017838e-04
Rpv_29_20 p_29_20 p_29_21 5.017838e-04
Rph_29_21 p_29_21 p_30_21 5.017838e-04
Rpv_29_21 p_29_21 p_29_22 5.017838e-04
Rph_29_22 p_29_22 p_30_22 5.017838e-04
Rpv_29_22 p_29_22 p_29_23 5.017838e-04
Rph_29_23 p_29_23 p_30_23 5.017838e-04
Rpv_29_23 p_29_23 p_29_24 5.017838e-04
Rph_29_24 p_29_24 p_30_24 5.017838e-04
Rpv_29_24 p_29_24 p_29_25 5.017838e-04
Rph_29_25 p_29_25 p_30_25 5.017838e-04
Rpv_29_25 p_29_25 p_29_26 5.017838e-04
Rph_29_26 p_29_26 p_30_26 5.017838e-04
Rpv_29_26 p_29_26 p_29_27 5.017838e-04
Rph_29_27 p_29_27 p_30_27 5.017838e-04
Rpv_29_27 p_29_27 p_29_28 5.017838e-04
Rph_29_28 p_29_28 p_30_28 5.017838e-04
Rpv_29_28 p_29_28 p_29_29 5.017838e-04
Rph_29_29 p_29_29 p_30_29 5.017838e-04
Rpv_29_29 p_29_29 p_29_30 5.017838e-04
Rph_29_30 p_29_30 p_30_30 5.017838e-04
Rpv_29_30 p_29_30 p_29_31 5.017838e-04
Rph_29_31 p_29_31 p_30_31 5.017838e-04
Rpv_29_31 p_29_31 p_29_32 5.017838e-04
Rph_29_32 p_29_32 p_30_32 5.017838e-04
Rpv_29_32 p_29_32 p_29_33 5.017838e-04
Rph_29_33 p_29_33 p_30_33 5.017838e-04
Rpv_29_33 p_29_33 p_29_34 5.017838e-04
Rph_29_34 p_29_34 p_30_34 5.017838e-04
Rpv_29_34 p_29_34 p_29_35 5.017838e-04
Rph_29_35 p_29_35 p_30_35 5.017838e-04
Rpv_29_35 p_29_35 p_29_36 5.017838e-04
Rph_29_36 p_29_36 p_30_36 5.017838e-04
Rpv_29_36 p_29_36 p_29_37 5.017838e-04
Rph_29_37 p_29_37 p_30_37 5.017838e-04
Rpv_29_37 p_29_37 p_29_38 5.017838e-04
Rph_29_38 p_29_38 p_30_38 5.017838e-04
Rpv_29_38 p_29_38 p_29_39 5.017838e-04
Rph_29_39 p_29_39 p_30_39 5.017838e-04
Rpv_29_39 p_29_39 p_29_40 5.017838e-04
Rph_29_40 p_29_40 p_30_40 5.017838e-04
Rpv_29_40 p_29_40 p_29_41 5.017838e-04
Rph_29_41 p_29_41 p_30_41 5.017838e-04
Rpv_29_41 p_29_41 p_29_42 5.017838e-04
Rph_29_42 p_29_42 p_30_42 5.017838e-04
Rpv_29_42 p_29_42 p_29_43 5.017838e-04
Rph_29_43 p_29_43 p_30_43 5.017838e-04
Rpv_29_43 p_29_43 p_29_44 5.017838e-04
Rph_29_44 p_29_44 p_30_44 5.017838e-04
Rpv_29_44 p_29_44 p_29_45 5.017838e-04
Rph_29_45 p_29_45 p_30_45 5.017838e-04
Rpv_29_45 p_29_45 p_29_46 5.017838e-04
Rph_29_46 p_29_46 p_30_46 5.017838e-04
Rpv_29_46 p_29_46 p_29_47 5.017838e-04
Rph_29_47 p_29_47 p_30_47 5.017838e-04
Rpv_29_47 p_29_47 p_29_48 5.017838e-04
Rph_29_48 p_29_48 p_30_48 5.017838e-04
Rpv_29_48 p_29_48 p_29_49 5.017838e-04
Rph_29_49 p_29_49 p_30_49 5.017838e-04
Rpv_29_49 p_29_49 p_29_50 5.017838e-04
Rph_29_50 p_29_50 p_30_50 5.017838e-04
Rpv_29_50 p_29_50 p_29_51 5.017838e-04
Rph_29_51 p_29_51 p_30_51 5.017838e-04
Rpv_29_51 p_29_51 p_29_52 5.017838e-04
Rph_29_52 p_29_52 p_30_52 5.017838e-04
Rpv_29_52 p_29_52 p_29_53 5.017838e-04
Rph_29_53 p_29_53 p_30_53 5.017838e-04
Rpv_29_53 p_29_53 p_29_54 5.017838e-04
Rph_29_54 p_29_54 p_30_54 5.017838e-04
Rpv_29_54 p_29_54 p_29_55 5.017838e-04
Rph_29_55 p_29_55 p_30_55 5.017838e-04
Rpv_29_55 p_29_55 p_29_56 5.017838e-04
Rph_29_56 p_29_56 p_30_56 5.017838e-04
Rpv_29_56 p_29_56 p_29_57 5.017838e-04
Rph_29_57 p_29_57 p_30_57 5.017838e-04
Rpv_29_57 p_29_57 p_29_58 5.017838e-04
Rph_29_58 p_29_58 p_30_58 5.017838e-04
Rpv_29_58 p_29_58 p_29_59 5.017838e-04
Rph_29_59 p_29_59 p_30_59 5.017838e-04
Rpv_29_59 p_29_59 p_29_60 5.017838e-04
Rph_29_60 p_29_60 p_30_60 5.017838e-04
Rpv_29_60 p_29_60 p_29_61 5.017838e-04
Rph_29_61 p_29_61 p_30_61 5.017838e-04
Rpv_29_61 p_29_61 p_29_62 5.017838e-04
Rph_29_62 p_29_62 p_30_62 5.017838e-04
Rpv_29_62 p_29_62 p_29_63 5.017838e-04
Rph_29_63 p_29_63 p_30_63 5.017838e-04
Rpv_29_63 p_29_63 p_29_64 5.017838e-04
Rph_29_64 p_29_64 p_30_64 5.017838e-04
Rpv_29_64 p_29_64 p_29_65 5.017838e-04
Rph_29_65 p_29_65 p_30_65 5.017838e-04
Rpv_29_65 p_29_65 p_29_66 5.017838e-04
Rph_29_66 p_29_66 p_30_66 5.017838e-04
Rpv_29_66 p_29_66 p_29_67 5.017838e-04
Rph_29_67 p_29_67 p_30_67 5.017838e-04
Rpv_29_67 p_29_67 p_29_68 5.017838e-04
Rph_29_68 p_29_68 p_30_68 5.017838e-04
Rpv_29_68 p_29_68 p_29_69 5.017838e-04
Rph_29_69 p_29_69 p_30_69 5.017838e-04
Rpv_29_69 p_29_69 p_29_70 5.017838e-04
Rph_29_70 p_29_70 p_30_70 5.017838e-04
Rpv_29_70 p_29_70 p_29_71 5.017838e-04
Rph_29_71 p_29_71 p_30_71 5.017838e-04
Rph_30_0 p_30_0 p_31_0 5.017838e-04
Rpv_30_0 p_30_0 p_30_1 5.017838e-04
Rph_30_1 p_30_1 p_31_1 5.017838e-04
Rpv_30_1 p_30_1 p_30_2 5.017838e-04
Rph_30_2 p_30_2 p_31_2 5.017838e-04
Rpv_30_2 p_30_2 p_30_3 5.017838e-04
Rph_30_3 p_30_3 p_31_3 5.017838e-04
Rpv_30_3 p_30_3 p_30_4 5.017838e-04
Rph_30_4 p_30_4 p_31_4 5.017838e-04
Rpv_30_4 p_30_4 p_30_5 5.017838e-04
Rph_30_5 p_30_5 p_31_5 5.017838e-04
Rpv_30_5 p_30_5 p_30_6 5.017838e-04
Rph_30_6 p_30_6 p_31_6 5.017838e-04
Rpv_30_6 p_30_6 p_30_7 5.017838e-04
Rph_30_7 p_30_7 p_31_7 5.017838e-04
Rpv_30_7 p_30_7 p_30_8 5.017838e-04
Rph_30_8 p_30_8 p_31_8 5.017838e-04
Rpv_30_8 p_30_8 p_30_9 5.017838e-04
Rph_30_9 p_30_9 p_31_9 5.017838e-04
Rpv_30_9 p_30_9 p_30_10 5.017838e-04
Rph_30_10 p_30_10 p_31_10 5.017838e-04
Rpv_30_10 p_30_10 p_30_11 5.017838e-04
Rph_30_11 p_30_11 p_31_11 5.017838e-04
Rpv_30_11 p_30_11 p_30_12 5.017838e-04
Rph_30_12 p_30_12 p_31_12 5.017838e-04
Rpv_30_12 p_30_12 p_30_13 5.017838e-04
Rph_30_13 p_30_13 p_31_13 5.017838e-04
Rpv_30_13 p_30_13 p_30_14 5.017838e-04
Rph_30_14 p_30_14 p_31_14 5.017838e-04
Rpv_30_14 p_30_14 p_30_15 5.017838e-04
Rph_30_15 p_30_15 p_31_15 5.017838e-04
Rpv_30_15 p_30_15 p_30_16 5.017838e-04
Rph_30_16 p_30_16 p_31_16 5.017838e-04
Rpv_30_16 p_30_16 p_30_17 5.017838e-04
Rph_30_17 p_30_17 p_31_17 5.017838e-04
Rpv_30_17 p_30_17 p_30_18 5.017838e-04
Rph_30_18 p_30_18 p_31_18 5.017838e-04
Rpv_30_18 p_30_18 p_30_19 5.017838e-04
Rph_30_19 p_30_19 p_31_19 5.017838e-04
Rpv_30_19 p_30_19 p_30_20 5.017838e-04
Rph_30_20 p_30_20 p_31_20 5.017838e-04
Rpv_30_20 p_30_20 p_30_21 5.017838e-04
Rph_30_21 p_30_21 p_31_21 5.017838e-04
Rpv_30_21 p_30_21 p_30_22 5.017838e-04
Rph_30_22 p_30_22 p_31_22 5.017838e-04
Rpv_30_22 p_30_22 p_30_23 5.017838e-04
Rph_30_23 p_30_23 p_31_23 5.017838e-04
Rpv_30_23 p_30_23 p_30_24 5.017838e-04
Rph_30_24 p_30_24 p_31_24 5.017838e-04
Rpv_30_24 p_30_24 p_30_25 5.017838e-04
Rph_30_25 p_30_25 p_31_25 5.017838e-04
Rpv_30_25 p_30_25 p_30_26 5.017838e-04
Rph_30_26 p_30_26 p_31_26 5.017838e-04
Rpv_30_26 p_30_26 p_30_27 5.017838e-04
Rph_30_27 p_30_27 p_31_27 5.017838e-04
Rpv_30_27 p_30_27 p_30_28 5.017838e-04
Rph_30_28 p_30_28 p_31_28 5.017838e-04
Rpv_30_28 p_30_28 p_30_29 5.017838e-04
Rph_30_29 p_30_29 p_31_29 5.017838e-04
Rpv_30_29 p_30_29 p_30_30 5.017838e-04
Rph_30_30 p_30_30 p_31_30 5.017838e-04
Rpv_30_30 p_30_30 p_30_31 5.017838e-04
Rph_30_31 p_30_31 p_31_31 5.017838e-04
Rpv_30_31 p_30_31 p_30_32 5.017838e-04
Rph_30_32 p_30_32 p_31_32 5.017838e-04
Rpv_30_32 p_30_32 p_30_33 5.017838e-04
Rph_30_33 p_30_33 p_31_33 5.017838e-04
Rpv_30_33 p_30_33 p_30_34 5.017838e-04
Rph_30_34 p_30_34 p_31_34 5.017838e-04
Rpv_30_34 p_30_34 p_30_35 5.017838e-04
Rph_30_35 p_30_35 p_31_35 5.017838e-04
Rpv_30_35 p_30_35 p_30_36 5.017838e-04
Rph_30_36 p_30_36 p_31_36 5.017838e-04
Rpv_30_36 p_30_36 p_30_37 5.017838e-04
Rph_30_37 p_30_37 p_31_37 5.017838e-04
Rpv_30_37 p_30_37 p_30_38 5.017838e-04
Rph_30_38 p_30_38 p_31_38 5.017838e-04
Rpv_30_38 p_30_38 p_30_39 5.017838e-04
Rph_30_39 p_30_39 p_31_39 5.017838e-04
Rpv_30_39 p_30_39 p_30_40 5.017838e-04
Rph_30_40 p_30_40 p_31_40 5.017838e-04
Rpv_30_40 p_30_40 p_30_41 5.017838e-04
Rph_30_41 p_30_41 p_31_41 5.017838e-04
Rpv_30_41 p_30_41 p_30_42 5.017838e-04
Rph_30_42 p_30_42 p_31_42 5.017838e-04
Rpv_30_42 p_30_42 p_30_43 5.017838e-04
Rph_30_43 p_30_43 p_31_43 5.017838e-04
Rpv_30_43 p_30_43 p_30_44 5.017838e-04
Rph_30_44 p_30_44 p_31_44 5.017838e-04
Rpv_30_44 p_30_44 p_30_45 5.017838e-04
Rph_30_45 p_30_45 p_31_45 5.017838e-04
Rpv_30_45 p_30_45 p_30_46 5.017838e-04
Rph_30_46 p_30_46 p_31_46 5.017838e-04
Rpv_30_46 p_30_46 p_30_47 5.017838e-04
Rph_30_47 p_30_47 p_31_47 5.017838e-04
Rpv_30_47 p_30_47 p_30_48 5.017838e-04
Rph_30_48 p_30_48 p_31_48 5.017838e-04
Rpv_30_48 p_30_48 p_30_49 5.017838e-04
Rph_30_49 p_30_49 p_31_49 5.017838e-04
Rpv_30_49 p_30_49 p_30_50 5.017838e-04
Rph_30_50 p_30_50 p_31_50 5.017838e-04
Rpv_30_50 p_30_50 p_30_51 5.017838e-04
Rph_30_51 p_30_51 p_31_51 5.017838e-04
Rpv_30_51 p_30_51 p_30_52 5.017838e-04
Rph_30_52 p_30_52 p_31_52 5.017838e-04
Rpv_30_52 p_30_52 p_30_53 5.017838e-04
Rph_30_53 p_30_53 p_31_53 5.017838e-04
Rpv_30_53 p_30_53 p_30_54 5.017838e-04
Rph_30_54 p_30_54 p_31_54 5.017838e-04
Rpv_30_54 p_30_54 p_30_55 5.017838e-04
Rph_30_55 p_30_55 p_31_55 5.017838e-04
Rpv_30_55 p_30_55 p_30_56 5.017838e-04
Rph_30_56 p_30_56 p_31_56 5.017838e-04
Rpv_30_56 p_30_56 p_30_57 5.017838e-04
Rph_30_57 p_30_57 p_31_57 5.017838e-04
Rpv_30_57 p_30_57 p_30_58 5.017838e-04
Rph_30_58 p_30_58 p_31_58 5.017838e-04
Rpv_30_58 p_30_58 p_30_59 5.017838e-04
Rph_30_59 p_30_59 p_31_59 5.017838e-04
Rpv_30_59 p_30_59 p_30_60 5.017838e-04
Rph_30_60 p_30_60 p_31_60 5.017838e-04
Rpv_30_60 p_30_60 p_30_61 5.017838e-04
Rph_30_61 p_30_61 p_31_61 5.017838e-04
Rpv_30_61 p_30_61 p_30_62 5.017838e-04
Rph_30_62 p_30_62 p_31_62 5.017838e-04
Rpv_30_62 p_30_62 p_30_63 5.017838e-04
Rph_30_63 p_30_63 p_31_63 5.017838e-04
Rpv_30_63 p_30_63 p_30_64 5.017838e-04
Rph_30_64 p_30_64 p_31_64 5.017838e-04
Rpv_30_64 p_30_64 p_30_65 5.017838e-04
Rph_30_65 p_30_65 p_31_65 5.017838e-04
Rpv_30_65 p_30_65 p_30_66 5.017838e-04
Rph_30_66 p_30_66 p_31_66 5.017838e-04
Rpv_30_66 p_30_66 p_30_67 5.017838e-04
Rph_30_67 p_30_67 p_31_67 5.017838e-04
Rpv_30_67 p_30_67 p_30_68 5.017838e-04
Rph_30_68 p_30_68 p_31_68 5.017838e-04
Rpv_30_68 p_30_68 p_30_69 5.017838e-04
Rph_30_69 p_30_69 p_31_69 5.017838e-04
Rpv_30_69 p_30_69 p_30_70 5.017838e-04
Rph_30_70 p_30_70 p_31_70 5.017838e-04
Rpv_30_70 p_30_70 p_30_71 5.017838e-04
Rph_30_71 p_30_71 p_31_71 5.017838e-04
Rph_31_0 p_31_0 p_32_0 5.017838e-04
Rpv_31_0 p_31_0 p_31_1 5.017838e-04
Rph_31_1 p_31_1 p_32_1 5.017838e-04
Rpv_31_1 p_31_1 p_31_2 5.017838e-04
Rph_31_2 p_31_2 p_32_2 5.017838e-04
Rpv_31_2 p_31_2 p_31_3 5.017838e-04
Rph_31_3 p_31_3 p_32_3 5.017838e-04
Rpv_31_3 p_31_3 p_31_4 5.017838e-04
Rph_31_4 p_31_4 p_32_4 5.017838e-04
Rpv_31_4 p_31_4 p_31_5 5.017838e-04
Rph_31_5 p_31_5 p_32_5 5.017838e-04
Rpv_31_5 p_31_5 p_31_6 5.017838e-04
Rph_31_6 p_31_6 p_32_6 5.017838e-04
Rpv_31_6 p_31_6 p_31_7 5.017838e-04
Rph_31_7 p_31_7 p_32_7 5.017838e-04
Rpv_31_7 p_31_7 p_31_8 5.017838e-04
Rph_31_8 p_31_8 p_32_8 5.017838e-04
Rpv_31_8 p_31_8 p_31_9 5.017838e-04
Rph_31_9 p_31_9 p_32_9 5.017838e-04
Rpv_31_9 p_31_9 p_31_10 5.017838e-04
Rph_31_10 p_31_10 p_32_10 5.017838e-04
Rpv_31_10 p_31_10 p_31_11 5.017838e-04
Rph_31_11 p_31_11 p_32_11 5.017838e-04
Rpv_31_11 p_31_11 p_31_12 5.017838e-04
Rph_31_12 p_31_12 p_32_12 5.017838e-04
Rpv_31_12 p_31_12 p_31_13 5.017838e-04
Rph_31_13 p_31_13 p_32_13 5.017838e-04
Rpv_31_13 p_31_13 p_31_14 5.017838e-04
Rph_31_14 p_31_14 p_32_14 5.017838e-04
Rpv_31_14 p_31_14 p_31_15 5.017838e-04
Rph_31_15 p_31_15 p_32_15 5.017838e-04
Rpv_31_15 p_31_15 p_31_16 5.017838e-04
Rph_31_16 p_31_16 p_32_16 5.017838e-04
Rpv_31_16 p_31_16 p_31_17 5.017838e-04
Rph_31_17 p_31_17 p_32_17 5.017838e-04
Rpv_31_17 p_31_17 p_31_18 5.017838e-04
Rph_31_18 p_31_18 p_32_18 5.017838e-04
Rpv_31_18 p_31_18 p_31_19 5.017838e-04
Rph_31_19 p_31_19 p_32_19 5.017838e-04
Rpv_31_19 p_31_19 p_31_20 5.017838e-04
Rph_31_20 p_31_20 p_32_20 5.017838e-04
Rpv_31_20 p_31_20 p_31_21 5.017838e-04
Rph_31_21 p_31_21 p_32_21 5.017838e-04
Rpv_31_21 p_31_21 p_31_22 5.017838e-04
Rph_31_22 p_31_22 p_32_22 5.017838e-04
Rpv_31_22 p_31_22 p_31_23 5.017838e-04
Rph_31_23 p_31_23 p_32_23 5.017838e-04
Rpv_31_23 p_31_23 p_31_24 5.017838e-04
Rph_31_24 p_31_24 p_32_24 5.017838e-04
Rpv_31_24 p_31_24 p_31_25 5.017838e-04
Rph_31_25 p_31_25 p_32_25 5.017838e-04
Rpv_31_25 p_31_25 p_31_26 5.017838e-04
Rph_31_26 p_31_26 p_32_26 5.017838e-04
Rpv_31_26 p_31_26 p_31_27 5.017838e-04
Rph_31_27 p_31_27 p_32_27 5.017838e-04
Rpv_31_27 p_31_27 p_31_28 5.017838e-04
Rph_31_28 p_31_28 p_32_28 5.017838e-04
Rpv_31_28 p_31_28 p_31_29 5.017838e-04
Rph_31_29 p_31_29 p_32_29 5.017838e-04
Rpv_31_29 p_31_29 p_31_30 5.017838e-04
Rph_31_30 p_31_30 p_32_30 5.017838e-04
Rpv_31_30 p_31_30 p_31_31 5.017838e-04
Rph_31_31 p_31_31 p_32_31 5.017838e-04
Rpv_31_31 p_31_31 p_31_32 5.017838e-04
Rph_31_32 p_31_32 p_32_32 5.017838e-04
Rpv_31_32 p_31_32 p_31_33 5.017838e-04
Rph_31_33 p_31_33 p_32_33 5.017838e-04
Rpv_31_33 p_31_33 p_31_34 5.017838e-04
Rph_31_34 p_31_34 p_32_34 5.017838e-04
Rpv_31_34 p_31_34 p_31_35 5.017838e-04
Rph_31_35 p_31_35 p_32_35 5.017838e-04
Rpv_31_35 p_31_35 p_31_36 5.017838e-04
Rph_31_36 p_31_36 p_32_36 5.017838e-04
Rpv_31_36 p_31_36 p_31_37 5.017838e-04
Rph_31_37 p_31_37 p_32_37 5.017838e-04
Rpv_31_37 p_31_37 p_31_38 5.017838e-04
Rph_31_38 p_31_38 p_32_38 5.017838e-04
Rpv_31_38 p_31_38 p_31_39 5.017838e-04
Rph_31_39 p_31_39 p_32_39 5.017838e-04
Rpv_31_39 p_31_39 p_31_40 5.017838e-04
Rph_31_40 p_31_40 p_32_40 5.017838e-04
Rpv_31_40 p_31_40 p_31_41 5.017838e-04
Rph_31_41 p_31_41 p_32_41 5.017838e-04
Rpv_31_41 p_31_41 p_31_42 5.017838e-04
Rph_31_42 p_31_42 p_32_42 5.017838e-04
Rpv_31_42 p_31_42 p_31_43 5.017838e-04
Rph_31_43 p_31_43 p_32_43 5.017838e-04
Rpv_31_43 p_31_43 p_31_44 5.017838e-04
Rph_31_44 p_31_44 p_32_44 5.017838e-04
Rpv_31_44 p_31_44 p_31_45 5.017838e-04
Rph_31_45 p_31_45 p_32_45 5.017838e-04
Rpv_31_45 p_31_45 p_31_46 5.017838e-04
Rph_31_46 p_31_46 p_32_46 5.017838e-04
Rpv_31_46 p_31_46 p_31_47 5.017838e-04
Rph_31_47 p_31_47 p_32_47 5.017838e-04
Rpv_31_47 p_31_47 p_31_48 5.017838e-04
Rph_31_48 p_31_48 p_32_48 5.017838e-04
Rpv_31_48 p_31_48 p_31_49 5.017838e-04
Rph_31_49 p_31_49 p_32_49 5.017838e-04
Rpv_31_49 p_31_49 p_31_50 5.017838e-04
Rph_31_50 p_31_50 p_32_50 5.017838e-04
Rpv_31_50 p_31_50 p_31_51 5.017838e-04
Rph_31_51 p_31_51 p_32_51 5.017838e-04
Rpv_31_51 p_31_51 p_31_52 5.017838e-04
Rph_31_52 p_31_52 p_32_52 5.017838e-04
Rpv_31_52 p_31_52 p_31_53 5.017838e-04
Rph_31_53 p_31_53 p_32_53 5.017838e-04
Rpv_31_53 p_31_53 p_31_54 5.017838e-04
Rph_31_54 p_31_54 p_32_54 5.017838e-04
Rpv_31_54 p_31_54 p_31_55 5.017838e-04
Rph_31_55 p_31_55 p_32_55 5.017838e-04
Rpv_31_55 p_31_55 p_31_56 5.017838e-04
Rph_31_56 p_31_56 p_32_56 5.017838e-04
Rpv_31_56 p_31_56 p_31_57 5.017838e-04
Rph_31_57 p_31_57 p_32_57 5.017838e-04
Rpv_31_57 p_31_57 p_31_58 5.017838e-04
Rph_31_58 p_31_58 p_32_58 5.017838e-04
Rpv_31_58 p_31_58 p_31_59 5.017838e-04
Rph_31_59 p_31_59 p_32_59 5.017838e-04
Rpv_31_59 p_31_59 p_31_60 5.017838e-04
Rph_31_60 p_31_60 p_32_60 5.017838e-04
Rpv_31_60 p_31_60 p_31_61 5.017838e-04
Rph_31_61 p_31_61 p_32_61 5.017838e-04
Rpv_31_61 p_31_61 p_31_62 5.017838e-04
Rph_31_62 p_31_62 p_32_62 5.017838e-04
Rpv_31_62 p_31_62 p_31_63 5.017838e-04
Rph_31_63 p_31_63 p_32_63 5.017838e-04
Rpv_31_63 p_31_63 p_31_64 5.017838e-04
Rph_31_64 p_31_64 p_32_64 5.017838e-04
Rpv_31_64 p_31_64 p_31_65 5.017838e-04
Rph_31_65 p_31_65 p_32_65 5.017838e-04
Rpv_31_65 p_31_65 p_31_66 5.017838e-04
Rph_31_66 p_31_66 p_32_66 5.017838e-04
Rpv_31_66 p_31_66 p_31_67 5.017838e-04
Rph_31_67 p_31_67 p_32_67 5.017838e-04
Rpv_31_67 p_31_67 p_31_68 5.017838e-04
Rph_31_68 p_31_68 p_32_68 5.017838e-04
Rpv_31_68 p_31_68 p_31_69 5.017838e-04
Rph_31_69 p_31_69 p_32_69 5.017838e-04
Rpv_31_69 p_31_69 p_31_70 5.017838e-04
Rph_31_70 p_31_70 p_32_70 5.017838e-04
Rpv_31_70 p_31_70 p_31_71 5.017838e-04
Rph_31_71 p_31_71 p_32_71 5.017838e-04
Rph_32_0 p_32_0 p_33_0 5.017838e-04
Rpv_32_0 p_32_0 p_32_1 5.017838e-04
Rph_32_1 p_32_1 p_33_1 5.017838e-04
Rpv_32_1 p_32_1 p_32_2 5.017838e-04
Rph_32_2 p_32_2 p_33_2 5.017838e-04
Rpv_32_2 p_32_2 p_32_3 5.017838e-04
Rph_32_3 p_32_3 p_33_3 5.017838e-04
Rpv_32_3 p_32_3 p_32_4 5.017838e-04
Rph_32_4 p_32_4 p_33_4 5.017838e-04
Rpv_32_4 p_32_4 p_32_5 5.017838e-04
Rph_32_5 p_32_5 p_33_5 5.017838e-04
Rpv_32_5 p_32_5 p_32_6 5.017838e-04
Rph_32_6 p_32_6 p_33_6 5.017838e-04
Rpv_32_6 p_32_6 p_32_7 5.017838e-04
Rph_32_7 p_32_7 p_33_7 5.017838e-04
Rpv_32_7 p_32_7 p_32_8 5.017838e-04
Rph_32_8 p_32_8 p_33_8 5.017838e-04
Rpv_32_8 p_32_8 p_32_9 5.017838e-04
Rph_32_9 p_32_9 p_33_9 5.017838e-04
Rpv_32_9 p_32_9 p_32_10 5.017838e-04
Rph_32_10 p_32_10 p_33_10 5.017838e-04
Rpv_32_10 p_32_10 p_32_11 5.017838e-04
Rph_32_11 p_32_11 p_33_11 5.017838e-04
Rpv_32_11 p_32_11 p_32_12 5.017838e-04
Rph_32_12 p_32_12 p_33_12 5.017838e-04
Rpv_32_12 p_32_12 p_32_13 5.017838e-04
Rph_32_13 p_32_13 p_33_13 5.017838e-04
Rpv_32_13 p_32_13 p_32_14 5.017838e-04
Rph_32_14 p_32_14 p_33_14 5.017838e-04
Rpv_32_14 p_32_14 p_32_15 5.017838e-04
Rph_32_15 p_32_15 p_33_15 5.017838e-04
Rpv_32_15 p_32_15 p_32_16 5.017838e-04
Rph_32_16 p_32_16 p_33_16 5.017838e-04
Rpv_32_16 p_32_16 p_32_17 5.017838e-04
Rph_32_17 p_32_17 p_33_17 5.017838e-04
Rpv_32_17 p_32_17 p_32_18 5.017838e-04
Rph_32_18 p_32_18 p_33_18 5.017838e-04
Rpv_32_18 p_32_18 p_32_19 5.017838e-04
Rph_32_19 p_32_19 p_33_19 5.017838e-04
Rpv_32_19 p_32_19 p_32_20 5.017838e-04
Rph_32_20 p_32_20 p_33_20 5.017838e-04
Rpv_32_20 p_32_20 p_32_21 5.017838e-04
Rph_32_21 p_32_21 p_33_21 5.017838e-04
Rpv_32_21 p_32_21 p_32_22 5.017838e-04
Rph_32_22 p_32_22 p_33_22 5.017838e-04
Rpv_32_22 p_32_22 p_32_23 5.017838e-04
Rph_32_23 p_32_23 p_33_23 5.017838e-04
Rpv_32_23 p_32_23 p_32_24 5.017838e-04
Rph_32_24 p_32_24 p_33_24 5.017838e-04
Rpv_32_24 p_32_24 p_32_25 5.017838e-04
Rph_32_25 p_32_25 p_33_25 5.017838e-04
Rpv_32_25 p_32_25 p_32_26 5.017838e-04
Rph_32_26 p_32_26 p_33_26 5.017838e-04
Rpv_32_26 p_32_26 p_32_27 5.017838e-04
Rph_32_27 p_32_27 p_33_27 5.017838e-04
Rpv_32_27 p_32_27 p_32_28 5.017838e-04
Rph_32_28 p_32_28 p_33_28 5.017838e-04
Rpv_32_28 p_32_28 p_32_29 5.017838e-04
Rph_32_29 p_32_29 p_33_29 5.017838e-04
Rpv_32_29 p_32_29 p_32_30 5.017838e-04
Rph_32_30 p_32_30 p_33_30 5.017838e-04
Rpv_32_30 p_32_30 p_32_31 5.017838e-04
Rph_32_31 p_32_31 p_33_31 5.017838e-04
Rpv_32_31 p_32_31 p_32_32 5.017838e-04
Rph_32_32 p_32_32 p_33_32 5.017838e-04
Rpv_32_32 p_32_32 p_32_33 5.017838e-04
Rph_32_33 p_32_33 p_33_33 5.017838e-04
Rpv_32_33 p_32_33 p_32_34 5.017838e-04
Rph_32_34 p_32_34 p_33_34 5.017838e-04
Rpv_32_34 p_32_34 p_32_35 5.017838e-04
Rph_32_35 p_32_35 p_33_35 5.017838e-04
Rpv_32_35 p_32_35 p_32_36 5.017838e-04
Rph_32_36 p_32_36 p_33_36 5.017838e-04
Rpv_32_36 p_32_36 p_32_37 5.017838e-04
Rph_32_37 p_32_37 p_33_37 5.017838e-04
Rpv_32_37 p_32_37 p_32_38 5.017838e-04
Rph_32_38 p_32_38 p_33_38 5.017838e-04
Rpv_32_38 p_32_38 p_32_39 5.017838e-04
Rph_32_39 p_32_39 p_33_39 5.017838e-04
Rpv_32_39 p_32_39 p_32_40 5.017838e-04
Rph_32_40 p_32_40 p_33_40 5.017838e-04
Rpv_32_40 p_32_40 p_32_41 5.017838e-04
Rph_32_41 p_32_41 p_33_41 5.017838e-04
Rpv_32_41 p_32_41 p_32_42 5.017838e-04
Rph_32_42 p_32_42 p_33_42 5.017838e-04
Rpv_32_42 p_32_42 p_32_43 5.017838e-04
Rph_32_43 p_32_43 p_33_43 5.017838e-04
Rpv_32_43 p_32_43 p_32_44 5.017838e-04
Rph_32_44 p_32_44 p_33_44 5.017838e-04
Rpv_32_44 p_32_44 p_32_45 5.017838e-04
Rph_32_45 p_32_45 p_33_45 5.017838e-04
Rpv_32_45 p_32_45 p_32_46 5.017838e-04
Rph_32_46 p_32_46 p_33_46 5.017838e-04
Rpv_32_46 p_32_46 p_32_47 5.017838e-04
Rph_32_47 p_32_47 p_33_47 5.017838e-04
Rpv_32_47 p_32_47 p_32_48 5.017838e-04
Rph_32_48 p_32_48 p_33_48 5.017838e-04
Rpv_32_48 p_32_48 p_32_49 5.017838e-04
Rph_32_49 p_32_49 p_33_49 5.017838e-04
Rpv_32_49 p_32_49 p_32_50 5.017838e-04
Rph_32_50 p_32_50 p_33_50 5.017838e-04
Rpv_32_50 p_32_50 p_32_51 5.017838e-04
Rph_32_51 p_32_51 p_33_51 5.017838e-04
Rpv_32_51 p_32_51 p_32_52 5.017838e-04
Rph_32_52 p_32_52 p_33_52 5.017838e-04
Rpv_32_52 p_32_52 p_32_53 5.017838e-04
Rph_32_53 p_32_53 p_33_53 5.017838e-04
Rpv_32_53 p_32_53 p_32_54 5.017838e-04
Rph_32_54 p_32_54 p_33_54 5.017838e-04
Rpv_32_54 p_32_54 p_32_55 5.017838e-04
Rph_32_55 p_32_55 p_33_55 5.017838e-04
Rpv_32_55 p_32_55 p_32_56 5.017838e-04
Rph_32_56 p_32_56 p_33_56 5.017838e-04
Rpv_32_56 p_32_56 p_32_57 5.017838e-04
Rph_32_57 p_32_57 p_33_57 5.017838e-04
Rpv_32_57 p_32_57 p_32_58 5.017838e-04
Rph_32_58 p_32_58 p_33_58 5.017838e-04
Rpv_32_58 p_32_58 p_32_59 5.017838e-04
Rph_32_59 p_32_59 p_33_59 5.017838e-04
Rpv_32_59 p_32_59 p_32_60 5.017838e-04
Rph_32_60 p_32_60 p_33_60 5.017838e-04
Rpv_32_60 p_32_60 p_32_61 5.017838e-04
Rph_32_61 p_32_61 p_33_61 5.017838e-04
Rpv_32_61 p_32_61 p_32_62 5.017838e-04
Rph_32_62 p_32_62 p_33_62 5.017838e-04
Rpv_32_62 p_32_62 p_32_63 5.017838e-04
Rph_32_63 p_32_63 p_33_63 5.017838e-04
Rpv_32_63 p_32_63 p_32_64 5.017838e-04
Rph_32_64 p_32_64 p_33_64 5.017838e-04
Rpv_32_64 p_32_64 p_32_65 5.017838e-04
Rph_32_65 p_32_65 p_33_65 5.017838e-04
Rpv_32_65 p_32_65 p_32_66 5.017838e-04
Rph_32_66 p_32_66 p_33_66 5.017838e-04
Rpv_32_66 p_32_66 p_32_67 5.017838e-04
Rph_32_67 p_32_67 p_33_67 5.017838e-04
Rpv_32_67 p_32_67 p_32_68 5.017838e-04
Rph_32_68 p_32_68 p_33_68 5.017838e-04
Rpv_32_68 p_32_68 p_32_69 5.017838e-04
Rph_32_69 p_32_69 p_33_69 5.017838e-04
Rpv_32_69 p_32_69 p_32_70 5.017838e-04
Rph_32_70 p_32_70 p_33_70 5.017838e-04
Rpv_32_70 p_32_70 p_32_71 5.017838e-04
Rph_32_71 p_32_71 p_33_71 5.017838e-04
Rph_33_0 p_33_0 p_34_0 5.017838e-04
Rpv_33_0 p_33_0 p_33_1 5.017838e-04
Rph_33_1 p_33_1 p_34_1 5.017838e-04
Rpv_33_1 p_33_1 p_33_2 5.017838e-04
Rph_33_2 p_33_2 p_34_2 5.017838e-04
Rpv_33_2 p_33_2 p_33_3 5.017838e-04
Rph_33_3 p_33_3 p_34_3 5.017838e-04
Rpv_33_3 p_33_3 p_33_4 5.017838e-04
Rph_33_4 p_33_4 p_34_4 5.017838e-04
Rpv_33_4 p_33_4 p_33_5 5.017838e-04
Rph_33_5 p_33_5 p_34_5 5.017838e-04
Rpv_33_5 p_33_5 p_33_6 5.017838e-04
Rph_33_6 p_33_6 p_34_6 5.017838e-04
Rpv_33_6 p_33_6 p_33_7 5.017838e-04
Rph_33_7 p_33_7 p_34_7 5.017838e-04
Rpv_33_7 p_33_7 p_33_8 5.017838e-04
Rph_33_8 p_33_8 p_34_8 5.017838e-04
Rpv_33_8 p_33_8 p_33_9 5.017838e-04
Rph_33_9 p_33_9 p_34_9 5.017838e-04
Rpv_33_9 p_33_9 p_33_10 5.017838e-04
Rph_33_10 p_33_10 p_34_10 5.017838e-04
Rpv_33_10 p_33_10 p_33_11 5.017838e-04
Rph_33_11 p_33_11 p_34_11 5.017838e-04
Rpv_33_11 p_33_11 p_33_12 5.017838e-04
Rph_33_12 p_33_12 p_34_12 5.017838e-04
Rpv_33_12 p_33_12 p_33_13 5.017838e-04
Rph_33_13 p_33_13 p_34_13 5.017838e-04
Rpv_33_13 p_33_13 p_33_14 5.017838e-04
Rph_33_14 p_33_14 p_34_14 5.017838e-04
Rpv_33_14 p_33_14 p_33_15 5.017838e-04
Rph_33_15 p_33_15 p_34_15 5.017838e-04
Rpv_33_15 p_33_15 p_33_16 5.017838e-04
Rph_33_16 p_33_16 p_34_16 5.017838e-04
Rpv_33_16 p_33_16 p_33_17 5.017838e-04
Rph_33_17 p_33_17 p_34_17 5.017838e-04
Rpv_33_17 p_33_17 p_33_18 5.017838e-04
Rph_33_18 p_33_18 p_34_18 5.017838e-04
Rpv_33_18 p_33_18 p_33_19 5.017838e-04
Rph_33_19 p_33_19 p_34_19 5.017838e-04
Rpv_33_19 p_33_19 p_33_20 5.017838e-04
Rph_33_20 p_33_20 p_34_20 5.017838e-04
Rpv_33_20 p_33_20 p_33_21 5.017838e-04
Rph_33_21 p_33_21 p_34_21 5.017838e-04
Rpv_33_21 p_33_21 p_33_22 5.017838e-04
Rph_33_22 p_33_22 p_34_22 5.017838e-04
Rpv_33_22 p_33_22 p_33_23 5.017838e-04
Rph_33_23 p_33_23 p_34_23 5.017838e-04
Rpv_33_23 p_33_23 p_33_24 5.017838e-04
Rph_33_24 p_33_24 p_34_24 5.017838e-04
Rpv_33_24 p_33_24 p_33_25 5.017838e-04
Rph_33_25 p_33_25 p_34_25 5.017838e-04
Rpv_33_25 p_33_25 p_33_26 5.017838e-04
Rph_33_26 p_33_26 p_34_26 5.017838e-04
Rpv_33_26 p_33_26 p_33_27 5.017838e-04
Rph_33_27 p_33_27 p_34_27 5.017838e-04
Rpv_33_27 p_33_27 p_33_28 5.017838e-04
Rph_33_28 p_33_28 p_34_28 5.017838e-04
Rpv_33_28 p_33_28 p_33_29 5.017838e-04
Rph_33_29 p_33_29 p_34_29 5.017838e-04
Rpv_33_29 p_33_29 p_33_30 5.017838e-04
Rph_33_30 p_33_30 p_34_30 5.017838e-04
Rpv_33_30 p_33_30 p_33_31 5.017838e-04
Rph_33_31 p_33_31 p_34_31 5.017838e-04
Rpv_33_31 p_33_31 p_33_32 5.017838e-04
Rph_33_32 p_33_32 p_34_32 5.017838e-04
Rpv_33_32 p_33_32 p_33_33 5.017838e-04
Rph_33_33 p_33_33 p_34_33 5.017838e-04
Rpv_33_33 p_33_33 p_33_34 5.017838e-04
Rph_33_34 p_33_34 p_34_34 5.017838e-04
Rpv_33_34 p_33_34 p_33_35 5.017838e-04
Rph_33_35 p_33_35 p_34_35 5.017838e-04
Rpv_33_35 p_33_35 p_33_36 5.017838e-04
Rph_33_36 p_33_36 p_34_36 5.017838e-04
Rpv_33_36 p_33_36 p_33_37 5.017838e-04
Rph_33_37 p_33_37 p_34_37 5.017838e-04
Rpv_33_37 p_33_37 p_33_38 5.017838e-04
Rph_33_38 p_33_38 p_34_38 5.017838e-04
Rpv_33_38 p_33_38 p_33_39 5.017838e-04
Rph_33_39 p_33_39 p_34_39 5.017838e-04
Rpv_33_39 p_33_39 p_33_40 5.017838e-04
Rph_33_40 p_33_40 p_34_40 5.017838e-04
Rpv_33_40 p_33_40 p_33_41 5.017838e-04
Rph_33_41 p_33_41 p_34_41 5.017838e-04
Rpv_33_41 p_33_41 p_33_42 5.017838e-04
Rph_33_42 p_33_42 p_34_42 5.017838e-04
Rpv_33_42 p_33_42 p_33_43 5.017838e-04
Rph_33_43 p_33_43 p_34_43 5.017838e-04
Rpv_33_43 p_33_43 p_33_44 5.017838e-04
Rph_33_44 p_33_44 p_34_44 5.017838e-04
Rpv_33_44 p_33_44 p_33_45 5.017838e-04
Rph_33_45 p_33_45 p_34_45 5.017838e-04
Rpv_33_45 p_33_45 p_33_46 5.017838e-04
Rph_33_46 p_33_46 p_34_46 5.017838e-04
Rpv_33_46 p_33_46 p_33_47 5.017838e-04
Rph_33_47 p_33_47 p_34_47 5.017838e-04
Rpv_33_47 p_33_47 p_33_48 5.017838e-04
Rph_33_48 p_33_48 p_34_48 5.017838e-04
Rpv_33_48 p_33_48 p_33_49 5.017838e-04
Rph_33_49 p_33_49 p_34_49 5.017838e-04
Rpv_33_49 p_33_49 p_33_50 5.017838e-04
Rph_33_50 p_33_50 p_34_50 5.017838e-04
Rpv_33_50 p_33_50 p_33_51 5.017838e-04
Rph_33_51 p_33_51 p_34_51 5.017838e-04
Rpv_33_51 p_33_51 p_33_52 5.017838e-04
Rph_33_52 p_33_52 p_34_52 5.017838e-04
Rpv_33_52 p_33_52 p_33_53 5.017838e-04
Rph_33_53 p_33_53 p_34_53 5.017838e-04
Rpv_33_53 p_33_53 p_33_54 5.017838e-04
Rph_33_54 p_33_54 p_34_54 5.017838e-04
Rpv_33_54 p_33_54 p_33_55 5.017838e-04
Rph_33_55 p_33_55 p_34_55 5.017838e-04
Rpv_33_55 p_33_55 p_33_56 5.017838e-04
Rph_33_56 p_33_56 p_34_56 5.017838e-04
Rpv_33_56 p_33_56 p_33_57 5.017838e-04
Rph_33_57 p_33_57 p_34_57 5.017838e-04
Rpv_33_57 p_33_57 p_33_58 5.017838e-04
Rph_33_58 p_33_58 p_34_58 5.017838e-04
Rpv_33_58 p_33_58 p_33_59 5.017838e-04
Rph_33_59 p_33_59 p_34_59 5.017838e-04
Rpv_33_59 p_33_59 p_33_60 5.017838e-04
Rph_33_60 p_33_60 p_34_60 5.017838e-04
Rpv_33_60 p_33_60 p_33_61 5.017838e-04
Rph_33_61 p_33_61 p_34_61 5.017838e-04
Rpv_33_61 p_33_61 p_33_62 5.017838e-04
Rph_33_62 p_33_62 p_34_62 5.017838e-04
Rpv_33_62 p_33_62 p_33_63 5.017838e-04
Rph_33_63 p_33_63 p_34_63 5.017838e-04
Rpv_33_63 p_33_63 p_33_64 5.017838e-04
Rph_33_64 p_33_64 p_34_64 5.017838e-04
Rpv_33_64 p_33_64 p_33_65 5.017838e-04
Rph_33_65 p_33_65 p_34_65 5.017838e-04
Rpv_33_65 p_33_65 p_33_66 5.017838e-04
Rph_33_66 p_33_66 p_34_66 5.017838e-04
Rpv_33_66 p_33_66 p_33_67 5.017838e-04
Rph_33_67 p_33_67 p_34_67 5.017838e-04
Rpv_33_67 p_33_67 p_33_68 5.017838e-04
Rph_33_68 p_33_68 p_34_68 5.017838e-04
Rpv_33_68 p_33_68 p_33_69 5.017838e-04
Rph_33_69 p_33_69 p_34_69 5.017838e-04
Rpv_33_69 p_33_69 p_33_70 5.017838e-04
Rph_33_70 p_33_70 p_34_70 5.017838e-04
Rpv_33_70 p_33_70 p_33_71 5.017838e-04
Rph_33_71 p_33_71 p_34_71 5.017838e-04
Rph_34_0 p_34_0 p_35_0 5.017838e-04
Rpv_34_0 p_34_0 p_34_1 5.017838e-04
Rph_34_1 p_34_1 p_35_1 5.017838e-04
Rpv_34_1 p_34_1 p_34_2 5.017838e-04
Rph_34_2 p_34_2 p_35_2 5.017838e-04
Rpv_34_2 p_34_2 p_34_3 5.017838e-04
Rph_34_3 p_34_3 p_35_3 5.017838e-04
Rpv_34_3 p_34_3 p_34_4 5.017838e-04
Rph_34_4 p_34_4 p_35_4 5.017838e-04
Rpv_34_4 p_34_4 p_34_5 5.017838e-04
Rph_34_5 p_34_5 p_35_5 5.017838e-04
Rpv_34_5 p_34_5 p_34_6 5.017838e-04
Rph_34_6 p_34_6 p_35_6 5.017838e-04
Rpv_34_6 p_34_6 p_34_7 5.017838e-04
Rph_34_7 p_34_7 p_35_7 5.017838e-04
Rpv_34_7 p_34_7 p_34_8 5.017838e-04
Rph_34_8 p_34_8 p_35_8 5.017838e-04
Rpv_34_8 p_34_8 p_34_9 5.017838e-04
Rph_34_9 p_34_9 p_35_9 5.017838e-04
Rpv_34_9 p_34_9 p_34_10 5.017838e-04
Rph_34_10 p_34_10 p_35_10 5.017838e-04
Rpv_34_10 p_34_10 p_34_11 5.017838e-04
Rph_34_11 p_34_11 p_35_11 5.017838e-04
Rpv_34_11 p_34_11 p_34_12 5.017838e-04
Rph_34_12 p_34_12 p_35_12 5.017838e-04
Rpv_34_12 p_34_12 p_34_13 5.017838e-04
Rph_34_13 p_34_13 p_35_13 5.017838e-04
Rpv_34_13 p_34_13 p_34_14 5.017838e-04
Rph_34_14 p_34_14 p_35_14 5.017838e-04
Rpv_34_14 p_34_14 p_34_15 5.017838e-04
Rph_34_15 p_34_15 p_35_15 5.017838e-04
Rpv_34_15 p_34_15 p_34_16 5.017838e-04
Rph_34_16 p_34_16 p_35_16 5.017838e-04
Rpv_34_16 p_34_16 p_34_17 5.017838e-04
Rph_34_17 p_34_17 p_35_17 5.017838e-04
Rpv_34_17 p_34_17 p_34_18 5.017838e-04
Rph_34_18 p_34_18 p_35_18 5.017838e-04
Rpv_34_18 p_34_18 p_34_19 5.017838e-04
Rph_34_19 p_34_19 p_35_19 5.017838e-04
Rpv_34_19 p_34_19 p_34_20 5.017838e-04
Rph_34_20 p_34_20 p_35_20 5.017838e-04
Rpv_34_20 p_34_20 p_34_21 5.017838e-04
Rph_34_21 p_34_21 p_35_21 5.017838e-04
Rpv_34_21 p_34_21 p_34_22 5.017838e-04
Rph_34_22 p_34_22 p_35_22 5.017838e-04
Rpv_34_22 p_34_22 p_34_23 5.017838e-04
Rph_34_23 p_34_23 p_35_23 5.017838e-04
Rpv_34_23 p_34_23 p_34_24 5.017838e-04
Rph_34_24 p_34_24 p_35_24 5.017838e-04
Rpv_34_24 p_34_24 p_34_25 5.017838e-04
Rph_34_25 p_34_25 p_35_25 5.017838e-04
Rpv_34_25 p_34_25 p_34_26 5.017838e-04
Rph_34_26 p_34_26 p_35_26 5.017838e-04
Rpv_34_26 p_34_26 p_34_27 5.017838e-04
Rph_34_27 p_34_27 p_35_27 5.017838e-04
Rpv_34_27 p_34_27 p_34_28 5.017838e-04
Rph_34_28 p_34_28 p_35_28 5.017838e-04
Rpv_34_28 p_34_28 p_34_29 5.017838e-04
Rph_34_29 p_34_29 p_35_29 5.017838e-04
Rpv_34_29 p_34_29 p_34_30 5.017838e-04
Rph_34_30 p_34_30 p_35_30 5.017838e-04
Rpv_34_30 p_34_30 p_34_31 5.017838e-04
Rph_34_31 p_34_31 p_35_31 5.017838e-04
Rpv_34_31 p_34_31 p_34_32 5.017838e-04
Rph_34_32 p_34_32 p_35_32 5.017838e-04
Rpv_34_32 p_34_32 p_34_33 5.017838e-04
Rph_34_33 p_34_33 p_35_33 5.017838e-04
Rpv_34_33 p_34_33 p_34_34 5.017838e-04
Rph_34_34 p_34_34 p_35_34 5.017838e-04
Rpv_34_34 p_34_34 p_34_35 5.017838e-04
Rph_34_35 p_34_35 p_35_35 5.017838e-04
Rpv_34_35 p_34_35 p_34_36 5.017838e-04
Rph_34_36 p_34_36 p_35_36 5.017838e-04
Rpv_34_36 p_34_36 p_34_37 5.017838e-04
Rph_34_37 p_34_37 p_35_37 5.017838e-04
Rpv_34_37 p_34_37 p_34_38 5.017838e-04
Rph_34_38 p_34_38 p_35_38 5.017838e-04
Rpv_34_38 p_34_38 p_34_39 5.017838e-04
Rph_34_39 p_34_39 p_35_39 5.017838e-04
Rpv_34_39 p_34_39 p_34_40 5.017838e-04
Rph_34_40 p_34_40 p_35_40 5.017838e-04
Rpv_34_40 p_34_40 p_34_41 5.017838e-04
Rph_34_41 p_34_41 p_35_41 5.017838e-04
Rpv_34_41 p_34_41 p_34_42 5.017838e-04
Rph_34_42 p_34_42 p_35_42 5.017838e-04
Rpv_34_42 p_34_42 p_34_43 5.017838e-04
Rph_34_43 p_34_43 p_35_43 5.017838e-04
Rpv_34_43 p_34_43 p_34_44 5.017838e-04
Rph_34_44 p_34_44 p_35_44 5.017838e-04
Rpv_34_44 p_34_44 p_34_45 5.017838e-04
Rph_34_45 p_34_45 p_35_45 5.017838e-04
Rpv_34_45 p_34_45 p_34_46 5.017838e-04
Rph_34_46 p_34_46 p_35_46 5.017838e-04
Rpv_34_46 p_34_46 p_34_47 5.017838e-04
Rph_34_47 p_34_47 p_35_47 5.017838e-04
Rpv_34_47 p_34_47 p_34_48 5.017838e-04
Rph_34_48 p_34_48 p_35_48 5.017838e-04
Rpv_34_48 p_34_48 p_34_49 5.017838e-04
Rph_34_49 p_34_49 p_35_49 5.017838e-04
Rpv_34_49 p_34_49 p_34_50 5.017838e-04
Rph_34_50 p_34_50 p_35_50 5.017838e-04
Rpv_34_50 p_34_50 p_34_51 5.017838e-04
Rph_34_51 p_34_51 p_35_51 5.017838e-04
Rpv_34_51 p_34_51 p_34_52 5.017838e-04
Rph_34_52 p_34_52 p_35_52 5.017838e-04
Rpv_34_52 p_34_52 p_34_53 5.017838e-04
Rph_34_53 p_34_53 p_35_53 5.017838e-04
Rpv_34_53 p_34_53 p_34_54 5.017838e-04
Rph_34_54 p_34_54 p_35_54 5.017838e-04
Rpv_34_54 p_34_54 p_34_55 5.017838e-04
Rph_34_55 p_34_55 p_35_55 5.017838e-04
Rpv_34_55 p_34_55 p_34_56 5.017838e-04
Rph_34_56 p_34_56 p_35_56 5.017838e-04
Rpv_34_56 p_34_56 p_34_57 5.017838e-04
Rph_34_57 p_34_57 p_35_57 5.017838e-04
Rpv_34_57 p_34_57 p_34_58 5.017838e-04
Rph_34_58 p_34_58 p_35_58 5.017838e-04
Rpv_34_58 p_34_58 p_34_59 5.017838e-04
Rph_34_59 p_34_59 p_35_59 5.017838e-04
Rpv_34_59 p_34_59 p_34_60 5.017838e-04
Rph_34_60 p_34_60 p_35_60 5.017838e-04
Rpv_34_60 p_34_60 p_34_61 5.017838e-04
Rph_34_61 p_34_61 p_35_61 5.017838e-04
Rpv_34_61 p_34_61 p_34_62 5.017838e-04
Rph_34_62 p_34_62 p_35_62 5.017838e-04
Rpv_34_62 p_34_62 p_34_63 5.017838e-04
Rph_34_63 p_34_63 p_35_63 5.017838e-04
Rpv_34_63 p_34_63 p_34_64 5.017838e-04
Rph_34_64 p_34_64 p_35_64 5.017838e-04
Rpv_34_64 p_34_64 p_34_65 5.017838e-04
Rph_34_65 p_34_65 p_35_65 5.017838e-04
Rpv_34_65 p_34_65 p_34_66 5.017838e-04
Rph_34_66 p_34_66 p_35_66 5.017838e-04
Rpv_34_66 p_34_66 p_34_67 5.017838e-04
Rph_34_67 p_34_67 p_35_67 5.017838e-04
Rpv_34_67 p_34_67 p_34_68 5.017838e-04
Rph_34_68 p_34_68 p_35_68 5.017838e-04
Rpv_34_68 p_34_68 p_34_69 5.017838e-04
Rph_34_69 p_34_69 p_35_69 5.017838e-04
Rpv_34_69 p_34_69 p_34_70 5.017838e-04
Rph_34_70 p_34_70 p_35_70 5.017838e-04
Rpv_34_70 p_34_70 p_34_71 5.017838e-04
Rph_34_71 p_34_71 p_35_71 5.017838e-04
Rph_35_0 p_35_0 p_36_0 5.017838e-04
Rpv_35_0 p_35_0 p_35_1 5.017838e-04
Rph_35_1 p_35_1 p_36_1 5.017838e-04
Rpv_35_1 p_35_1 p_35_2 5.017838e-04
Rph_35_2 p_35_2 p_36_2 5.017838e-04
Rpv_35_2 p_35_2 p_35_3 5.017838e-04
Rph_35_3 p_35_3 p_36_3 5.017838e-04
Rpv_35_3 p_35_3 p_35_4 5.017838e-04
Rph_35_4 p_35_4 p_36_4 5.017838e-04
Rpv_35_4 p_35_4 p_35_5 5.017838e-04
Rph_35_5 p_35_5 p_36_5 5.017838e-04
Rpv_35_5 p_35_5 p_35_6 5.017838e-04
Rph_35_6 p_35_6 p_36_6 5.017838e-04
Rpv_35_6 p_35_6 p_35_7 5.017838e-04
Rph_35_7 p_35_7 p_36_7 5.017838e-04
Rpv_35_7 p_35_7 p_35_8 5.017838e-04
Rph_35_8 p_35_8 p_36_8 5.017838e-04
Rpv_35_8 p_35_8 p_35_9 5.017838e-04
Rph_35_9 p_35_9 p_36_9 5.017838e-04
Rpv_35_9 p_35_9 p_35_10 5.017838e-04
Rph_35_10 p_35_10 p_36_10 5.017838e-04
Rpv_35_10 p_35_10 p_35_11 5.017838e-04
Rph_35_11 p_35_11 p_36_11 5.017838e-04
Rpv_35_11 p_35_11 p_35_12 5.017838e-04
Rph_35_12 p_35_12 p_36_12 5.017838e-04
Rpv_35_12 p_35_12 p_35_13 5.017838e-04
Rph_35_13 p_35_13 p_36_13 5.017838e-04
Rpv_35_13 p_35_13 p_35_14 5.017838e-04
Rph_35_14 p_35_14 p_36_14 5.017838e-04
Rpv_35_14 p_35_14 p_35_15 5.017838e-04
Rph_35_15 p_35_15 p_36_15 5.017838e-04
Rpv_35_15 p_35_15 p_35_16 5.017838e-04
Rph_35_16 p_35_16 p_36_16 5.017838e-04
Rpv_35_16 p_35_16 p_35_17 5.017838e-04
Rph_35_17 p_35_17 p_36_17 5.017838e-04
Rpv_35_17 p_35_17 p_35_18 5.017838e-04
Rph_35_18 p_35_18 p_36_18 5.017838e-04
Rpv_35_18 p_35_18 p_35_19 5.017838e-04
Rph_35_19 p_35_19 p_36_19 5.017838e-04
Rpv_35_19 p_35_19 p_35_20 5.017838e-04
Rph_35_20 p_35_20 p_36_20 5.017838e-04
Rpv_35_20 p_35_20 p_35_21 5.017838e-04
Rph_35_21 p_35_21 p_36_21 5.017838e-04
Rpv_35_21 p_35_21 p_35_22 5.017838e-04
Rph_35_22 p_35_22 p_36_22 5.017838e-04
Rpv_35_22 p_35_22 p_35_23 5.017838e-04
Rph_35_23 p_35_23 p_36_23 5.017838e-04
Rpv_35_23 p_35_23 p_35_24 5.017838e-04
Rph_35_24 p_35_24 p_36_24 5.017838e-04
Rpv_35_24 p_35_24 p_35_25 5.017838e-04
Rph_35_25 p_35_25 p_36_25 5.017838e-04
Rpv_35_25 p_35_25 p_35_26 5.017838e-04
Rph_35_26 p_35_26 p_36_26 5.017838e-04
Rpv_35_26 p_35_26 p_35_27 5.017838e-04
Rph_35_27 p_35_27 p_36_27 5.017838e-04
Rpv_35_27 p_35_27 p_35_28 5.017838e-04
Rph_35_28 p_35_28 p_36_28 5.017838e-04
Rpv_35_28 p_35_28 p_35_29 5.017838e-04
Rph_35_29 p_35_29 p_36_29 5.017838e-04
Rpv_35_29 p_35_29 p_35_30 5.017838e-04
Rph_35_30 p_35_30 p_36_30 5.017838e-04
Rpv_35_30 p_35_30 p_35_31 5.017838e-04
Rph_35_31 p_35_31 p_36_31 5.017838e-04
Rpv_35_31 p_35_31 p_35_32 5.017838e-04
Rph_35_32 p_35_32 p_36_32 5.017838e-04
Rpv_35_32 p_35_32 p_35_33 5.017838e-04
Rph_35_33 p_35_33 p_36_33 5.017838e-04
Rpv_35_33 p_35_33 p_35_34 5.017838e-04
Rph_35_34 p_35_34 p_36_34 5.017838e-04
Rpv_35_34 p_35_34 p_35_35 5.017838e-04
Rph_35_35 p_35_35 p_36_35 5.017838e-04
Rpv_35_35 p_35_35 p_35_36 5.017838e-04
Rph_35_36 p_35_36 p_36_36 5.017838e-04
Rpv_35_36 p_35_36 p_35_37 5.017838e-04
Rph_35_37 p_35_37 p_36_37 5.017838e-04
Rpv_35_37 p_35_37 p_35_38 5.017838e-04
Rph_35_38 p_35_38 p_36_38 5.017838e-04
Rpv_35_38 p_35_38 p_35_39 5.017838e-04
Rph_35_39 p_35_39 p_36_39 5.017838e-04
Rpv_35_39 p_35_39 p_35_40 5.017838e-04
Rph_35_40 p_35_40 p_36_40 5.017838e-04
Rpv_35_40 p_35_40 p_35_41 5.017838e-04
Rph_35_41 p_35_41 p_36_41 5.017838e-04
Rpv_35_41 p_35_41 p_35_42 5.017838e-04
Rph_35_42 p_35_42 p_36_42 5.017838e-04
Rpv_35_42 p_35_42 p_35_43 5.017838e-04
Rph_35_43 p_35_43 p_36_43 5.017838e-04
Rpv_35_43 p_35_43 p_35_44 5.017838e-04
Rph_35_44 p_35_44 p_36_44 5.017838e-04
Rpv_35_44 p_35_44 p_35_45 5.017838e-04
Rph_35_45 p_35_45 p_36_45 5.017838e-04
Rpv_35_45 p_35_45 p_35_46 5.017838e-04
Rph_35_46 p_35_46 p_36_46 5.017838e-04
Rpv_35_46 p_35_46 p_35_47 5.017838e-04
Rph_35_47 p_35_47 p_36_47 5.017838e-04
Rpv_35_47 p_35_47 p_35_48 5.017838e-04
Rph_35_48 p_35_48 p_36_48 5.017838e-04
Rpv_35_48 p_35_48 p_35_49 5.017838e-04
Rph_35_49 p_35_49 p_36_49 5.017838e-04
Rpv_35_49 p_35_49 p_35_50 5.017838e-04
Rph_35_50 p_35_50 p_36_50 5.017838e-04
Rpv_35_50 p_35_50 p_35_51 5.017838e-04
Rph_35_51 p_35_51 p_36_51 5.017838e-04
Rpv_35_51 p_35_51 p_35_52 5.017838e-04
Rph_35_52 p_35_52 p_36_52 5.017838e-04
Rpv_35_52 p_35_52 p_35_53 5.017838e-04
Rph_35_53 p_35_53 p_36_53 5.017838e-04
Rpv_35_53 p_35_53 p_35_54 5.017838e-04
Rph_35_54 p_35_54 p_36_54 5.017838e-04
Rpv_35_54 p_35_54 p_35_55 5.017838e-04
Rph_35_55 p_35_55 p_36_55 5.017838e-04
Rpv_35_55 p_35_55 p_35_56 5.017838e-04
Rph_35_56 p_35_56 p_36_56 5.017838e-04
Rpv_35_56 p_35_56 p_35_57 5.017838e-04
Rph_35_57 p_35_57 p_36_57 5.017838e-04
Rpv_35_57 p_35_57 p_35_58 5.017838e-04
Rph_35_58 p_35_58 p_36_58 5.017838e-04
Rpv_35_58 p_35_58 p_35_59 5.017838e-04
Rph_35_59 p_35_59 p_36_59 5.017838e-04
Rpv_35_59 p_35_59 p_35_60 5.017838e-04
Rph_35_60 p_35_60 p_36_60 5.017838e-04
Rpv_35_60 p_35_60 p_35_61 5.017838e-04
Rph_35_61 p_35_61 p_36_61 5.017838e-04
Rpv_35_61 p_35_61 p_35_62 5.017838e-04
Rph_35_62 p_35_62 p_36_62 5.017838e-04
Rpv_35_62 p_35_62 p_35_63 5.017838e-04
Rph_35_63 p_35_63 p_36_63 5.017838e-04
Rpv_35_63 p_35_63 p_35_64 5.017838e-04
Rph_35_64 p_35_64 p_36_64 5.017838e-04
Rpv_35_64 p_35_64 p_35_65 5.017838e-04
Rph_35_65 p_35_65 p_36_65 5.017838e-04
Rpv_35_65 p_35_65 p_35_66 5.017838e-04
Rph_35_66 p_35_66 p_36_66 5.017838e-04
Rpv_35_66 p_35_66 p_35_67 5.017838e-04
Rph_35_67 p_35_67 p_36_67 5.017838e-04
Rpv_35_67 p_35_67 p_35_68 5.017838e-04
Rph_35_68 p_35_68 p_36_68 5.017838e-04
Rpv_35_68 p_35_68 p_35_69 5.017838e-04
Rph_35_69 p_35_69 p_36_69 5.017838e-04
Rpv_35_69 p_35_69 p_35_70 5.017838e-04
Rph_35_70 p_35_70 p_36_70 5.017838e-04
Rpv_35_70 p_35_70 p_35_71 5.017838e-04
Rph_35_71 p_35_71 p_36_71 5.017838e-04
Rph_36_0 p_36_0 p_37_0 5.017838e-04
Rpv_36_0 p_36_0 p_36_1 5.017838e-04
Rph_36_1 p_36_1 p_37_1 5.017838e-04
Rpv_36_1 p_36_1 p_36_2 5.017838e-04
Rph_36_2 p_36_2 p_37_2 5.017838e-04
Rpv_36_2 p_36_2 p_36_3 5.017838e-04
Rph_36_3 p_36_3 p_37_3 5.017838e-04
Rpv_36_3 p_36_3 p_36_4 5.017838e-04
Rph_36_4 p_36_4 p_37_4 5.017838e-04
Rpv_36_4 p_36_4 p_36_5 5.017838e-04
Rph_36_5 p_36_5 p_37_5 5.017838e-04
Rpv_36_5 p_36_5 p_36_6 5.017838e-04
Rph_36_6 p_36_6 p_37_6 5.017838e-04
Rpv_36_6 p_36_6 p_36_7 5.017838e-04
Rph_36_7 p_36_7 p_37_7 5.017838e-04
Rpv_36_7 p_36_7 p_36_8 5.017838e-04
Rph_36_8 p_36_8 p_37_8 5.017838e-04
Rpv_36_8 p_36_8 p_36_9 5.017838e-04
Rph_36_9 p_36_9 p_37_9 5.017838e-04
Rpv_36_9 p_36_9 p_36_10 5.017838e-04
Rph_36_10 p_36_10 p_37_10 5.017838e-04
Rpv_36_10 p_36_10 p_36_11 5.017838e-04
Rph_36_11 p_36_11 p_37_11 5.017838e-04
Rpv_36_11 p_36_11 p_36_12 5.017838e-04
Rph_36_12 p_36_12 p_37_12 5.017838e-04
Rpv_36_12 p_36_12 p_36_13 5.017838e-04
Rph_36_13 p_36_13 p_37_13 5.017838e-04
Rpv_36_13 p_36_13 p_36_14 5.017838e-04
Rph_36_14 p_36_14 p_37_14 5.017838e-04
Rpv_36_14 p_36_14 p_36_15 5.017838e-04
Rph_36_15 p_36_15 p_37_15 5.017838e-04
Rpv_36_15 p_36_15 p_36_16 5.017838e-04
Rph_36_16 p_36_16 p_37_16 5.017838e-04
Rpv_36_16 p_36_16 p_36_17 5.017838e-04
Rph_36_17 p_36_17 p_37_17 5.017838e-04
Rpv_36_17 p_36_17 p_36_18 5.017838e-04
Rph_36_18 p_36_18 p_37_18 5.017838e-04
Rpv_36_18 p_36_18 p_36_19 5.017838e-04
Rph_36_19 p_36_19 p_37_19 5.017838e-04
Rpv_36_19 p_36_19 p_36_20 5.017838e-04
Rph_36_20 p_36_20 p_37_20 5.017838e-04
Rpv_36_20 p_36_20 p_36_21 5.017838e-04
Rph_36_21 p_36_21 p_37_21 5.017838e-04
Rpv_36_21 p_36_21 p_36_22 5.017838e-04
Rph_36_22 p_36_22 p_37_22 5.017838e-04
Rpv_36_22 p_36_22 p_36_23 5.017838e-04
Rph_36_23 p_36_23 p_37_23 5.017838e-04
Rpv_36_23 p_36_23 p_36_24 5.017838e-04
Rph_36_24 p_36_24 p_37_24 5.017838e-04
Rpv_36_24 p_36_24 p_36_25 5.017838e-04
Rph_36_25 p_36_25 p_37_25 5.017838e-04
Rpv_36_25 p_36_25 p_36_26 5.017838e-04
Rph_36_26 p_36_26 p_37_26 5.017838e-04
Rpv_36_26 p_36_26 p_36_27 5.017838e-04
Rph_36_27 p_36_27 p_37_27 5.017838e-04
Rpv_36_27 p_36_27 p_36_28 5.017838e-04
Rph_36_28 p_36_28 p_37_28 5.017838e-04
Rpv_36_28 p_36_28 p_36_29 5.017838e-04
Rph_36_29 p_36_29 p_37_29 5.017838e-04
Rpv_36_29 p_36_29 p_36_30 5.017838e-04
Rph_36_30 p_36_30 p_37_30 5.017838e-04
Rpv_36_30 p_36_30 p_36_31 5.017838e-04
Rph_36_31 p_36_31 p_37_31 5.017838e-04
Rpv_36_31 p_36_31 p_36_32 5.017838e-04
Rph_36_32 p_36_32 p_37_32 5.017838e-04
Rpv_36_32 p_36_32 p_36_33 5.017838e-04
Rph_36_33 p_36_33 p_37_33 5.017838e-04
Rpv_36_33 p_36_33 p_36_34 5.017838e-04
Rph_36_34 p_36_34 p_37_34 5.017838e-04
Rpv_36_34 p_36_34 p_36_35 5.017838e-04
Rph_36_35 p_36_35 p_37_35 5.017838e-04
Rpv_36_35 p_36_35 p_36_36 5.017838e-04
Rph_36_36 p_36_36 p_37_36 5.017838e-04
Rpv_36_36 p_36_36 p_36_37 5.017838e-04
Rph_36_37 p_36_37 p_37_37 5.017838e-04
Rpv_36_37 p_36_37 p_36_38 5.017838e-04
Rph_36_38 p_36_38 p_37_38 5.017838e-04
Rpv_36_38 p_36_38 p_36_39 5.017838e-04
Rph_36_39 p_36_39 p_37_39 5.017838e-04
Rpv_36_39 p_36_39 p_36_40 5.017838e-04
Rph_36_40 p_36_40 p_37_40 5.017838e-04
Rpv_36_40 p_36_40 p_36_41 5.017838e-04
Rph_36_41 p_36_41 p_37_41 5.017838e-04
Rpv_36_41 p_36_41 p_36_42 5.017838e-04
Rph_36_42 p_36_42 p_37_42 5.017838e-04
Rpv_36_42 p_36_42 p_36_43 5.017838e-04
Rph_36_43 p_36_43 p_37_43 5.017838e-04
Rpv_36_43 p_36_43 p_36_44 5.017838e-04
Rph_36_44 p_36_44 p_37_44 5.017838e-04
Rpv_36_44 p_36_44 p_36_45 5.017838e-04
Rph_36_45 p_36_45 p_37_45 5.017838e-04
Rpv_36_45 p_36_45 p_36_46 5.017838e-04
Rph_36_46 p_36_46 p_37_46 5.017838e-04
Rpv_36_46 p_36_46 p_36_47 5.017838e-04
Rph_36_47 p_36_47 p_37_47 5.017838e-04
Rpv_36_47 p_36_47 p_36_48 5.017838e-04
Rph_36_48 p_36_48 p_37_48 5.017838e-04
Rpv_36_48 p_36_48 p_36_49 5.017838e-04
Rph_36_49 p_36_49 p_37_49 5.017838e-04
Rpv_36_49 p_36_49 p_36_50 5.017838e-04
Rph_36_50 p_36_50 p_37_50 5.017838e-04
Rpv_36_50 p_36_50 p_36_51 5.017838e-04
Rph_36_51 p_36_51 p_37_51 5.017838e-04
Rpv_36_51 p_36_51 p_36_52 5.017838e-04
Rph_36_52 p_36_52 p_37_52 5.017838e-04
Rpv_36_52 p_36_52 p_36_53 5.017838e-04
Rph_36_53 p_36_53 p_37_53 5.017838e-04
Rpv_36_53 p_36_53 p_36_54 5.017838e-04
Rph_36_54 p_36_54 p_37_54 5.017838e-04
Rpv_36_54 p_36_54 p_36_55 5.017838e-04
Rph_36_55 p_36_55 p_37_55 5.017838e-04
Rpv_36_55 p_36_55 p_36_56 5.017838e-04
Rph_36_56 p_36_56 p_37_56 5.017838e-04
Rpv_36_56 p_36_56 p_36_57 5.017838e-04
Rph_36_57 p_36_57 p_37_57 5.017838e-04
Rpv_36_57 p_36_57 p_36_58 5.017838e-04
Rph_36_58 p_36_58 p_37_58 5.017838e-04
Rpv_36_58 p_36_58 p_36_59 5.017838e-04
Rph_36_59 p_36_59 p_37_59 5.017838e-04
Rpv_36_59 p_36_59 p_36_60 5.017838e-04
Rph_36_60 p_36_60 p_37_60 5.017838e-04
Rpv_36_60 p_36_60 p_36_61 5.017838e-04
Rph_36_61 p_36_61 p_37_61 5.017838e-04
Rpv_36_61 p_36_61 p_36_62 5.017838e-04
Rph_36_62 p_36_62 p_37_62 5.017838e-04
Rpv_36_62 p_36_62 p_36_63 5.017838e-04
Rph_36_63 p_36_63 p_37_63 5.017838e-04
Rpv_36_63 p_36_63 p_36_64 5.017838e-04
Rph_36_64 p_36_64 p_37_64 5.017838e-04
Rpv_36_64 p_36_64 p_36_65 5.017838e-04
Rph_36_65 p_36_65 p_37_65 5.017838e-04
Rpv_36_65 p_36_65 p_36_66 5.017838e-04
Rph_36_66 p_36_66 p_37_66 5.017838e-04
Rpv_36_66 p_36_66 p_36_67 5.017838e-04
Rph_36_67 p_36_67 p_37_67 5.017838e-04
Rpv_36_67 p_36_67 p_36_68 5.017838e-04
Rph_36_68 p_36_68 p_37_68 5.017838e-04
Rpv_36_68 p_36_68 p_36_69 5.017838e-04
Rph_36_69 p_36_69 p_37_69 5.017838e-04
Rpv_36_69 p_36_69 p_36_70 5.017838e-04
Rph_36_70 p_36_70 p_37_70 5.017838e-04
Rpv_36_70 p_36_70 p_36_71 5.017838e-04
Rph_36_71 p_36_71 p_37_71 5.017838e-04
Rph_37_0 p_37_0 p_38_0 5.017838e-04
Rpv_37_0 p_37_0 p_37_1 5.017838e-04
Rph_37_1 p_37_1 p_38_1 5.017838e-04
Rpv_37_1 p_37_1 p_37_2 5.017838e-04
Rph_37_2 p_37_2 p_38_2 5.017838e-04
Rpv_37_2 p_37_2 p_37_3 5.017838e-04
Rph_37_3 p_37_3 p_38_3 5.017838e-04
Rpv_37_3 p_37_3 p_37_4 5.017838e-04
Rph_37_4 p_37_4 p_38_4 5.017838e-04
Rpv_37_4 p_37_4 p_37_5 5.017838e-04
Rph_37_5 p_37_5 p_38_5 5.017838e-04
Rpv_37_5 p_37_5 p_37_6 5.017838e-04
Rph_37_6 p_37_6 p_38_6 5.017838e-04
Rpv_37_6 p_37_6 p_37_7 5.017838e-04
Rph_37_7 p_37_7 p_38_7 5.017838e-04
Rpv_37_7 p_37_7 p_37_8 5.017838e-04
Rph_37_8 p_37_8 p_38_8 5.017838e-04
Rpv_37_8 p_37_8 p_37_9 5.017838e-04
Rph_37_9 p_37_9 p_38_9 5.017838e-04
Rpv_37_9 p_37_9 p_37_10 5.017838e-04
Rph_37_10 p_37_10 p_38_10 5.017838e-04
Rpv_37_10 p_37_10 p_37_11 5.017838e-04
Rph_37_11 p_37_11 p_38_11 5.017838e-04
Rpv_37_11 p_37_11 p_37_12 5.017838e-04
Rph_37_12 p_37_12 p_38_12 5.017838e-04
Rpv_37_12 p_37_12 p_37_13 5.017838e-04
Rph_37_13 p_37_13 p_38_13 5.017838e-04
Rpv_37_13 p_37_13 p_37_14 5.017838e-04
Rph_37_14 p_37_14 p_38_14 5.017838e-04
Rpv_37_14 p_37_14 p_37_15 5.017838e-04
Rph_37_15 p_37_15 p_38_15 5.017838e-04
Rpv_37_15 p_37_15 p_37_16 5.017838e-04
Rph_37_16 p_37_16 p_38_16 5.017838e-04
Rpv_37_16 p_37_16 p_37_17 5.017838e-04
Rph_37_17 p_37_17 p_38_17 5.017838e-04
Rpv_37_17 p_37_17 p_37_18 5.017838e-04
Rph_37_18 p_37_18 p_38_18 5.017838e-04
Rpv_37_18 p_37_18 p_37_19 5.017838e-04
Rph_37_19 p_37_19 p_38_19 5.017838e-04
Rpv_37_19 p_37_19 p_37_20 5.017838e-04
Rph_37_20 p_37_20 p_38_20 5.017838e-04
Rpv_37_20 p_37_20 p_37_21 5.017838e-04
Rph_37_21 p_37_21 p_38_21 5.017838e-04
Rpv_37_21 p_37_21 p_37_22 5.017838e-04
Rph_37_22 p_37_22 p_38_22 5.017838e-04
Rpv_37_22 p_37_22 p_37_23 5.017838e-04
Rph_37_23 p_37_23 p_38_23 5.017838e-04
Rpv_37_23 p_37_23 p_37_24 5.017838e-04
Rph_37_24 p_37_24 p_38_24 5.017838e-04
Rpv_37_24 p_37_24 p_37_25 5.017838e-04
Rph_37_25 p_37_25 p_38_25 5.017838e-04
Rpv_37_25 p_37_25 p_37_26 5.017838e-04
Rph_37_26 p_37_26 p_38_26 5.017838e-04
Rpv_37_26 p_37_26 p_37_27 5.017838e-04
Rph_37_27 p_37_27 p_38_27 5.017838e-04
Rpv_37_27 p_37_27 p_37_28 5.017838e-04
Rph_37_28 p_37_28 p_38_28 5.017838e-04
Rpv_37_28 p_37_28 p_37_29 5.017838e-04
Rph_37_29 p_37_29 p_38_29 5.017838e-04
Rpv_37_29 p_37_29 p_37_30 5.017838e-04
Rph_37_30 p_37_30 p_38_30 5.017838e-04
Rpv_37_30 p_37_30 p_37_31 5.017838e-04
Rph_37_31 p_37_31 p_38_31 5.017838e-04
Rpv_37_31 p_37_31 p_37_32 5.017838e-04
Rph_37_32 p_37_32 p_38_32 5.017838e-04
Rpv_37_32 p_37_32 p_37_33 5.017838e-04
Rph_37_33 p_37_33 p_38_33 5.017838e-04
Rpv_37_33 p_37_33 p_37_34 5.017838e-04
Rph_37_34 p_37_34 p_38_34 5.017838e-04
Rpv_37_34 p_37_34 p_37_35 5.017838e-04
Rph_37_35 p_37_35 p_38_35 5.017838e-04
Rpv_37_35 p_37_35 p_37_36 5.017838e-04
Rph_37_36 p_37_36 p_38_36 5.017838e-04
Rpv_37_36 p_37_36 p_37_37 5.017838e-04
Rph_37_37 p_37_37 p_38_37 5.017838e-04
Rpv_37_37 p_37_37 p_37_38 5.017838e-04
Rph_37_38 p_37_38 p_38_38 5.017838e-04
Rpv_37_38 p_37_38 p_37_39 5.017838e-04
Rph_37_39 p_37_39 p_38_39 5.017838e-04
Rpv_37_39 p_37_39 p_37_40 5.017838e-04
Rph_37_40 p_37_40 p_38_40 5.017838e-04
Rpv_37_40 p_37_40 p_37_41 5.017838e-04
Rph_37_41 p_37_41 p_38_41 5.017838e-04
Rpv_37_41 p_37_41 p_37_42 5.017838e-04
Rph_37_42 p_37_42 p_38_42 5.017838e-04
Rpv_37_42 p_37_42 p_37_43 5.017838e-04
Rph_37_43 p_37_43 p_38_43 5.017838e-04
Rpv_37_43 p_37_43 p_37_44 5.017838e-04
Rph_37_44 p_37_44 p_38_44 5.017838e-04
Rpv_37_44 p_37_44 p_37_45 5.017838e-04
Rph_37_45 p_37_45 p_38_45 5.017838e-04
Rpv_37_45 p_37_45 p_37_46 5.017838e-04
Rph_37_46 p_37_46 p_38_46 5.017838e-04
Rpv_37_46 p_37_46 p_37_47 5.017838e-04
Rph_37_47 p_37_47 p_38_47 5.017838e-04
Rpv_37_47 p_37_47 p_37_48 5.017838e-04
Rph_37_48 p_37_48 p_38_48 5.017838e-04
Rpv_37_48 p_37_48 p_37_49 5.017838e-04
Rph_37_49 p_37_49 p_38_49 5.017838e-04
Rpv_37_49 p_37_49 p_37_50 5.017838e-04
Rph_37_50 p_37_50 p_38_50 5.017838e-04
Rpv_37_50 p_37_50 p_37_51 5.017838e-04
Rph_37_51 p_37_51 p_38_51 5.017838e-04
Rpv_37_51 p_37_51 p_37_52 5.017838e-04
Rph_37_52 p_37_52 p_38_52 5.017838e-04
Rpv_37_52 p_37_52 p_37_53 5.017838e-04
Rph_37_53 p_37_53 p_38_53 5.017838e-04
Rpv_37_53 p_37_53 p_37_54 5.017838e-04
Rph_37_54 p_37_54 p_38_54 5.017838e-04
Rpv_37_54 p_37_54 p_37_55 5.017838e-04
Rph_37_55 p_37_55 p_38_55 5.017838e-04
Rpv_37_55 p_37_55 p_37_56 5.017838e-04
Rph_37_56 p_37_56 p_38_56 5.017838e-04
Rpv_37_56 p_37_56 p_37_57 5.017838e-04
Rph_37_57 p_37_57 p_38_57 5.017838e-04
Rpv_37_57 p_37_57 p_37_58 5.017838e-04
Rph_37_58 p_37_58 p_38_58 5.017838e-04
Rpv_37_58 p_37_58 p_37_59 5.017838e-04
Rph_37_59 p_37_59 p_38_59 5.017838e-04
Rpv_37_59 p_37_59 p_37_60 5.017838e-04
Rph_37_60 p_37_60 p_38_60 5.017838e-04
Rpv_37_60 p_37_60 p_37_61 5.017838e-04
Rph_37_61 p_37_61 p_38_61 5.017838e-04
Rpv_37_61 p_37_61 p_37_62 5.017838e-04
Rph_37_62 p_37_62 p_38_62 5.017838e-04
Rpv_37_62 p_37_62 p_37_63 5.017838e-04
Rph_37_63 p_37_63 p_38_63 5.017838e-04
Rpv_37_63 p_37_63 p_37_64 5.017838e-04
Rph_37_64 p_37_64 p_38_64 5.017838e-04
Rpv_37_64 p_37_64 p_37_65 5.017838e-04
Rph_37_65 p_37_65 p_38_65 5.017838e-04
Rpv_37_65 p_37_65 p_37_66 5.017838e-04
Rph_37_66 p_37_66 p_38_66 5.017838e-04
Rpv_37_66 p_37_66 p_37_67 5.017838e-04
Rph_37_67 p_37_67 p_38_67 5.017838e-04
Rpv_37_67 p_37_67 p_37_68 5.017838e-04
Rph_37_68 p_37_68 p_38_68 5.017838e-04
Rpv_37_68 p_37_68 p_37_69 5.017838e-04
Rph_37_69 p_37_69 p_38_69 5.017838e-04
Rpv_37_69 p_37_69 p_37_70 5.017838e-04
Rph_37_70 p_37_70 p_38_70 5.017838e-04
Rpv_37_70 p_37_70 p_37_71 5.017838e-04
Rph_37_71 p_37_71 p_38_71 5.017838e-04
Rph_38_0 p_38_0 p_39_0 5.017838e-04
Rpv_38_0 p_38_0 p_38_1 5.017838e-04
Rph_38_1 p_38_1 p_39_1 5.017838e-04
Rpv_38_1 p_38_1 p_38_2 5.017838e-04
Rph_38_2 p_38_2 p_39_2 5.017838e-04
Rpv_38_2 p_38_2 p_38_3 5.017838e-04
Rph_38_3 p_38_3 p_39_3 5.017838e-04
Rpv_38_3 p_38_3 p_38_4 5.017838e-04
Rph_38_4 p_38_4 p_39_4 5.017838e-04
Rpv_38_4 p_38_4 p_38_5 5.017838e-04
Rph_38_5 p_38_5 p_39_5 5.017838e-04
Rpv_38_5 p_38_5 p_38_6 5.017838e-04
Rph_38_6 p_38_6 p_39_6 5.017838e-04
Rpv_38_6 p_38_6 p_38_7 5.017838e-04
Rph_38_7 p_38_7 p_39_7 5.017838e-04
Rpv_38_7 p_38_7 p_38_8 5.017838e-04
Rph_38_8 p_38_8 p_39_8 5.017838e-04
Rpv_38_8 p_38_8 p_38_9 5.017838e-04
Rph_38_9 p_38_9 p_39_9 5.017838e-04
Rpv_38_9 p_38_9 p_38_10 5.017838e-04
Rph_38_10 p_38_10 p_39_10 5.017838e-04
Rpv_38_10 p_38_10 p_38_11 5.017838e-04
Rph_38_11 p_38_11 p_39_11 5.017838e-04
Rpv_38_11 p_38_11 p_38_12 5.017838e-04
Rph_38_12 p_38_12 p_39_12 5.017838e-04
Rpv_38_12 p_38_12 p_38_13 5.017838e-04
Rph_38_13 p_38_13 p_39_13 5.017838e-04
Rpv_38_13 p_38_13 p_38_14 5.017838e-04
Rph_38_14 p_38_14 p_39_14 5.017838e-04
Rpv_38_14 p_38_14 p_38_15 5.017838e-04
Rph_38_15 p_38_15 p_39_15 5.017838e-04
Rpv_38_15 p_38_15 p_38_16 5.017838e-04
Rph_38_16 p_38_16 p_39_16 5.017838e-04
Rpv_38_16 p_38_16 p_38_17 5.017838e-04
Rph_38_17 p_38_17 p_39_17 5.017838e-04
Rpv_38_17 p_38_17 p_38_18 5.017838e-04
Rph_38_18 p_38_18 p_39_18 5.017838e-04
Rpv_38_18 p_38_18 p_38_19 5.017838e-04
Rph_38_19 p_38_19 p_39_19 5.017838e-04
Rpv_38_19 p_38_19 p_38_20 5.017838e-04
Rph_38_20 p_38_20 p_39_20 5.017838e-04
Rpv_38_20 p_38_20 p_38_21 5.017838e-04
Rph_38_21 p_38_21 p_39_21 5.017838e-04
Rpv_38_21 p_38_21 p_38_22 5.017838e-04
Rph_38_22 p_38_22 p_39_22 5.017838e-04
Rpv_38_22 p_38_22 p_38_23 5.017838e-04
Rph_38_23 p_38_23 p_39_23 5.017838e-04
Rpv_38_23 p_38_23 p_38_24 5.017838e-04
Rph_38_24 p_38_24 p_39_24 5.017838e-04
Rpv_38_24 p_38_24 p_38_25 5.017838e-04
Rph_38_25 p_38_25 p_39_25 5.017838e-04
Rpv_38_25 p_38_25 p_38_26 5.017838e-04
Rph_38_26 p_38_26 p_39_26 5.017838e-04
Rpv_38_26 p_38_26 p_38_27 5.017838e-04
Rph_38_27 p_38_27 p_39_27 5.017838e-04
Rpv_38_27 p_38_27 p_38_28 5.017838e-04
Rph_38_28 p_38_28 p_39_28 5.017838e-04
Rpv_38_28 p_38_28 p_38_29 5.017838e-04
Rph_38_29 p_38_29 p_39_29 5.017838e-04
Rpv_38_29 p_38_29 p_38_30 5.017838e-04
Rph_38_30 p_38_30 p_39_30 5.017838e-04
Rpv_38_30 p_38_30 p_38_31 5.017838e-04
Rph_38_31 p_38_31 p_39_31 5.017838e-04
Rpv_38_31 p_38_31 p_38_32 5.017838e-04
Rph_38_32 p_38_32 p_39_32 5.017838e-04
Rpv_38_32 p_38_32 p_38_33 5.017838e-04
Rph_38_33 p_38_33 p_39_33 5.017838e-04
Rpv_38_33 p_38_33 p_38_34 5.017838e-04
Rph_38_34 p_38_34 p_39_34 5.017838e-04
Rpv_38_34 p_38_34 p_38_35 5.017838e-04
Rph_38_35 p_38_35 p_39_35 5.017838e-04
Rpv_38_35 p_38_35 p_38_36 5.017838e-04
Rph_38_36 p_38_36 p_39_36 5.017838e-04
Rpv_38_36 p_38_36 p_38_37 5.017838e-04
Rph_38_37 p_38_37 p_39_37 5.017838e-04
Rpv_38_37 p_38_37 p_38_38 5.017838e-04
Rph_38_38 p_38_38 p_39_38 5.017838e-04
Rpv_38_38 p_38_38 p_38_39 5.017838e-04
Rph_38_39 p_38_39 p_39_39 5.017838e-04
Rpv_38_39 p_38_39 p_38_40 5.017838e-04
Rph_38_40 p_38_40 p_39_40 5.017838e-04
Rpv_38_40 p_38_40 p_38_41 5.017838e-04
Rph_38_41 p_38_41 p_39_41 5.017838e-04
Rpv_38_41 p_38_41 p_38_42 5.017838e-04
Rph_38_42 p_38_42 p_39_42 5.017838e-04
Rpv_38_42 p_38_42 p_38_43 5.017838e-04
Rph_38_43 p_38_43 p_39_43 5.017838e-04
Rpv_38_43 p_38_43 p_38_44 5.017838e-04
Rph_38_44 p_38_44 p_39_44 5.017838e-04
Rpv_38_44 p_38_44 p_38_45 5.017838e-04
Rph_38_45 p_38_45 p_39_45 5.017838e-04
Rpv_38_45 p_38_45 p_38_46 5.017838e-04
Rph_38_46 p_38_46 p_39_46 5.017838e-04
Rpv_38_46 p_38_46 p_38_47 5.017838e-04
Rph_38_47 p_38_47 p_39_47 5.017838e-04
Rpv_38_47 p_38_47 p_38_48 5.017838e-04
Rph_38_48 p_38_48 p_39_48 5.017838e-04
Rpv_38_48 p_38_48 p_38_49 5.017838e-04
Rph_38_49 p_38_49 p_39_49 5.017838e-04
Rpv_38_49 p_38_49 p_38_50 5.017838e-04
Rph_38_50 p_38_50 p_39_50 5.017838e-04
Rpv_38_50 p_38_50 p_38_51 5.017838e-04
Rph_38_51 p_38_51 p_39_51 5.017838e-04
Rpv_38_51 p_38_51 p_38_52 5.017838e-04
Rph_38_52 p_38_52 p_39_52 5.017838e-04
Rpv_38_52 p_38_52 p_38_53 5.017838e-04
Rph_38_53 p_38_53 p_39_53 5.017838e-04
Rpv_38_53 p_38_53 p_38_54 5.017838e-04
Rph_38_54 p_38_54 p_39_54 5.017838e-04
Rpv_38_54 p_38_54 p_38_55 5.017838e-04
Rph_38_55 p_38_55 p_39_55 5.017838e-04
Rpv_38_55 p_38_55 p_38_56 5.017838e-04
Rph_38_56 p_38_56 p_39_56 5.017838e-04
Rpv_38_56 p_38_56 p_38_57 5.017838e-04
Rph_38_57 p_38_57 p_39_57 5.017838e-04
Rpv_38_57 p_38_57 p_38_58 5.017838e-04
Rph_38_58 p_38_58 p_39_58 5.017838e-04
Rpv_38_58 p_38_58 p_38_59 5.017838e-04
Rph_38_59 p_38_59 p_39_59 5.017838e-04
Rpv_38_59 p_38_59 p_38_60 5.017838e-04
Rph_38_60 p_38_60 p_39_60 5.017838e-04
Rpv_38_60 p_38_60 p_38_61 5.017838e-04
Rph_38_61 p_38_61 p_39_61 5.017838e-04
Rpv_38_61 p_38_61 p_38_62 5.017838e-04
Rph_38_62 p_38_62 p_39_62 5.017838e-04
Rpv_38_62 p_38_62 p_38_63 5.017838e-04
Rph_38_63 p_38_63 p_39_63 5.017838e-04
Rpv_38_63 p_38_63 p_38_64 5.017838e-04
Rph_38_64 p_38_64 p_39_64 5.017838e-04
Rpv_38_64 p_38_64 p_38_65 5.017838e-04
Rph_38_65 p_38_65 p_39_65 5.017838e-04
Rpv_38_65 p_38_65 p_38_66 5.017838e-04
Rph_38_66 p_38_66 p_39_66 5.017838e-04
Rpv_38_66 p_38_66 p_38_67 5.017838e-04
Rph_38_67 p_38_67 p_39_67 5.017838e-04
Rpv_38_67 p_38_67 p_38_68 5.017838e-04
Rph_38_68 p_38_68 p_39_68 5.017838e-04
Rpv_38_68 p_38_68 p_38_69 5.017838e-04
Rph_38_69 p_38_69 p_39_69 5.017838e-04
Rpv_38_69 p_38_69 p_38_70 5.017838e-04
Rph_38_70 p_38_70 p_39_70 5.017838e-04
Rpv_38_70 p_38_70 p_38_71 5.017838e-04
Rph_38_71 p_38_71 p_39_71 5.017838e-04
Rph_39_0 p_39_0 p_40_0 5.017838e-04
Rpv_39_0 p_39_0 p_39_1 5.017838e-04
Rph_39_1 p_39_1 p_40_1 5.017838e-04
Rpv_39_1 p_39_1 p_39_2 5.017838e-04
Rph_39_2 p_39_2 p_40_2 5.017838e-04
Rpv_39_2 p_39_2 p_39_3 5.017838e-04
Rph_39_3 p_39_3 p_40_3 5.017838e-04
Rpv_39_3 p_39_3 p_39_4 5.017838e-04
Rph_39_4 p_39_4 p_40_4 5.017838e-04
Rpv_39_4 p_39_4 p_39_5 5.017838e-04
Rph_39_5 p_39_5 p_40_5 5.017838e-04
Rpv_39_5 p_39_5 p_39_6 5.017838e-04
Rph_39_6 p_39_6 p_40_6 5.017838e-04
Rpv_39_6 p_39_6 p_39_7 5.017838e-04
Rph_39_7 p_39_7 p_40_7 5.017838e-04
Rpv_39_7 p_39_7 p_39_8 5.017838e-04
Rph_39_8 p_39_8 p_40_8 5.017838e-04
Rpv_39_8 p_39_8 p_39_9 5.017838e-04
Rph_39_9 p_39_9 p_40_9 5.017838e-04
Rpv_39_9 p_39_9 p_39_10 5.017838e-04
Rph_39_10 p_39_10 p_40_10 5.017838e-04
Rpv_39_10 p_39_10 p_39_11 5.017838e-04
Rph_39_11 p_39_11 p_40_11 5.017838e-04
Rpv_39_11 p_39_11 p_39_12 5.017838e-04
Rph_39_12 p_39_12 p_40_12 5.017838e-04
Rpv_39_12 p_39_12 p_39_13 5.017838e-04
Rph_39_13 p_39_13 p_40_13 5.017838e-04
Rpv_39_13 p_39_13 p_39_14 5.017838e-04
Rph_39_14 p_39_14 p_40_14 5.017838e-04
Rpv_39_14 p_39_14 p_39_15 5.017838e-04
Rph_39_15 p_39_15 p_40_15 5.017838e-04
Rpv_39_15 p_39_15 p_39_16 5.017838e-04
Rph_39_16 p_39_16 p_40_16 5.017838e-04
Rpv_39_16 p_39_16 p_39_17 5.017838e-04
Rph_39_17 p_39_17 p_40_17 5.017838e-04
Rpv_39_17 p_39_17 p_39_18 5.017838e-04
Rph_39_18 p_39_18 p_40_18 5.017838e-04
Rpv_39_18 p_39_18 p_39_19 5.017838e-04
Rph_39_19 p_39_19 p_40_19 5.017838e-04
Rpv_39_19 p_39_19 p_39_20 5.017838e-04
Rph_39_20 p_39_20 p_40_20 5.017838e-04
Rpv_39_20 p_39_20 p_39_21 5.017838e-04
Rph_39_21 p_39_21 p_40_21 5.017838e-04
Rpv_39_21 p_39_21 p_39_22 5.017838e-04
Rph_39_22 p_39_22 p_40_22 5.017838e-04
Rpv_39_22 p_39_22 p_39_23 5.017838e-04
Rph_39_23 p_39_23 p_40_23 5.017838e-04
Rpv_39_23 p_39_23 p_39_24 5.017838e-04
Rph_39_24 p_39_24 p_40_24 5.017838e-04
Rpv_39_24 p_39_24 p_39_25 5.017838e-04
Rph_39_25 p_39_25 p_40_25 5.017838e-04
Rpv_39_25 p_39_25 p_39_26 5.017838e-04
Rph_39_26 p_39_26 p_40_26 5.017838e-04
Rpv_39_26 p_39_26 p_39_27 5.017838e-04
Rph_39_27 p_39_27 p_40_27 5.017838e-04
Rpv_39_27 p_39_27 p_39_28 5.017838e-04
Rph_39_28 p_39_28 p_40_28 5.017838e-04
Rpv_39_28 p_39_28 p_39_29 5.017838e-04
Rph_39_29 p_39_29 p_40_29 5.017838e-04
Rpv_39_29 p_39_29 p_39_30 5.017838e-04
Rph_39_30 p_39_30 p_40_30 5.017838e-04
Rpv_39_30 p_39_30 p_39_31 5.017838e-04
Rph_39_31 p_39_31 p_40_31 5.017838e-04
Rpv_39_31 p_39_31 p_39_32 5.017838e-04
Rph_39_32 p_39_32 p_40_32 5.017838e-04
Rpv_39_32 p_39_32 p_39_33 5.017838e-04
Rph_39_33 p_39_33 p_40_33 5.017838e-04
Rpv_39_33 p_39_33 p_39_34 5.017838e-04
Rph_39_34 p_39_34 p_40_34 5.017838e-04
Rpv_39_34 p_39_34 p_39_35 5.017838e-04
Rph_39_35 p_39_35 p_40_35 5.017838e-04
Rpv_39_35 p_39_35 p_39_36 5.017838e-04
Rph_39_36 p_39_36 p_40_36 5.017838e-04
Rpv_39_36 p_39_36 p_39_37 5.017838e-04
Rph_39_37 p_39_37 p_40_37 5.017838e-04
Rpv_39_37 p_39_37 p_39_38 5.017838e-04
Rph_39_38 p_39_38 p_40_38 5.017838e-04
Rpv_39_38 p_39_38 p_39_39 5.017838e-04
Rph_39_39 p_39_39 p_40_39 5.017838e-04
Rpv_39_39 p_39_39 p_39_40 5.017838e-04
Rph_39_40 p_39_40 p_40_40 5.017838e-04
Rpv_39_40 p_39_40 p_39_41 5.017838e-04
Rph_39_41 p_39_41 p_40_41 5.017838e-04
Rpv_39_41 p_39_41 p_39_42 5.017838e-04
Rph_39_42 p_39_42 p_40_42 5.017838e-04
Rpv_39_42 p_39_42 p_39_43 5.017838e-04
Rph_39_43 p_39_43 p_40_43 5.017838e-04
Rpv_39_43 p_39_43 p_39_44 5.017838e-04
Rph_39_44 p_39_44 p_40_44 5.017838e-04
Rpv_39_44 p_39_44 p_39_45 5.017838e-04
Rph_39_45 p_39_45 p_40_45 5.017838e-04
Rpv_39_45 p_39_45 p_39_46 5.017838e-04
Rph_39_46 p_39_46 p_40_46 5.017838e-04
Rpv_39_46 p_39_46 p_39_47 5.017838e-04
Rph_39_47 p_39_47 p_40_47 5.017838e-04
Rpv_39_47 p_39_47 p_39_48 5.017838e-04
Rph_39_48 p_39_48 p_40_48 5.017838e-04
Rpv_39_48 p_39_48 p_39_49 5.017838e-04
Rph_39_49 p_39_49 p_40_49 5.017838e-04
Rpv_39_49 p_39_49 p_39_50 5.017838e-04
Rph_39_50 p_39_50 p_40_50 5.017838e-04
Rpv_39_50 p_39_50 p_39_51 5.017838e-04
Rph_39_51 p_39_51 p_40_51 5.017838e-04
Rpv_39_51 p_39_51 p_39_52 5.017838e-04
Rph_39_52 p_39_52 p_40_52 5.017838e-04
Rpv_39_52 p_39_52 p_39_53 5.017838e-04
Rph_39_53 p_39_53 p_40_53 5.017838e-04
Rpv_39_53 p_39_53 p_39_54 5.017838e-04
Rph_39_54 p_39_54 p_40_54 5.017838e-04
Rpv_39_54 p_39_54 p_39_55 5.017838e-04
Rph_39_55 p_39_55 p_40_55 5.017838e-04
Rpv_39_55 p_39_55 p_39_56 5.017838e-04
Rph_39_56 p_39_56 p_40_56 5.017838e-04
Rpv_39_56 p_39_56 p_39_57 5.017838e-04
Rph_39_57 p_39_57 p_40_57 5.017838e-04
Rpv_39_57 p_39_57 p_39_58 5.017838e-04
Rph_39_58 p_39_58 p_40_58 5.017838e-04
Rpv_39_58 p_39_58 p_39_59 5.017838e-04
Rph_39_59 p_39_59 p_40_59 5.017838e-04
Rpv_39_59 p_39_59 p_39_60 5.017838e-04
Rph_39_60 p_39_60 p_40_60 5.017838e-04
Rpv_39_60 p_39_60 p_39_61 5.017838e-04
Rph_39_61 p_39_61 p_40_61 5.017838e-04
Rpv_39_61 p_39_61 p_39_62 5.017838e-04
Rph_39_62 p_39_62 p_40_62 5.017838e-04
Rpv_39_62 p_39_62 p_39_63 5.017838e-04
Rph_39_63 p_39_63 p_40_63 5.017838e-04
Rpv_39_63 p_39_63 p_39_64 5.017838e-04
Rph_39_64 p_39_64 p_40_64 5.017838e-04
Rpv_39_64 p_39_64 p_39_65 5.017838e-04
Rph_39_65 p_39_65 p_40_65 5.017838e-04
Rpv_39_65 p_39_65 p_39_66 5.017838e-04
Rph_39_66 p_39_66 p_40_66 5.017838e-04
Rpv_39_66 p_39_66 p_39_67 5.017838e-04
Rph_39_67 p_39_67 p_40_67 5.017838e-04
Rpv_39_67 p_39_67 p_39_68 5.017838e-04
Rph_39_68 p_39_68 p_40_68 5.017838e-04
Rpv_39_68 p_39_68 p_39_69 5.017838e-04
Rph_39_69 p_39_69 p_40_69 5.017838e-04
Rpv_39_69 p_39_69 p_39_70 5.017838e-04
Rph_39_70 p_39_70 p_40_70 5.017838e-04
Rpv_39_70 p_39_70 p_39_71 5.017838e-04
Rph_39_71 p_39_71 p_40_71 5.017838e-04
Rph_40_0 p_40_0 p_41_0 5.017838e-04
Rpv_40_0 p_40_0 p_40_1 5.017838e-04
Rph_40_1 p_40_1 p_41_1 5.017838e-04
Rpv_40_1 p_40_1 p_40_2 5.017838e-04
Rph_40_2 p_40_2 p_41_2 5.017838e-04
Rpv_40_2 p_40_2 p_40_3 5.017838e-04
Rph_40_3 p_40_3 p_41_3 5.017838e-04
Rpv_40_3 p_40_3 p_40_4 5.017838e-04
Rph_40_4 p_40_4 p_41_4 5.017838e-04
Rpv_40_4 p_40_4 p_40_5 5.017838e-04
Rph_40_5 p_40_5 p_41_5 5.017838e-04
Rpv_40_5 p_40_5 p_40_6 5.017838e-04
Rph_40_6 p_40_6 p_41_6 5.017838e-04
Rpv_40_6 p_40_6 p_40_7 5.017838e-04
Rph_40_7 p_40_7 p_41_7 5.017838e-04
Rpv_40_7 p_40_7 p_40_8 5.017838e-04
Rph_40_8 p_40_8 p_41_8 5.017838e-04
Rpv_40_8 p_40_8 p_40_9 5.017838e-04
Rph_40_9 p_40_9 p_41_9 5.017838e-04
Rpv_40_9 p_40_9 p_40_10 5.017838e-04
Rph_40_10 p_40_10 p_41_10 5.017838e-04
Rpv_40_10 p_40_10 p_40_11 5.017838e-04
Rph_40_11 p_40_11 p_41_11 5.017838e-04
Rpv_40_11 p_40_11 p_40_12 5.017838e-04
Rph_40_12 p_40_12 p_41_12 5.017838e-04
Rpv_40_12 p_40_12 p_40_13 5.017838e-04
Rph_40_13 p_40_13 p_41_13 5.017838e-04
Rpv_40_13 p_40_13 p_40_14 5.017838e-04
Rph_40_14 p_40_14 p_41_14 5.017838e-04
Rpv_40_14 p_40_14 p_40_15 5.017838e-04
Rph_40_15 p_40_15 p_41_15 5.017838e-04
Rpv_40_15 p_40_15 p_40_16 5.017838e-04
Rph_40_16 p_40_16 p_41_16 5.017838e-04
Rpv_40_16 p_40_16 p_40_17 5.017838e-04
Rph_40_17 p_40_17 p_41_17 5.017838e-04
Rpv_40_17 p_40_17 p_40_18 5.017838e-04
Rph_40_18 p_40_18 p_41_18 5.017838e-04
Rpv_40_18 p_40_18 p_40_19 5.017838e-04
Rph_40_19 p_40_19 p_41_19 5.017838e-04
Rpv_40_19 p_40_19 p_40_20 5.017838e-04
Rph_40_20 p_40_20 p_41_20 5.017838e-04
Rpv_40_20 p_40_20 p_40_21 5.017838e-04
Rph_40_21 p_40_21 p_41_21 5.017838e-04
Rpv_40_21 p_40_21 p_40_22 5.017838e-04
Rph_40_22 p_40_22 p_41_22 5.017838e-04
Rpv_40_22 p_40_22 p_40_23 5.017838e-04
Rph_40_23 p_40_23 p_41_23 5.017838e-04
Rpv_40_23 p_40_23 p_40_24 5.017838e-04
Rph_40_24 p_40_24 p_41_24 5.017838e-04
Rpv_40_24 p_40_24 p_40_25 5.017838e-04
Rph_40_25 p_40_25 p_41_25 5.017838e-04
Rpv_40_25 p_40_25 p_40_26 5.017838e-04
Rph_40_26 p_40_26 p_41_26 5.017838e-04
Rpv_40_26 p_40_26 p_40_27 5.017838e-04
Rph_40_27 p_40_27 p_41_27 5.017838e-04
Rpv_40_27 p_40_27 p_40_28 5.017838e-04
Rph_40_28 p_40_28 p_41_28 5.017838e-04
Rpv_40_28 p_40_28 p_40_29 5.017838e-04
Rph_40_29 p_40_29 p_41_29 5.017838e-04
Rpv_40_29 p_40_29 p_40_30 5.017838e-04
Rph_40_30 p_40_30 p_41_30 5.017838e-04
Rpv_40_30 p_40_30 p_40_31 5.017838e-04
Rph_40_31 p_40_31 p_41_31 5.017838e-04
Rpv_40_31 p_40_31 p_40_32 5.017838e-04
Rph_40_32 p_40_32 p_41_32 5.017838e-04
Rpv_40_32 p_40_32 p_40_33 5.017838e-04
Rph_40_33 p_40_33 p_41_33 5.017838e-04
Rpv_40_33 p_40_33 p_40_34 5.017838e-04
Rph_40_34 p_40_34 p_41_34 5.017838e-04
Rpv_40_34 p_40_34 p_40_35 5.017838e-04
Rph_40_35 p_40_35 p_41_35 5.017838e-04
Rpv_40_35 p_40_35 p_40_36 5.017838e-04
Rph_40_36 p_40_36 p_41_36 5.017838e-04
Rpv_40_36 p_40_36 p_40_37 5.017838e-04
Rph_40_37 p_40_37 p_41_37 5.017838e-04
Rpv_40_37 p_40_37 p_40_38 5.017838e-04
Rph_40_38 p_40_38 p_41_38 5.017838e-04
Rpv_40_38 p_40_38 p_40_39 5.017838e-04
Rph_40_39 p_40_39 p_41_39 5.017838e-04
Rpv_40_39 p_40_39 p_40_40 5.017838e-04
Rph_40_40 p_40_40 p_41_40 5.017838e-04
Rpv_40_40 p_40_40 p_40_41 5.017838e-04
Rph_40_41 p_40_41 p_41_41 5.017838e-04
Rpv_40_41 p_40_41 p_40_42 5.017838e-04
Rph_40_42 p_40_42 p_41_42 5.017838e-04
Rpv_40_42 p_40_42 p_40_43 5.017838e-04
Rph_40_43 p_40_43 p_41_43 5.017838e-04
Rpv_40_43 p_40_43 p_40_44 5.017838e-04
Rph_40_44 p_40_44 p_41_44 5.017838e-04
Rpv_40_44 p_40_44 p_40_45 5.017838e-04
Rph_40_45 p_40_45 p_41_45 5.017838e-04
Rpv_40_45 p_40_45 p_40_46 5.017838e-04
Rph_40_46 p_40_46 p_41_46 5.017838e-04
Rpv_40_46 p_40_46 p_40_47 5.017838e-04
Rph_40_47 p_40_47 p_41_47 5.017838e-04
Rpv_40_47 p_40_47 p_40_48 5.017838e-04
Rph_40_48 p_40_48 p_41_48 5.017838e-04
Rpv_40_48 p_40_48 p_40_49 5.017838e-04
Rph_40_49 p_40_49 p_41_49 5.017838e-04
Rpv_40_49 p_40_49 p_40_50 5.017838e-04
Rph_40_50 p_40_50 p_41_50 5.017838e-04
Rpv_40_50 p_40_50 p_40_51 5.017838e-04
Rph_40_51 p_40_51 p_41_51 5.017838e-04
Rpv_40_51 p_40_51 p_40_52 5.017838e-04
Rph_40_52 p_40_52 p_41_52 5.017838e-04
Rpv_40_52 p_40_52 p_40_53 5.017838e-04
Rph_40_53 p_40_53 p_41_53 5.017838e-04
Rpv_40_53 p_40_53 p_40_54 5.017838e-04
Rph_40_54 p_40_54 p_41_54 5.017838e-04
Rpv_40_54 p_40_54 p_40_55 5.017838e-04
Rph_40_55 p_40_55 p_41_55 5.017838e-04
Rpv_40_55 p_40_55 p_40_56 5.017838e-04
Rph_40_56 p_40_56 p_41_56 5.017838e-04
Rpv_40_56 p_40_56 p_40_57 5.017838e-04
Rph_40_57 p_40_57 p_41_57 5.017838e-04
Rpv_40_57 p_40_57 p_40_58 5.017838e-04
Rph_40_58 p_40_58 p_41_58 5.017838e-04
Rpv_40_58 p_40_58 p_40_59 5.017838e-04
Rph_40_59 p_40_59 p_41_59 5.017838e-04
Rpv_40_59 p_40_59 p_40_60 5.017838e-04
Rph_40_60 p_40_60 p_41_60 5.017838e-04
Rpv_40_60 p_40_60 p_40_61 5.017838e-04
Rph_40_61 p_40_61 p_41_61 5.017838e-04
Rpv_40_61 p_40_61 p_40_62 5.017838e-04
Rph_40_62 p_40_62 p_41_62 5.017838e-04
Rpv_40_62 p_40_62 p_40_63 5.017838e-04
Rph_40_63 p_40_63 p_41_63 5.017838e-04
Rpv_40_63 p_40_63 p_40_64 5.017838e-04
Rph_40_64 p_40_64 p_41_64 5.017838e-04
Rpv_40_64 p_40_64 p_40_65 5.017838e-04
Rph_40_65 p_40_65 p_41_65 5.017838e-04
Rpv_40_65 p_40_65 p_40_66 5.017838e-04
Rph_40_66 p_40_66 p_41_66 5.017838e-04
Rpv_40_66 p_40_66 p_40_67 5.017838e-04
Rph_40_67 p_40_67 p_41_67 5.017838e-04
Rpv_40_67 p_40_67 p_40_68 5.017838e-04
Rph_40_68 p_40_68 p_41_68 5.017838e-04
Rpv_40_68 p_40_68 p_40_69 5.017838e-04
Rph_40_69 p_40_69 p_41_69 5.017838e-04
Rpv_40_69 p_40_69 p_40_70 5.017838e-04
Rph_40_70 p_40_70 p_41_70 5.017838e-04
Rpv_40_70 p_40_70 p_40_71 5.017838e-04
Rph_40_71 p_40_71 p_41_71 5.017838e-04
Rph_41_0 p_41_0 p_42_0 5.017838e-04
Rpv_41_0 p_41_0 p_41_1 5.017838e-04
Rph_41_1 p_41_1 p_42_1 5.017838e-04
Rpv_41_1 p_41_1 p_41_2 5.017838e-04
Rph_41_2 p_41_2 p_42_2 5.017838e-04
Rpv_41_2 p_41_2 p_41_3 5.017838e-04
Rph_41_3 p_41_3 p_42_3 5.017838e-04
Rpv_41_3 p_41_3 p_41_4 5.017838e-04
Rph_41_4 p_41_4 p_42_4 5.017838e-04
Rpv_41_4 p_41_4 p_41_5 5.017838e-04
Rph_41_5 p_41_5 p_42_5 5.017838e-04
Rpv_41_5 p_41_5 p_41_6 5.017838e-04
Rph_41_6 p_41_6 p_42_6 5.017838e-04
Rpv_41_6 p_41_6 p_41_7 5.017838e-04
Rph_41_7 p_41_7 p_42_7 5.017838e-04
Rpv_41_7 p_41_7 p_41_8 5.017838e-04
Rph_41_8 p_41_8 p_42_8 5.017838e-04
Rpv_41_8 p_41_8 p_41_9 5.017838e-04
Rph_41_9 p_41_9 p_42_9 5.017838e-04
Rpv_41_9 p_41_9 p_41_10 5.017838e-04
Rph_41_10 p_41_10 p_42_10 5.017838e-04
Rpv_41_10 p_41_10 p_41_11 5.017838e-04
Rph_41_11 p_41_11 p_42_11 5.017838e-04
Rpv_41_11 p_41_11 p_41_12 5.017838e-04
Rph_41_12 p_41_12 p_42_12 5.017838e-04
Rpv_41_12 p_41_12 p_41_13 5.017838e-04
Rph_41_13 p_41_13 p_42_13 5.017838e-04
Rpv_41_13 p_41_13 p_41_14 5.017838e-04
Rph_41_14 p_41_14 p_42_14 5.017838e-04
Rpv_41_14 p_41_14 p_41_15 5.017838e-04
Rph_41_15 p_41_15 p_42_15 5.017838e-04
Rpv_41_15 p_41_15 p_41_16 5.017838e-04
Rph_41_16 p_41_16 p_42_16 5.017838e-04
Rpv_41_16 p_41_16 p_41_17 5.017838e-04
Rph_41_17 p_41_17 p_42_17 5.017838e-04
Rpv_41_17 p_41_17 p_41_18 5.017838e-04
Rph_41_18 p_41_18 p_42_18 5.017838e-04
Rpv_41_18 p_41_18 p_41_19 5.017838e-04
Rph_41_19 p_41_19 p_42_19 5.017838e-04
Rpv_41_19 p_41_19 p_41_20 5.017838e-04
Rph_41_20 p_41_20 p_42_20 5.017838e-04
Rpv_41_20 p_41_20 p_41_21 5.017838e-04
Rph_41_21 p_41_21 p_42_21 5.017838e-04
Rpv_41_21 p_41_21 p_41_22 5.017838e-04
Rph_41_22 p_41_22 p_42_22 5.017838e-04
Rpv_41_22 p_41_22 p_41_23 5.017838e-04
Rph_41_23 p_41_23 p_42_23 5.017838e-04
Rpv_41_23 p_41_23 p_41_24 5.017838e-04
Rph_41_24 p_41_24 p_42_24 5.017838e-04
Rpv_41_24 p_41_24 p_41_25 5.017838e-04
Rph_41_25 p_41_25 p_42_25 5.017838e-04
Rpv_41_25 p_41_25 p_41_26 5.017838e-04
Rph_41_26 p_41_26 p_42_26 5.017838e-04
Rpv_41_26 p_41_26 p_41_27 5.017838e-04
Rph_41_27 p_41_27 p_42_27 5.017838e-04
Rpv_41_27 p_41_27 p_41_28 5.017838e-04
Rph_41_28 p_41_28 p_42_28 5.017838e-04
Rpv_41_28 p_41_28 p_41_29 5.017838e-04
Rph_41_29 p_41_29 p_42_29 5.017838e-04
Rpv_41_29 p_41_29 p_41_30 5.017838e-04
Rph_41_30 p_41_30 p_42_30 5.017838e-04
Rpv_41_30 p_41_30 p_41_31 5.017838e-04
Rph_41_31 p_41_31 p_42_31 5.017838e-04
Rpv_41_31 p_41_31 p_41_32 5.017838e-04
Rph_41_32 p_41_32 p_42_32 5.017838e-04
Rpv_41_32 p_41_32 p_41_33 5.017838e-04
Rph_41_33 p_41_33 p_42_33 5.017838e-04
Rpv_41_33 p_41_33 p_41_34 5.017838e-04
Rph_41_34 p_41_34 p_42_34 5.017838e-04
Rpv_41_34 p_41_34 p_41_35 5.017838e-04
Rph_41_35 p_41_35 p_42_35 5.017838e-04
Rpv_41_35 p_41_35 p_41_36 5.017838e-04
Rph_41_36 p_41_36 p_42_36 5.017838e-04
Rpv_41_36 p_41_36 p_41_37 5.017838e-04
Rph_41_37 p_41_37 p_42_37 5.017838e-04
Rpv_41_37 p_41_37 p_41_38 5.017838e-04
Rph_41_38 p_41_38 p_42_38 5.017838e-04
Rpv_41_38 p_41_38 p_41_39 5.017838e-04
Rph_41_39 p_41_39 p_42_39 5.017838e-04
Rpv_41_39 p_41_39 p_41_40 5.017838e-04
Rph_41_40 p_41_40 p_42_40 5.017838e-04
Rpv_41_40 p_41_40 p_41_41 5.017838e-04
Rph_41_41 p_41_41 p_42_41 5.017838e-04
Rpv_41_41 p_41_41 p_41_42 5.017838e-04
Rph_41_42 p_41_42 p_42_42 5.017838e-04
Rpv_41_42 p_41_42 p_41_43 5.017838e-04
Rph_41_43 p_41_43 p_42_43 5.017838e-04
Rpv_41_43 p_41_43 p_41_44 5.017838e-04
Rph_41_44 p_41_44 p_42_44 5.017838e-04
Rpv_41_44 p_41_44 p_41_45 5.017838e-04
Rph_41_45 p_41_45 p_42_45 5.017838e-04
Rpv_41_45 p_41_45 p_41_46 5.017838e-04
Rph_41_46 p_41_46 p_42_46 5.017838e-04
Rpv_41_46 p_41_46 p_41_47 5.017838e-04
Rph_41_47 p_41_47 p_42_47 5.017838e-04
Rpv_41_47 p_41_47 p_41_48 5.017838e-04
Rph_41_48 p_41_48 p_42_48 5.017838e-04
Rpv_41_48 p_41_48 p_41_49 5.017838e-04
Rph_41_49 p_41_49 p_42_49 5.017838e-04
Rpv_41_49 p_41_49 p_41_50 5.017838e-04
Rph_41_50 p_41_50 p_42_50 5.017838e-04
Rpv_41_50 p_41_50 p_41_51 5.017838e-04
Rph_41_51 p_41_51 p_42_51 5.017838e-04
Rpv_41_51 p_41_51 p_41_52 5.017838e-04
Rph_41_52 p_41_52 p_42_52 5.017838e-04
Rpv_41_52 p_41_52 p_41_53 5.017838e-04
Rph_41_53 p_41_53 p_42_53 5.017838e-04
Rpv_41_53 p_41_53 p_41_54 5.017838e-04
Rph_41_54 p_41_54 p_42_54 5.017838e-04
Rpv_41_54 p_41_54 p_41_55 5.017838e-04
Rph_41_55 p_41_55 p_42_55 5.017838e-04
Rpv_41_55 p_41_55 p_41_56 5.017838e-04
Rph_41_56 p_41_56 p_42_56 5.017838e-04
Rpv_41_56 p_41_56 p_41_57 5.017838e-04
Rph_41_57 p_41_57 p_42_57 5.017838e-04
Rpv_41_57 p_41_57 p_41_58 5.017838e-04
Rph_41_58 p_41_58 p_42_58 5.017838e-04
Rpv_41_58 p_41_58 p_41_59 5.017838e-04
Rph_41_59 p_41_59 p_42_59 5.017838e-04
Rpv_41_59 p_41_59 p_41_60 5.017838e-04
Rph_41_60 p_41_60 p_42_60 5.017838e-04
Rpv_41_60 p_41_60 p_41_61 5.017838e-04
Rph_41_61 p_41_61 p_42_61 5.017838e-04
Rpv_41_61 p_41_61 p_41_62 5.017838e-04
Rph_41_62 p_41_62 p_42_62 5.017838e-04
Rpv_41_62 p_41_62 p_41_63 5.017838e-04
Rph_41_63 p_41_63 p_42_63 5.017838e-04
Rpv_41_63 p_41_63 p_41_64 5.017838e-04
Rph_41_64 p_41_64 p_42_64 5.017838e-04
Rpv_41_64 p_41_64 p_41_65 5.017838e-04
Rph_41_65 p_41_65 p_42_65 5.017838e-04
Rpv_41_65 p_41_65 p_41_66 5.017838e-04
Rph_41_66 p_41_66 p_42_66 5.017838e-04
Rpv_41_66 p_41_66 p_41_67 5.017838e-04
Rph_41_67 p_41_67 p_42_67 5.017838e-04
Rpv_41_67 p_41_67 p_41_68 5.017838e-04
Rph_41_68 p_41_68 p_42_68 5.017838e-04
Rpv_41_68 p_41_68 p_41_69 5.017838e-04
Rph_41_69 p_41_69 p_42_69 5.017838e-04
Rpv_41_69 p_41_69 p_41_70 5.017838e-04
Rph_41_70 p_41_70 p_42_70 5.017838e-04
Rpv_41_70 p_41_70 p_41_71 5.017838e-04
Rph_41_71 p_41_71 p_42_71 5.017838e-04
Rph_42_0 p_42_0 p_43_0 5.017838e-04
Rpv_42_0 p_42_0 p_42_1 5.017838e-04
Rph_42_1 p_42_1 p_43_1 5.017838e-04
Rpv_42_1 p_42_1 p_42_2 5.017838e-04
Rph_42_2 p_42_2 p_43_2 5.017838e-04
Rpv_42_2 p_42_2 p_42_3 5.017838e-04
Rph_42_3 p_42_3 p_43_3 5.017838e-04
Rpv_42_3 p_42_3 p_42_4 5.017838e-04
Rph_42_4 p_42_4 p_43_4 5.017838e-04
Rpv_42_4 p_42_4 p_42_5 5.017838e-04
Rph_42_5 p_42_5 p_43_5 5.017838e-04
Rpv_42_5 p_42_5 p_42_6 5.017838e-04
Rph_42_6 p_42_6 p_43_6 5.017838e-04
Rpv_42_6 p_42_6 p_42_7 5.017838e-04
Rph_42_7 p_42_7 p_43_7 5.017838e-04
Rpv_42_7 p_42_7 p_42_8 5.017838e-04
Rph_42_8 p_42_8 p_43_8 5.017838e-04
Rpv_42_8 p_42_8 p_42_9 5.017838e-04
Rph_42_9 p_42_9 p_43_9 5.017838e-04
Rpv_42_9 p_42_9 p_42_10 5.017838e-04
Rph_42_10 p_42_10 p_43_10 5.017838e-04
Rpv_42_10 p_42_10 p_42_11 5.017838e-04
Rph_42_11 p_42_11 p_43_11 5.017838e-04
Rpv_42_11 p_42_11 p_42_12 5.017838e-04
Rph_42_12 p_42_12 p_43_12 5.017838e-04
Rpv_42_12 p_42_12 p_42_13 5.017838e-04
Rph_42_13 p_42_13 p_43_13 5.017838e-04
Rpv_42_13 p_42_13 p_42_14 5.017838e-04
Rph_42_14 p_42_14 p_43_14 5.017838e-04
Rpv_42_14 p_42_14 p_42_15 5.017838e-04
Rph_42_15 p_42_15 p_43_15 5.017838e-04
Rpv_42_15 p_42_15 p_42_16 5.017838e-04
Rph_42_16 p_42_16 p_43_16 5.017838e-04
Rpv_42_16 p_42_16 p_42_17 5.017838e-04
Rph_42_17 p_42_17 p_43_17 5.017838e-04
Rpv_42_17 p_42_17 p_42_18 5.017838e-04
Rph_42_18 p_42_18 p_43_18 5.017838e-04
Rpv_42_18 p_42_18 p_42_19 5.017838e-04
Rph_42_19 p_42_19 p_43_19 5.017838e-04
Rpv_42_19 p_42_19 p_42_20 5.017838e-04
Rph_42_20 p_42_20 p_43_20 5.017838e-04
Rpv_42_20 p_42_20 p_42_21 5.017838e-04
Rph_42_21 p_42_21 p_43_21 5.017838e-04
Rpv_42_21 p_42_21 p_42_22 5.017838e-04
Rph_42_22 p_42_22 p_43_22 5.017838e-04
Rpv_42_22 p_42_22 p_42_23 5.017838e-04
Rph_42_23 p_42_23 p_43_23 5.017838e-04
Rpv_42_23 p_42_23 p_42_24 5.017838e-04
Rph_42_24 p_42_24 p_43_24 5.017838e-04
Rpv_42_24 p_42_24 p_42_25 5.017838e-04
Rph_42_25 p_42_25 p_43_25 5.017838e-04
Rpv_42_25 p_42_25 p_42_26 5.017838e-04
Rph_42_26 p_42_26 p_43_26 5.017838e-04
Rpv_42_26 p_42_26 p_42_27 5.017838e-04
Rph_42_27 p_42_27 p_43_27 5.017838e-04
Rpv_42_27 p_42_27 p_42_28 5.017838e-04
Rph_42_28 p_42_28 p_43_28 5.017838e-04
Rpv_42_28 p_42_28 p_42_29 5.017838e-04
Rph_42_29 p_42_29 p_43_29 5.017838e-04
Rpv_42_29 p_42_29 p_42_30 5.017838e-04
Rph_42_30 p_42_30 p_43_30 5.017838e-04
Rpv_42_30 p_42_30 p_42_31 5.017838e-04
Rph_42_31 p_42_31 p_43_31 5.017838e-04
Rpv_42_31 p_42_31 p_42_32 5.017838e-04
Rph_42_32 p_42_32 p_43_32 5.017838e-04
Rpv_42_32 p_42_32 p_42_33 5.017838e-04
Rph_42_33 p_42_33 p_43_33 5.017838e-04
Rpv_42_33 p_42_33 p_42_34 5.017838e-04
Rph_42_34 p_42_34 p_43_34 5.017838e-04
Rpv_42_34 p_42_34 p_42_35 5.017838e-04
Rph_42_35 p_42_35 p_43_35 5.017838e-04
Rpv_42_35 p_42_35 p_42_36 5.017838e-04
Rph_42_36 p_42_36 p_43_36 5.017838e-04
Rpv_42_36 p_42_36 p_42_37 5.017838e-04
Rph_42_37 p_42_37 p_43_37 5.017838e-04
Rpv_42_37 p_42_37 p_42_38 5.017838e-04
Rph_42_38 p_42_38 p_43_38 5.017838e-04
Rpv_42_38 p_42_38 p_42_39 5.017838e-04
Rph_42_39 p_42_39 p_43_39 5.017838e-04
Rpv_42_39 p_42_39 p_42_40 5.017838e-04
Rph_42_40 p_42_40 p_43_40 5.017838e-04
Rpv_42_40 p_42_40 p_42_41 5.017838e-04
Rph_42_41 p_42_41 p_43_41 5.017838e-04
Rpv_42_41 p_42_41 p_42_42 5.017838e-04
Rph_42_42 p_42_42 p_43_42 5.017838e-04
Rpv_42_42 p_42_42 p_42_43 5.017838e-04
Rph_42_43 p_42_43 p_43_43 5.017838e-04
Rpv_42_43 p_42_43 p_42_44 5.017838e-04
Rph_42_44 p_42_44 p_43_44 5.017838e-04
Rpv_42_44 p_42_44 p_42_45 5.017838e-04
Rph_42_45 p_42_45 p_43_45 5.017838e-04
Rpv_42_45 p_42_45 p_42_46 5.017838e-04
Rph_42_46 p_42_46 p_43_46 5.017838e-04
Rpv_42_46 p_42_46 p_42_47 5.017838e-04
Rph_42_47 p_42_47 p_43_47 5.017838e-04
Rpv_42_47 p_42_47 p_42_48 5.017838e-04
Rph_42_48 p_42_48 p_43_48 5.017838e-04
Rpv_42_48 p_42_48 p_42_49 5.017838e-04
Rph_42_49 p_42_49 p_43_49 5.017838e-04
Rpv_42_49 p_42_49 p_42_50 5.017838e-04
Rph_42_50 p_42_50 p_43_50 5.017838e-04
Rpv_42_50 p_42_50 p_42_51 5.017838e-04
Rph_42_51 p_42_51 p_43_51 5.017838e-04
Rpv_42_51 p_42_51 p_42_52 5.017838e-04
Rph_42_52 p_42_52 p_43_52 5.017838e-04
Rpv_42_52 p_42_52 p_42_53 5.017838e-04
Rph_42_53 p_42_53 p_43_53 5.017838e-04
Rpv_42_53 p_42_53 p_42_54 5.017838e-04
Rph_42_54 p_42_54 p_43_54 5.017838e-04
Rpv_42_54 p_42_54 p_42_55 5.017838e-04
Rph_42_55 p_42_55 p_43_55 5.017838e-04
Rpv_42_55 p_42_55 p_42_56 5.017838e-04
Rph_42_56 p_42_56 p_43_56 5.017838e-04
Rpv_42_56 p_42_56 p_42_57 5.017838e-04
Rph_42_57 p_42_57 p_43_57 5.017838e-04
Rpv_42_57 p_42_57 p_42_58 5.017838e-04
Rph_42_58 p_42_58 p_43_58 5.017838e-04
Rpv_42_58 p_42_58 p_42_59 5.017838e-04
Rph_42_59 p_42_59 p_43_59 5.017838e-04
Rpv_42_59 p_42_59 p_42_60 5.017838e-04
Rph_42_60 p_42_60 p_43_60 5.017838e-04
Rpv_42_60 p_42_60 p_42_61 5.017838e-04
Rph_42_61 p_42_61 p_43_61 5.017838e-04
Rpv_42_61 p_42_61 p_42_62 5.017838e-04
Rph_42_62 p_42_62 p_43_62 5.017838e-04
Rpv_42_62 p_42_62 p_42_63 5.017838e-04
Rph_42_63 p_42_63 p_43_63 5.017838e-04
Rpv_42_63 p_42_63 p_42_64 5.017838e-04
Rph_42_64 p_42_64 p_43_64 5.017838e-04
Rpv_42_64 p_42_64 p_42_65 5.017838e-04
Rph_42_65 p_42_65 p_43_65 5.017838e-04
Rpv_42_65 p_42_65 p_42_66 5.017838e-04
Rph_42_66 p_42_66 p_43_66 5.017838e-04
Rpv_42_66 p_42_66 p_42_67 5.017838e-04
Rph_42_67 p_42_67 p_43_67 5.017838e-04
Rpv_42_67 p_42_67 p_42_68 5.017838e-04
Rph_42_68 p_42_68 p_43_68 5.017838e-04
Rpv_42_68 p_42_68 p_42_69 5.017838e-04
Rph_42_69 p_42_69 p_43_69 5.017838e-04
Rpv_42_69 p_42_69 p_42_70 5.017838e-04
Rph_42_70 p_42_70 p_43_70 5.017838e-04
Rpv_42_70 p_42_70 p_42_71 5.017838e-04
Rph_42_71 p_42_71 p_43_71 5.017838e-04
Rph_43_0 p_43_0 p_44_0 5.017838e-04
Rpv_43_0 p_43_0 p_43_1 5.017838e-04
Rph_43_1 p_43_1 p_44_1 5.017838e-04
Rpv_43_1 p_43_1 p_43_2 5.017838e-04
Rph_43_2 p_43_2 p_44_2 5.017838e-04
Rpv_43_2 p_43_2 p_43_3 5.017838e-04
Rph_43_3 p_43_3 p_44_3 5.017838e-04
Rpv_43_3 p_43_3 p_43_4 5.017838e-04
Rph_43_4 p_43_4 p_44_4 5.017838e-04
Rpv_43_4 p_43_4 p_43_5 5.017838e-04
Rph_43_5 p_43_5 p_44_5 5.017838e-04
Rpv_43_5 p_43_5 p_43_6 5.017838e-04
Rph_43_6 p_43_6 p_44_6 5.017838e-04
Rpv_43_6 p_43_6 p_43_7 5.017838e-04
Rph_43_7 p_43_7 p_44_7 5.017838e-04
Rpv_43_7 p_43_7 p_43_8 5.017838e-04
Rph_43_8 p_43_8 p_44_8 5.017838e-04
Rpv_43_8 p_43_8 p_43_9 5.017838e-04
Rph_43_9 p_43_9 p_44_9 5.017838e-04
Rpv_43_9 p_43_9 p_43_10 5.017838e-04
Rph_43_10 p_43_10 p_44_10 5.017838e-04
Rpv_43_10 p_43_10 p_43_11 5.017838e-04
Rph_43_11 p_43_11 p_44_11 5.017838e-04
Rpv_43_11 p_43_11 p_43_12 5.017838e-04
Rph_43_12 p_43_12 p_44_12 5.017838e-04
Rpv_43_12 p_43_12 p_43_13 5.017838e-04
Rph_43_13 p_43_13 p_44_13 5.017838e-04
Rpv_43_13 p_43_13 p_43_14 5.017838e-04
Rph_43_14 p_43_14 p_44_14 5.017838e-04
Rpv_43_14 p_43_14 p_43_15 5.017838e-04
Rph_43_15 p_43_15 p_44_15 5.017838e-04
Rpv_43_15 p_43_15 p_43_16 5.017838e-04
Rph_43_16 p_43_16 p_44_16 5.017838e-04
Rpv_43_16 p_43_16 p_43_17 5.017838e-04
Rph_43_17 p_43_17 p_44_17 5.017838e-04
Rpv_43_17 p_43_17 p_43_18 5.017838e-04
Rph_43_18 p_43_18 p_44_18 5.017838e-04
Rpv_43_18 p_43_18 p_43_19 5.017838e-04
Rph_43_19 p_43_19 p_44_19 5.017838e-04
Rpv_43_19 p_43_19 p_43_20 5.017838e-04
Rph_43_20 p_43_20 p_44_20 5.017838e-04
Rpv_43_20 p_43_20 p_43_21 5.017838e-04
Rph_43_21 p_43_21 p_44_21 5.017838e-04
Rpv_43_21 p_43_21 p_43_22 5.017838e-04
Rph_43_22 p_43_22 p_44_22 5.017838e-04
Rpv_43_22 p_43_22 p_43_23 5.017838e-04
Rph_43_23 p_43_23 p_44_23 5.017838e-04
Rpv_43_23 p_43_23 p_43_24 5.017838e-04
Rph_43_24 p_43_24 p_44_24 5.017838e-04
Rpv_43_24 p_43_24 p_43_25 5.017838e-04
Rph_43_25 p_43_25 p_44_25 5.017838e-04
Rpv_43_25 p_43_25 p_43_26 5.017838e-04
Rph_43_26 p_43_26 p_44_26 5.017838e-04
Rpv_43_26 p_43_26 p_43_27 5.017838e-04
Rph_43_27 p_43_27 p_44_27 5.017838e-04
Rpv_43_27 p_43_27 p_43_28 5.017838e-04
Rph_43_28 p_43_28 p_44_28 5.017838e-04
Rpv_43_28 p_43_28 p_43_29 5.017838e-04
Rph_43_29 p_43_29 p_44_29 5.017838e-04
Rpv_43_29 p_43_29 p_43_30 5.017838e-04
Rph_43_30 p_43_30 p_44_30 5.017838e-04
Rpv_43_30 p_43_30 p_43_31 5.017838e-04
Rph_43_31 p_43_31 p_44_31 5.017838e-04
Rpv_43_31 p_43_31 p_43_32 5.017838e-04
Rph_43_32 p_43_32 p_44_32 5.017838e-04
Rpv_43_32 p_43_32 p_43_33 5.017838e-04
Rph_43_33 p_43_33 p_44_33 5.017838e-04
Rpv_43_33 p_43_33 p_43_34 5.017838e-04
Rph_43_34 p_43_34 p_44_34 5.017838e-04
Rpv_43_34 p_43_34 p_43_35 5.017838e-04
Rph_43_35 p_43_35 p_44_35 5.017838e-04
Rpv_43_35 p_43_35 p_43_36 5.017838e-04
Rph_43_36 p_43_36 p_44_36 5.017838e-04
Rpv_43_36 p_43_36 p_43_37 5.017838e-04
Rph_43_37 p_43_37 p_44_37 5.017838e-04
Rpv_43_37 p_43_37 p_43_38 5.017838e-04
Rph_43_38 p_43_38 p_44_38 5.017838e-04
Rpv_43_38 p_43_38 p_43_39 5.017838e-04
Rph_43_39 p_43_39 p_44_39 5.017838e-04
Rpv_43_39 p_43_39 p_43_40 5.017838e-04
Rph_43_40 p_43_40 p_44_40 5.017838e-04
Rpv_43_40 p_43_40 p_43_41 5.017838e-04
Rph_43_41 p_43_41 p_44_41 5.017838e-04
Rpv_43_41 p_43_41 p_43_42 5.017838e-04
Rph_43_42 p_43_42 p_44_42 5.017838e-04
Rpv_43_42 p_43_42 p_43_43 5.017838e-04
Rph_43_43 p_43_43 p_44_43 5.017838e-04
Rpv_43_43 p_43_43 p_43_44 5.017838e-04
Rph_43_44 p_43_44 p_44_44 5.017838e-04
Rpv_43_44 p_43_44 p_43_45 5.017838e-04
Rph_43_45 p_43_45 p_44_45 5.017838e-04
Rpv_43_45 p_43_45 p_43_46 5.017838e-04
Rph_43_46 p_43_46 p_44_46 5.017838e-04
Rpv_43_46 p_43_46 p_43_47 5.017838e-04
Rph_43_47 p_43_47 p_44_47 5.017838e-04
Rpv_43_47 p_43_47 p_43_48 5.017838e-04
Rph_43_48 p_43_48 p_44_48 5.017838e-04
Rpv_43_48 p_43_48 p_43_49 5.017838e-04
Rph_43_49 p_43_49 p_44_49 5.017838e-04
Rpv_43_49 p_43_49 p_43_50 5.017838e-04
Rph_43_50 p_43_50 p_44_50 5.017838e-04
Rpv_43_50 p_43_50 p_43_51 5.017838e-04
Rph_43_51 p_43_51 p_44_51 5.017838e-04
Rpv_43_51 p_43_51 p_43_52 5.017838e-04
Rph_43_52 p_43_52 p_44_52 5.017838e-04
Rpv_43_52 p_43_52 p_43_53 5.017838e-04
Rph_43_53 p_43_53 p_44_53 5.017838e-04
Rpv_43_53 p_43_53 p_43_54 5.017838e-04
Rph_43_54 p_43_54 p_44_54 5.017838e-04
Rpv_43_54 p_43_54 p_43_55 5.017838e-04
Rph_43_55 p_43_55 p_44_55 5.017838e-04
Rpv_43_55 p_43_55 p_43_56 5.017838e-04
Rph_43_56 p_43_56 p_44_56 5.017838e-04
Rpv_43_56 p_43_56 p_43_57 5.017838e-04
Rph_43_57 p_43_57 p_44_57 5.017838e-04
Rpv_43_57 p_43_57 p_43_58 5.017838e-04
Rph_43_58 p_43_58 p_44_58 5.017838e-04
Rpv_43_58 p_43_58 p_43_59 5.017838e-04
Rph_43_59 p_43_59 p_44_59 5.017838e-04
Rpv_43_59 p_43_59 p_43_60 5.017838e-04
Rph_43_60 p_43_60 p_44_60 5.017838e-04
Rpv_43_60 p_43_60 p_43_61 5.017838e-04
Rph_43_61 p_43_61 p_44_61 5.017838e-04
Rpv_43_61 p_43_61 p_43_62 5.017838e-04
Rph_43_62 p_43_62 p_44_62 5.017838e-04
Rpv_43_62 p_43_62 p_43_63 5.017838e-04
Rph_43_63 p_43_63 p_44_63 5.017838e-04
Rpv_43_63 p_43_63 p_43_64 5.017838e-04
Rph_43_64 p_43_64 p_44_64 5.017838e-04
Rpv_43_64 p_43_64 p_43_65 5.017838e-04
Rph_43_65 p_43_65 p_44_65 5.017838e-04
Rpv_43_65 p_43_65 p_43_66 5.017838e-04
Rph_43_66 p_43_66 p_44_66 5.017838e-04
Rpv_43_66 p_43_66 p_43_67 5.017838e-04
Rph_43_67 p_43_67 p_44_67 5.017838e-04
Rpv_43_67 p_43_67 p_43_68 5.017838e-04
Rph_43_68 p_43_68 p_44_68 5.017838e-04
Rpv_43_68 p_43_68 p_43_69 5.017838e-04
Rph_43_69 p_43_69 p_44_69 5.017838e-04
Rpv_43_69 p_43_69 p_43_70 5.017838e-04
Rph_43_70 p_43_70 p_44_70 5.017838e-04
Rpv_43_70 p_43_70 p_43_71 5.017838e-04
Rph_43_71 p_43_71 p_44_71 5.017838e-04
Rph_44_0 p_44_0 p_45_0 5.017838e-04
Rpv_44_0 p_44_0 p_44_1 5.017838e-04
Rph_44_1 p_44_1 p_45_1 5.017838e-04
Rpv_44_1 p_44_1 p_44_2 5.017838e-04
Rph_44_2 p_44_2 p_45_2 5.017838e-04
Rpv_44_2 p_44_2 p_44_3 5.017838e-04
Rph_44_3 p_44_3 p_45_3 5.017838e-04
Rpv_44_3 p_44_3 p_44_4 5.017838e-04
Rph_44_4 p_44_4 p_45_4 5.017838e-04
Rpv_44_4 p_44_4 p_44_5 5.017838e-04
Rph_44_5 p_44_5 p_45_5 5.017838e-04
Rpv_44_5 p_44_5 p_44_6 5.017838e-04
Rph_44_6 p_44_6 p_45_6 5.017838e-04
Rpv_44_6 p_44_6 p_44_7 5.017838e-04
Rph_44_7 p_44_7 p_45_7 5.017838e-04
Rpv_44_7 p_44_7 p_44_8 5.017838e-04
Rph_44_8 p_44_8 p_45_8 5.017838e-04
Rpv_44_8 p_44_8 p_44_9 5.017838e-04
Rph_44_9 p_44_9 p_45_9 5.017838e-04
Rpv_44_9 p_44_9 p_44_10 5.017838e-04
Rph_44_10 p_44_10 p_45_10 5.017838e-04
Rpv_44_10 p_44_10 p_44_11 5.017838e-04
Rph_44_11 p_44_11 p_45_11 5.017838e-04
Rpv_44_11 p_44_11 p_44_12 5.017838e-04
Rph_44_12 p_44_12 p_45_12 5.017838e-04
Rpv_44_12 p_44_12 p_44_13 5.017838e-04
Rph_44_13 p_44_13 p_45_13 5.017838e-04
Rpv_44_13 p_44_13 p_44_14 5.017838e-04
Rph_44_14 p_44_14 p_45_14 5.017838e-04
Rpv_44_14 p_44_14 p_44_15 5.017838e-04
Rph_44_15 p_44_15 p_45_15 5.017838e-04
Rpv_44_15 p_44_15 p_44_16 5.017838e-04
Rph_44_16 p_44_16 p_45_16 5.017838e-04
Rpv_44_16 p_44_16 p_44_17 5.017838e-04
Rph_44_17 p_44_17 p_45_17 5.017838e-04
Rpv_44_17 p_44_17 p_44_18 5.017838e-04
Rph_44_18 p_44_18 p_45_18 5.017838e-04
Rpv_44_18 p_44_18 p_44_19 5.017838e-04
Rph_44_19 p_44_19 p_45_19 5.017838e-04
Rpv_44_19 p_44_19 p_44_20 5.017838e-04
Rph_44_20 p_44_20 p_45_20 5.017838e-04
Rpv_44_20 p_44_20 p_44_21 5.017838e-04
Rph_44_21 p_44_21 p_45_21 5.017838e-04
Rpv_44_21 p_44_21 p_44_22 5.017838e-04
Rph_44_22 p_44_22 p_45_22 5.017838e-04
Rpv_44_22 p_44_22 p_44_23 5.017838e-04
Rph_44_23 p_44_23 p_45_23 5.017838e-04
Rpv_44_23 p_44_23 p_44_24 5.017838e-04
Rph_44_24 p_44_24 p_45_24 5.017838e-04
Rpv_44_24 p_44_24 p_44_25 5.017838e-04
Rph_44_25 p_44_25 p_45_25 5.017838e-04
Rpv_44_25 p_44_25 p_44_26 5.017838e-04
Rph_44_26 p_44_26 p_45_26 5.017838e-04
Rpv_44_26 p_44_26 p_44_27 5.017838e-04
Rph_44_27 p_44_27 p_45_27 5.017838e-04
Rpv_44_27 p_44_27 p_44_28 5.017838e-04
Rph_44_28 p_44_28 p_45_28 5.017838e-04
Rpv_44_28 p_44_28 p_44_29 5.017838e-04
Rph_44_29 p_44_29 p_45_29 5.017838e-04
Rpv_44_29 p_44_29 p_44_30 5.017838e-04
Rph_44_30 p_44_30 p_45_30 5.017838e-04
Rpv_44_30 p_44_30 p_44_31 5.017838e-04
Rph_44_31 p_44_31 p_45_31 5.017838e-04
Rpv_44_31 p_44_31 p_44_32 5.017838e-04
Rph_44_32 p_44_32 p_45_32 5.017838e-04
Rpv_44_32 p_44_32 p_44_33 5.017838e-04
Rph_44_33 p_44_33 p_45_33 5.017838e-04
Rpv_44_33 p_44_33 p_44_34 5.017838e-04
Rph_44_34 p_44_34 p_45_34 5.017838e-04
Rpv_44_34 p_44_34 p_44_35 5.017838e-04
Rph_44_35 p_44_35 p_45_35 5.017838e-04
Rpv_44_35 p_44_35 p_44_36 5.017838e-04
Rph_44_36 p_44_36 p_45_36 5.017838e-04
Rpv_44_36 p_44_36 p_44_37 5.017838e-04
Rph_44_37 p_44_37 p_45_37 5.017838e-04
Rpv_44_37 p_44_37 p_44_38 5.017838e-04
Rph_44_38 p_44_38 p_45_38 5.017838e-04
Rpv_44_38 p_44_38 p_44_39 5.017838e-04
Rph_44_39 p_44_39 p_45_39 5.017838e-04
Rpv_44_39 p_44_39 p_44_40 5.017838e-04
Rph_44_40 p_44_40 p_45_40 5.017838e-04
Rpv_44_40 p_44_40 p_44_41 5.017838e-04
Rph_44_41 p_44_41 p_45_41 5.017838e-04
Rpv_44_41 p_44_41 p_44_42 5.017838e-04
Rph_44_42 p_44_42 p_45_42 5.017838e-04
Rpv_44_42 p_44_42 p_44_43 5.017838e-04
Rph_44_43 p_44_43 p_45_43 5.017838e-04
Rpv_44_43 p_44_43 p_44_44 5.017838e-04
Rph_44_44 p_44_44 p_45_44 5.017838e-04
Rpv_44_44 p_44_44 p_44_45 5.017838e-04
Rph_44_45 p_44_45 p_45_45 5.017838e-04
Rpv_44_45 p_44_45 p_44_46 5.017838e-04
Rph_44_46 p_44_46 p_45_46 5.017838e-04
Rpv_44_46 p_44_46 p_44_47 5.017838e-04
Rph_44_47 p_44_47 p_45_47 5.017838e-04
Rpv_44_47 p_44_47 p_44_48 5.017838e-04
Rph_44_48 p_44_48 p_45_48 5.017838e-04
Rpv_44_48 p_44_48 p_44_49 5.017838e-04
Rph_44_49 p_44_49 p_45_49 5.017838e-04
Rpv_44_49 p_44_49 p_44_50 5.017838e-04
Rph_44_50 p_44_50 p_45_50 5.017838e-04
Rpv_44_50 p_44_50 p_44_51 5.017838e-04
Rph_44_51 p_44_51 p_45_51 5.017838e-04
Rpv_44_51 p_44_51 p_44_52 5.017838e-04
Rph_44_52 p_44_52 p_45_52 5.017838e-04
Rpv_44_52 p_44_52 p_44_53 5.017838e-04
Rph_44_53 p_44_53 p_45_53 5.017838e-04
Rpv_44_53 p_44_53 p_44_54 5.017838e-04
Rph_44_54 p_44_54 p_45_54 5.017838e-04
Rpv_44_54 p_44_54 p_44_55 5.017838e-04
Rph_44_55 p_44_55 p_45_55 5.017838e-04
Rpv_44_55 p_44_55 p_44_56 5.017838e-04
Rph_44_56 p_44_56 p_45_56 5.017838e-04
Rpv_44_56 p_44_56 p_44_57 5.017838e-04
Rph_44_57 p_44_57 p_45_57 5.017838e-04
Rpv_44_57 p_44_57 p_44_58 5.017838e-04
Rph_44_58 p_44_58 p_45_58 5.017838e-04
Rpv_44_58 p_44_58 p_44_59 5.017838e-04
Rph_44_59 p_44_59 p_45_59 5.017838e-04
Rpv_44_59 p_44_59 p_44_60 5.017838e-04
Rph_44_60 p_44_60 p_45_60 5.017838e-04
Rpv_44_60 p_44_60 p_44_61 5.017838e-04
Rph_44_61 p_44_61 p_45_61 5.017838e-04
Rpv_44_61 p_44_61 p_44_62 5.017838e-04
Rph_44_62 p_44_62 p_45_62 5.017838e-04
Rpv_44_62 p_44_62 p_44_63 5.017838e-04
Rph_44_63 p_44_63 p_45_63 5.017838e-04
Rpv_44_63 p_44_63 p_44_64 5.017838e-04
Rph_44_64 p_44_64 p_45_64 5.017838e-04
Rpv_44_64 p_44_64 p_44_65 5.017838e-04
Rph_44_65 p_44_65 p_45_65 5.017838e-04
Rpv_44_65 p_44_65 p_44_66 5.017838e-04
Rph_44_66 p_44_66 p_45_66 5.017838e-04
Rpv_44_66 p_44_66 p_44_67 5.017838e-04
Rph_44_67 p_44_67 p_45_67 5.017838e-04
Rpv_44_67 p_44_67 p_44_68 5.017838e-04
Rph_44_68 p_44_68 p_45_68 5.017838e-04
Rpv_44_68 p_44_68 p_44_69 5.017838e-04
Rph_44_69 p_44_69 p_45_69 5.017838e-04
Rpv_44_69 p_44_69 p_44_70 5.017838e-04
Rph_44_70 p_44_70 p_45_70 5.017838e-04
Rpv_44_70 p_44_70 p_44_71 5.017838e-04
Rph_44_71 p_44_71 p_45_71 5.017838e-04
Rph_45_0 p_45_0 p_46_0 5.017838e-04
Rpv_45_0 p_45_0 p_45_1 5.017838e-04
Rph_45_1 p_45_1 p_46_1 5.017838e-04
Rpv_45_1 p_45_1 p_45_2 5.017838e-04
Rph_45_2 p_45_2 p_46_2 5.017838e-04
Rpv_45_2 p_45_2 p_45_3 5.017838e-04
Rph_45_3 p_45_3 p_46_3 5.017838e-04
Rpv_45_3 p_45_3 p_45_4 5.017838e-04
Rph_45_4 p_45_4 p_46_4 5.017838e-04
Rpv_45_4 p_45_4 p_45_5 5.017838e-04
Rph_45_5 p_45_5 p_46_5 5.017838e-04
Rpv_45_5 p_45_5 p_45_6 5.017838e-04
Rph_45_6 p_45_6 p_46_6 5.017838e-04
Rpv_45_6 p_45_6 p_45_7 5.017838e-04
Rph_45_7 p_45_7 p_46_7 5.017838e-04
Rpv_45_7 p_45_7 p_45_8 5.017838e-04
Rph_45_8 p_45_8 p_46_8 5.017838e-04
Rpv_45_8 p_45_8 p_45_9 5.017838e-04
Rph_45_9 p_45_9 p_46_9 5.017838e-04
Rpv_45_9 p_45_9 p_45_10 5.017838e-04
Rph_45_10 p_45_10 p_46_10 5.017838e-04
Rpv_45_10 p_45_10 p_45_11 5.017838e-04
Rph_45_11 p_45_11 p_46_11 5.017838e-04
Rpv_45_11 p_45_11 p_45_12 5.017838e-04
Rph_45_12 p_45_12 p_46_12 5.017838e-04
Rpv_45_12 p_45_12 p_45_13 5.017838e-04
Rph_45_13 p_45_13 p_46_13 5.017838e-04
Rpv_45_13 p_45_13 p_45_14 5.017838e-04
Rph_45_14 p_45_14 p_46_14 5.017838e-04
Rpv_45_14 p_45_14 p_45_15 5.017838e-04
Rph_45_15 p_45_15 p_46_15 5.017838e-04
Rpv_45_15 p_45_15 p_45_16 5.017838e-04
Rph_45_16 p_45_16 p_46_16 5.017838e-04
Rpv_45_16 p_45_16 p_45_17 5.017838e-04
Rph_45_17 p_45_17 p_46_17 5.017838e-04
Rpv_45_17 p_45_17 p_45_18 5.017838e-04
Rph_45_18 p_45_18 p_46_18 5.017838e-04
Rpv_45_18 p_45_18 p_45_19 5.017838e-04
Rph_45_19 p_45_19 p_46_19 5.017838e-04
Rpv_45_19 p_45_19 p_45_20 5.017838e-04
Rph_45_20 p_45_20 p_46_20 5.017838e-04
Rpv_45_20 p_45_20 p_45_21 5.017838e-04
Rph_45_21 p_45_21 p_46_21 5.017838e-04
Rpv_45_21 p_45_21 p_45_22 5.017838e-04
Rph_45_22 p_45_22 p_46_22 5.017838e-04
Rpv_45_22 p_45_22 p_45_23 5.017838e-04
Rph_45_23 p_45_23 p_46_23 5.017838e-04
Rpv_45_23 p_45_23 p_45_24 5.017838e-04
Rph_45_24 p_45_24 p_46_24 5.017838e-04
Rpv_45_24 p_45_24 p_45_25 5.017838e-04
Rph_45_25 p_45_25 p_46_25 5.017838e-04
Rpv_45_25 p_45_25 p_45_26 5.017838e-04
Rph_45_26 p_45_26 p_46_26 5.017838e-04
Rpv_45_26 p_45_26 p_45_27 5.017838e-04
Rph_45_27 p_45_27 p_46_27 5.017838e-04
Rpv_45_27 p_45_27 p_45_28 5.017838e-04
Rph_45_28 p_45_28 p_46_28 5.017838e-04
Rpv_45_28 p_45_28 p_45_29 5.017838e-04
Rph_45_29 p_45_29 p_46_29 5.017838e-04
Rpv_45_29 p_45_29 p_45_30 5.017838e-04
Rph_45_30 p_45_30 p_46_30 5.017838e-04
Rpv_45_30 p_45_30 p_45_31 5.017838e-04
Rph_45_31 p_45_31 p_46_31 5.017838e-04
Rpv_45_31 p_45_31 p_45_32 5.017838e-04
Rph_45_32 p_45_32 p_46_32 5.017838e-04
Rpv_45_32 p_45_32 p_45_33 5.017838e-04
Rph_45_33 p_45_33 p_46_33 5.017838e-04
Rpv_45_33 p_45_33 p_45_34 5.017838e-04
Rph_45_34 p_45_34 p_46_34 5.017838e-04
Rpv_45_34 p_45_34 p_45_35 5.017838e-04
Rph_45_35 p_45_35 p_46_35 5.017838e-04
Rpv_45_35 p_45_35 p_45_36 5.017838e-04
Rph_45_36 p_45_36 p_46_36 5.017838e-04
Rpv_45_36 p_45_36 p_45_37 5.017838e-04
Rph_45_37 p_45_37 p_46_37 5.017838e-04
Rpv_45_37 p_45_37 p_45_38 5.017838e-04
Rph_45_38 p_45_38 p_46_38 5.017838e-04
Rpv_45_38 p_45_38 p_45_39 5.017838e-04
Rph_45_39 p_45_39 p_46_39 5.017838e-04
Rpv_45_39 p_45_39 p_45_40 5.017838e-04
Rph_45_40 p_45_40 p_46_40 5.017838e-04
Rpv_45_40 p_45_40 p_45_41 5.017838e-04
Rph_45_41 p_45_41 p_46_41 5.017838e-04
Rpv_45_41 p_45_41 p_45_42 5.017838e-04
Rph_45_42 p_45_42 p_46_42 5.017838e-04
Rpv_45_42 p_45_42 p_45_43 5.017838e-04
Rph_45_43 p_45_43 p_46_43 5.017838e-04
Rpv_45_43 p_45_43 p_45_44 5.017838e-04
Rph_45_44 p_45_44 p_46_44 5.017838e-04
Rpv_45_44 p_45_44 p_45_45 5.017838e-04
Rph_45_45 p_45_45 p_46_45 5.017838e-04
Rpv_45_45 p_45_45 p_45_46 5.017838e-04
Rph_45_46 p_45_46 p_46_46 5.017838e-04
Rpv_45_46 p_45_46 p_45_47 5.017838e-04
Rph_45_47 p_45_47 p_46_47 5.017838e-04
Rpv_45_47 p_45_47 p_45_48 5.017838e-04
Rph_45_48 p_45_48 p_46_48 5.017838e-04
Rpv_45_48 p_45_48 p_45_49 5.017838e-04
Rph_45_49 p_45_49 p_46_49 5.017838e-04
Rpv_45_49 p_45_49 p_45_50 5.017838e-04
Rph_45_50 p_45_50 p_46_50 5.017838e-04
Rpv_45_50 p_45_50 p_45_51 5.017838e-04
Rph_45_51 p_45_51 p_46_51 5.017838e-04
Rpv_45_51 p_45_51 p_45_52 5.017838e-04
Rph_45_52 p_45_52 p_46_52 5.017838e-04
Rpv_45_52 p_45_52 p_45_53 5.017838e-04
Rph_45_53 p_45_53 p_46_53 5.017838e-04
Rpv_45_53 p_45_53 p_45_54 5.017838e-04
Rph_45_54 p_45_54 p_46_54 5.017838e-04
Rpv_45_54 p_45_54 p_45_55 5.017838e-04
Rph_45_55 p_45_55 p_46_55 5.017838e-04
Rpv_45_55 p_45_55 p_45_56 5.017838e-04
Rph_45_56 p_45_56 p_46_56 5.017838e-04
Rpv_45_56 p_45_56 p_45_57 5.017838e-04
Rph_45_57 p_45_57 p_46_57 5.017838e-04
Rpv_45_57 p_45_57 p_45_58 5.017838e-04
Rph_45_58 p_45_58 p_46_58 5.017838e-04
Rpv_45_58 p_45_58 p_45_59 5.017838e-04
Rph_45_59 p_45_59 p_46_59 5.017838e-04
Rpv_45_59 p_45_59 p_45_60 5.017838e-04
Rph_45_60 p_45_60 p_46_60 5.017838e-04
Rpv_45_60 p_45_60 p_45_61 5.017838e-04
Rph_45_61 p_45_61 p_46_61 5.017838e-04
Rpv_45_61 p_45_61 p_45_62 5.017838e-04
Rph_45_62 p_45_62 p_46_62 5.017838e-04
Rpv_45_62 p_45_62 p_45_63 5.017838e-04
Rph_45_63 p_45_63 p_46_63 5.017838e-04
Rpv_45_63 p_45_63 p_45_64 5.017838e-04
Rph_45_64 p_45_64 p_46_64 5.017838e-04
Rpv_45_64 p_45_64 p_45_65 5.017838e-04
Rph_45_65 p_45_65 p_46_65 5.017838e-04
Rpv_45_65 p_45_65 p_45_66 5.017838e-04
Rph_45_66 p_45_66 p_46_66 5.017838e-04
Rpv_45_66 p_45_66 p_45_67 5.017838e-04
Rph_45_67 p_45_67 p_46_67 5.017838e-04
Rpv_45_67 p_45_67 p_45_68 5.017838e-04
Rph_45_68 p_45_68 p_46_68 5.017838e-04
Rpv_45_68 p_45_68 p_45_69 5.017838e-04
Rph_45_69 p_45_69 p_46_69 5.017838e-04
Rpv_45_69 p_45_69 p_45_70 5.017838e-04
Rph_45_70 p_45_70 p_46_70 5.017838e-04
Rpv_45_70 p_45_70 p_45_71 5.017838e-04
Rph_45_71 p_45_71 p_46_71 5.017838e-04
Rph_46_0 p_46_0 p_47_0 5.017838e-04
Rpv_46_0 p_46_0 p_46_1 5.017838e-04
Rph_46_1 p_46_1 p_47_1 5.017838e-04
Rpv_46_1 p_46_1 p_46_2 5.017838e-04
Rph_46_2 p_46_2 p_47_2 5.017838e-04
Rpv_46_2 p_46_2 p_46_3 5.017838e-04
Rph_46_3 p_46_3 p_47_3 5.017838e-04
Rpv_46_3 p_46_3 p_46_4 5.017838e-04
Rph_46_4 p_46_4 p_47_4 5.017838e-04
Rpv_46_4 p_46_4 p_46_5 5.017838e-04
Rph_46_5 p_46_5 p_47_5 5.017838e-04
Rpv_46_5 p_46_5 p_46_6 5.017838e-04
Rph_46_6 p_46_6 p_47_6 5.017838e-04
Rpv_46_6 p_46_6 p_46_7 5.017838e-04
Rph_46_7 p_46_7 p_47_7 5.017838e-04
Rpv_46_7 p_46_7 p_46_8 5.017838e-04
Rph_46_8 p_46_8 p_47_8 5.017838e-04
Rpv_46_8 p_46_8 p_46_9 5.017838e-04
Rph_46_9 p_46_9 p_47_9 5.017838e-04
Rpv_46_9 p_46_9 p_46_10 5.017838e-04
Rph_46_10 p_46_10 p_47_10 5.017838e-04
Rpv_46_10 p_46_10 p_46_11 5.017838e-04
Rph_46_11 p_46_11 p_47_11 5.017838e-04
Rpv_46_11 p_46_11 p_46_12 5.017838e-04
Rph_46_12 p_46_12 p_47_12 5.017838e-04
Rpv_46_12 p_46_12 p_46_13 5.017838e-04
Rph_46_13 p_46_13 p_47_13 5.017838e-04
Rpv_46_13 p_46_13 p_46_14 5.017838e-04
Rph_46_14 p_46_14 p_47_14 5.017838e-04
Rpv_46_14 p_46_14 p_46_15 5.017838e-04
Rph_46_15 p_46_15 p_47_15 5.017838e-04
Rpv_46_15 p_46_15 p_46_16 5.017838e-04
Rph_46_16 p_46_16 p_47_16 5.017838e-04
Rpv_46_16 p_46_16 p_46_17 5.017838e-04
Rph_46_17 p_46_17 p_47_17 5.017838e-04
Rpv_46_17 p_46_17 p_46_18 5.017838e-04
Rph_46_18 p_46_18 p_47_18 5.017838e-04
Rpv_46_18 p_46_18 p_46_19 5.017838e-04
Rph_46_19 p_46_19 p_47_19 5.017838e-04
Rpv_46_19 p_46_19 p_46_20 5.017838e-04
Rph_46_20 p_46_20 p_47_20 5.017838e-04
Rpv_46_20 p_46_20 p_46_21 5.017838e-04
Rph_46_21 p_46_21 p_47_21 5.017838e-04
Rpv_46_21 p_46_21 p_46_22 5.017838e-04
Rph_46_22 p_46_22 p_47_22 5.017838e-04
Rpv_46_22 p_46_22 p_46_23 5.017838e-04
Rph_46_23 p_46_23 p_47_23 5.017838e-04
Rpv_46_23 p_46_23 p_46_24 5.017838e-04
Rph_46_24 p_46_24 p_47_24 5.017838e-04
Rpv_46_24 p_46_24 p_46_25 5.017838e-04
Rph_46_25 p_46_25 p_47_25 5.017838e-04
Rpv_46_25 p_46_25 p_46_26 5.017838e-04
Rph_46_26 p_46_26 p_47_26 5.017838e-04
Rpv_46_26 p_46_26 p_46_27 5.017838e-04
Rph_46_27 p_46_27 p_47_27 5.017838e-04
Rpv_46_27 p_46_27 p_46_28 5.017838e-04
Rph_46_28 p_46_28 p_47_28 5.017838e-04
Rpv_46_28 p_46_28 p_46_29 5.017838e-04
Rph_46_29 p_46_29 p_47_29 5.017838e-04
Rpv_46_29 p_46_29 p_46_30 5.017838e-04
Rph_46_30 p_46_30 p_47_30 5.017838e-04
Rpv_46_30 p_46_30 p_46_31 5.017838e-04
Rph_46_31 p_46_31 p_47_31 5.017838e-04
Rpv_46_31 p_46_31 p_46_32 5.017838e-04
Rph_46_32 p_46_32 p_47_32 5.017838e-04
Rpv_46_32 p_46_32 p_46_33 5.017838e-04
Rph_46_33 p_46_33 p_47_33 5.017838e-04
Rpv_46_33 p_46_33 p_46_34 5.017838e-04
Rph_46_34 p_46_34 p_47_34 5.017838e-04
Rpv_46_34 p_46_34 p_46_35 5.017838e-04
Rph_46_35 p_46_35 p_47_35 5.017838e-04
Rpv_46_35 p_46_35 p_46_36 5.017838e-04
Rph_46_36 p_46_36 p_47_36 5.017838e-04
Rpv_46_36 p_46_36 p_46_37 5.017838e-04
Rph_46_37 p_46_37 p_47_37 5.017838e-04
Rpv_46_37 p_46_37 p_46_38 5.017838e-04
Rph_46_38 p_46_38 p_47_38 5.017838e-04
Rpv_46_38 p_46_38 p_46_39 5.017838e-04
Rph_46_39 p_46_39 p_47_39 5.017838e-04
Rpv_46_39 p_46_39 p_46_40 5.017838e-04
Rph_46_40 p_46_40 p_47_40 5.017838e-04
Rpv_46_40 p_46_40 p_46_41 5.017838e-04
Rph_46_41 p_46_41 p_47_41 5.017838e-04
Rpv_46_41 p_46_41 p_46_42 5.017838e-04
Rph_46_42 p_46_42 p_47_42 5.017838e-04
Rpv_46_42 p_46_42 p_46_43 5.017838e-04
Rph_46_43 p_46_43 p_47_43 5.017838e-04
Rpv_46_43 p_46_43 p_46_44 5.017838e-04
Rph_46_44 p_46_44 p_47_44 5.017838e-04
Rpv_46_44 p_46_44 p_46_45 5.017838e-04
Rph_46_45 p_46_45 p_47_45 5.017838e-04
Rpv_46_45 p_46_45 p_46_46 5.017838e-04
Rph_46_46 p_46_46 p_47_46 5.017838e-04
Rpv_46_46 p_46_46 p_46_47 5.017838e-04
Rph_46_47 p_46_47 p_47_47 5.017838e-04
Rpv_46_47 p_46_47 p_46_48 5.017838e-04
Rph_46_48 p_46_48 p_47_48 5.017838e-04
Rpv_46_48 p_46_48 p_46_49 5.017838e-04
Rph_46_49 p_46_49 p_47_49 5.017838e-04
Rpv_46_49 p_46_49 p_46_50 5.017838e-04
Rph_46_50 p_46_50 p_47_50 5.017838e-04
Rpv_46_50 p_46_50 p_46_51 5.017838e-04
Rph_46_51 p_46_51 p_47_51 5.017838e-04
Rpv_46_51 p_46_51 p_46_52 5.017838e-04
Rph_46_52 p_46_52 p_47_52 5.017838e-04
Rpv_46_52 p_46_52 p_46_53 5.017838e-04
Rph_46_53 p_46_53 p_47_53 5.017838e-04
Rpv_46_53 p_46_53 p_46_54 5.017838e-04
Rph_46_54 p_46_54 p_47_54 5.017838e-04
Rpv_46_54 p_46_54 p_46_55 5.017838e-04
Rph_46_55 p_46_55 p_47_55 5.017838e-04
Rpv_46_55 p_46_55 p_46_56 5.017838e-04
Rph_46_56 p_46_56 p_47_56 5.017838e-04
Rpv_46_56 p_46_56 p_46_57 5.017838e-04
Rph_46_57 p_46_57 p_47_57 5.017838e-04
Rpv_46_57 p_46_57 p_46_58 5.017838e-04
Rph_46_58 p_46_58 p_47_58 5.017838e-04
Rpv_46_58 p_46_58 p_46_59 5.017838e-04
Rph_46_59 p_46_59 p_47_59 5.017838e-04
Rpv_46_59 p_46_59 p_46_60 5.017838e-04
Rph_46_60 p_46_60 p_47_60 5.017838e-04
Rpv_46_60 p_46_60 p_46_61 5.017838e-04
Rph_46_61 p_46_61 p_47_61 5.017838e-04
Rpv_46_61 p_46_61 p_46_62 5.017838e-04
Rph_46_62 p_46_62 p_47_62 5.017838e-04
Rpv_46_62 p_46_62 p_46_63 5.017838e-04
Rph_46_63 p_46_63 p_47_63 5.017838e-04
Rpv_46_63 p_46_63 p_46_64 5.017838e-04
Rph_46_64 p_46_64 p_47_64 5.017838e-04
Rpv_46_64 p_46_64 p_46_65 5.017838e-04
Rph_46_65 p_46_65 p_47_65 5.017838e-04
Rpv_46_65 p_46_65 p_46_66 5.017838e-04
Rph_46_66 p_46_66 p_47_66 5.017838e-04
Rpv_46_66 p_46_66 p_46_67 5.017838e-04
Rph_46_67 p_46_67 p_47_67 5.017838e-04
Rpv_46_67 p_46_67 p_46_68 5.017838e-04
Rph_46_68 p_46_68 p_47_68 5.017838e-04
Rpv_46_68 p_46_68 p_46_69 5.017838e-04
Rph_46_69 p_46_69 p_47_69 5.017838e-04
Rpv_46_69 p_46_69 p_46_70 5.017838e-04
Rph_46_70 p_46_70 p_47_70 5.017838e-04
Rpv_46_70 p_46_70 p_46_71 5.017838e-04
Rph_46_71 p_46_71 p_47_71 5.017838e-04
Rph_47_0 p_47_0 p_48_0 5.017838e-04
Rpv_47_0 p_47_0 p_47_1 5.017838e-04
Rph_47_1 p_47_1 p_48_1 5.017838e-04
Rpv_47_1 p_47_1 p_47_2 5.017838e-04
Rph_47_2 p_47_2 p_48_2 5.017838e-04
Rpv_47_2 p_47_2 p_47_3 5.017838e-04
Rph_47_3 p_47_3 p_48_3 5.017838e-04
Rpv_47_3 p_47_3 p_47_4 5.017838e-04
Rph_47_4 p_47_4 p_48_4 5.017838e-04
Rpv_47_4 p_47_4 p_47_5 5.017838e-04
Rph_47_5 p_47_5 p_48_5 5.017838e-04
Rpv_47_5 p_47_5 p_47_6 5.017838e-04
Rph_47_6 p_47_6 p_48_6 5.017838e-04
Rpv_47_6 p_47_6 p_47_7 5.017838e-04
Rph_47_7 p_47_7 p_48_7 5.017838e-04
Rpv_47_7 p_47_7 p_47_8 5.017838e-04
Rph_47_8 p_47_8 p_48_8 5.017838e-04
Rpv_47_8 p_47_8 p_47_9 5.017838e-04
Rph_47_9 p_47_9 p_48_9 5.017838e-04
Rpv_47_9 p_47_9 p_47_10 5.017838e-04
Rph_47_10 p_47_10 p_48_10 5.017838e-04
Rpv_47_10 p_47_10 p_47_11 5.017838e-04
Rph_47_11 p_47_11 p_48_11 5.017838e-04
Rpv_47_11 p_47_11 p_47_12 5.017838e-04
Rph_47_12 p_47_12 p_48_12 5.017838e-04
Rpv_47_12 p_47_12 p_47_13 5.017838e-04
Rph_47_13 p_47_13 p_48_13 5.017838e-04
Rpv_47_13 p_47_13 p_47_14 5.017838e-04
Rph_47_14 p_47_14 p_48_14 5.017838e-04
Rpv_47_14 p_47_14 p_47_15 5.017838e-04
Rph_47_15 p_47_15 p_48_15 5.017838e-04
Rpv_47_15 p_47_15 p_47_16 5.017838e-04
Rph_47_16 p_47_16 p_48_16 5.017838e-04
Rpv_47_16 p_47_16 p_47_17 5.017838e-04
Rph_47_17 p_47_17 p_48_17 5.017838e-04
Rpv_47_17 p_47_17 p_47_18 5.017838e-04
Rph_47_18 p_47_18 p_48_18 5.017838e-04
Rpv_47_18 p_47_18 p_47_19 5.017838e-04
Rph_47_19 p_47_19 p_48_19 5.017838e-04
Rpv_47_19 p_47_19 p_47_20 5.017838e-04
Rph_47_20 p_47_20 p_48_20 5.017838e-04
Rpv_47_20 p_47_20 p_47_21 5.017838e-04
Rph_47_21 p_47_21 p_48_21 5.017838e-04
Rpv_47_21 p_47_21 p_47_22 5.017838e-04
Rph_47_22 p_47_22 p_48_22 5.017838e-04
Rpv_47_22 p_47_22 p_47_23 5.017838e-04
Rph_47_23 p_47_23 p_48_23 5.017838e-04
Rpv_47_23 p_47_23 p_47_24 5.017838e-04
Rph_47_24 p_47_24 p_48_24 5.017838e-04
Rpv_47_24 p_47_24 p_47_25 5.017838e-04
Rph_47_25 p_47_25 p_48_25 5.017838e-04
Rpv_47_25 p_47_25 p_47_26 5.017838e-04
Rph_47_26 p_47_26 p_48_26 5.017838e-04
Rpv_47_26 p_47_26 p_47_27 5.017838e-04
Rph_47_27 p_47_27 p_48_27 5.017838e-04
Rpv_47_27 p_47_27 p_47_28 5.017838e-04
Rph_47_28 p_47_28 p_48_28 5.017838e-04
Rpv_47_28 p_47_28 p_47_29 5.017838e-04
Rph_47_29 p_47_29 p_48_29 5.017838e-04
Rpv_47_29 p_47_29 p_47_30 5.017838e-04
Rph_47_30 p_47_30 p_48_30 5.017838e-04
Rpv_47_30 p_47_30 p_47_31 5.017838e-04
Rph_47_31 p_47_31 p_48_31 5.017838e-04
Rpv_47_31 p_47_31 p_47_32 5.017838e-04
Rph_47_32 p_47_32 p_48_32 5.017838e-04
Rpv_47_32 p_47_32 p_47_33 5.017838e-04
Rph_47_33 p_47_33 p_48_33 5.017838e-04
Rpv_47_33 p_47_33 p_47_34 5.017838e-04
Rph_47_34 p_47_34 p_48_34 5.017838e-04
Rpv_47_34 p_47_34 p_47_35 5.017838e-04
Rph_47_35 p_47_35 p_48_35 5.017838e-04
Rpv_47_35 p_47_35 p_47_36 5.017838e-04
Rph_47_36 p_47_36 p_48_36 5.017838e-04
Rpv_47_36 p_47_36 p_47_37 5.017838e-04
Rph_47_37 p_47_37 p_48_37 5.017838e-04
Rpv_47_37 p_47_37 p_47_38 5.017838e-04
Rph_47_38 p_47_38 p_48_38 5.017838e-04
Rpv_47_38 p_47_38 p_47_39 5.017838e-04
Rph_47_39 p_47_39 p_48_39 5.017838e-04
Rpv_47_39 p_47_39 p_47_40 5.017838e-04
Rph_47_40 p_47_40 p_48_40 5.017838e-04
Rpv_47_40 p_47_40 p_47_41 5.017838e-04
Rph_47_41 p_47_41 p_48_41 5.017838e-04
Rpv_47_41 p_47_41 p_47_42 5.017838e-04
Rph_47_42 p_47_42 p_48_42 5.017838e-04
Rpv_47_42 p_47_42 p_47_43 5.017838e-04
Rph_47_43 p_47_43 p_48_43 5.017838e-04
Rpv_47_43 p_47_43 p_47_44 5.017838e-04
Rph_47_44 p_47_44 p_48_44 5.017838e-04
Rpv_47_44 p_47_44 p_47_45 5.017838e-04
Rph_47_45 p_47_45 p_48_45 5.017838e-04
Rpv_47_45 p_47_45 p_47_46 5.017838e-04
Rph_47_46 p_47_46 p_48_46 5.017838e-04
Rpv_47_46 p_47_46 p_47_47 5.017838e-04
Rph_47_47 p_47_47 p_48_47 5.017838e-04
Rpv_47_47 p_47_47 p_47_48 5.017838e-04
Rph_47_48 p_47_48 p_48_48 5.017838e-04
Rpv_47_48 p_47_48 p_47_49 5.017838e-04
Rph_47_49 p_47_49 p_48_49 5.017838e-04
Rpv_47_49 p_47_49 p_47_50 5.017838e-04
Rph_47_50 p_47_50 p_48_50 5.017838e-04
Rpv_47_50 p_47_50 p_47_51 5.017838e-04
Rph_47_51 p_47_51 p_48_51 5.017838e-04
Rpv_47_51 p_47_51 p_47_52 5.017838e-04
Rph_47_52 p_47_52 p_48_52 5.017838e-04
Rpv_47_52 p_47_52 p_47_53 5.017838e-04
Rph_47_53 p_47_53 p_48_53 5.017838e-04
Rpv_47_53 p_47_53 p_47_54 5.017838e-04
Rph_47_54 p_47_54 p_48_54 5.017838e-04
Rpv_47_54 p_47_54 p_47_55 5.017838e-04
Rph_47_55 p_47_55 p_48_55 5.017838e-04
Rpv_47_55 p_47_55 p_47_56 5.017838e-04
Rph_47_56 p_47_56 p_48_56 5.017838e-04
Rpv_47_56 p_47_56 p_47_57 5.017838e-04
Rph_47_57 p_47_57 p_48_57 5.017838e-04
Rpv_47_57 p_47_57 p_47_58 5.017838e-04
Rph_47_58 p_47_58 p_48_58 5.017838e-04
Rpv_47_58 p_47_58 p_47_59 5.017838e-04
Rph_47_59 p_47_59 p_48_59 5.017838e-04
Rpv_47_59 p_47_59 p_47_60 5.017838e-04
Rph_47_60 p_47_60 p_48_60 5.017838e-04
Rpv_47_60 p_47_60 p_47_61 5.017838e-04
Rph_47_61 p_47_61 p_48_61 5.017838e-04
Rpv_47_61 p_47_61 p_47_62 5.017838e-04
Rph_47_62 p_47_62 p_48_62 5.017838e-04
Rpv_47_62 p_47_62 p_47_63 5.017838e-04
Rph_47_63 p_47_63 p_48_63 5.017838e-04
Rpv_47_63 p_47_63 p_47_64 5.017838e-04
Rph_47_64 p_47_64 p_48_64 5.017838e-04
Rpv_47_64 p_47_64 p_47_65 5.017838e-04
Rph_47_65 p_47_65 p_48_65 5.017838e-04
Rpv_47_65 p_47_65 p_47_66 5.017838e-04
Rph_47_66 p_47_66 p_48_66 5.017838e-04
Rpv_47_66 p_47_66 p_47_67 5.017838e-04
Rph_47_67 p_47_67 p_48_67 5.017838e-04
Rpv_47_67 p_47_67 p_47_68 5.017838e-04
Rph_47_68 p_47_68 p_48_68 5.017838e-04
Rpv_47_68 p_47_68 p_47_69 5.017838e-04
Rph_47_69 p_47_69 p_48_69 5.017838e-04
Rpv_47_69 p_47_69 p_47_70 5.017838e-04
Rph_47_70 p_47_70 p_48_70 5.017838e-04
Rpv_47_70 p_47_70 p_47_71 5.017838e-04
Rph_47_71 p_47_71 p_48_71 5.017838e-04
Rph_48_0 p_48_0 p_49_0 5.017838e-04
Rpv_48_0 p_48_0 p_48_1 5.017838e-04
Rph_48_1 p_48_1 p_49_1 5.017838e-04
Rpv_48_1 p_48_1 p_48_2 5.017838e-04
Rph_48_2 p_48_2 p_49_2 5.017838e-04
Rpv_48_2 p_48_2 p_48_3 5.017838e-04
Rph_48_3 p_48_3 p_49_3 5.017838e-04
Rpv_48_3 p_48_3 p_48_4 5.017838e-04
Rph_48_4 p_48_4 p_49_4 5.017838e-04
Rpv_48_4 p_48_4 p_48_5 5.017838e-04
Rph_48_5 p_48_5 p_49_5 5.017838e-04
Rpv_48_5 p_48_5 p_48_6 5.017838e-04
Rph_48_6 p_48_6 p_49_6 5.017838e-04
Rpv_48_6 p_48_6 p_48_7 5.017838e-04
Rph_48_7 p_48_7 p_49_7 5.017838e-04
Rpv_48_7 p_48_7 p_48_8 5.017838e-04
Rph_48_8 p_48_8 p_49_8 5.017838e-04
Rpv_48_8 p_48_8 p_48_9 5.017838e-04
Rph_48_9 p_48_9 p_49_9 5.017838e-04
Rpv_48_9 p_48_9 p_48_10 5.017838e-04
Rph_48_10 p_48_10 p_49_10 5.017838e-04
Rpv_48_10 p_48_10 p_48_11 5.017838e-04
Rph_48_11 p_48_11 p_49_11 5.017838e-04
Rpv_48_11 p_48_11 p_48_12 5.017838e-04
Rph_48_12 p_48_12 p_49_12 5.017838e-04
Rpv_48_12 p_48_12 p_48_13 5.017838e-04
Rph_48_13 p_48_13 p_49_13 5.017838e-04
Rpv_48_13 p_48_13 p_48_14 5.017838e-04
Rph_48_14 p_48_14 p_49_14 5.017838e-04
Rpv_48_14 p_48_14 p_48_15 5.017838e-04
Rph_48_15 p_48_15 p_49_15 5.017838e-04
Rpv_48_15 p_48_15 p_48_16 5.017838e-04
Rph_48_16 p_48_16 p_49_16 5.017838e-04
Rpv_48_16 p_48_16 p_48_17 5.017838e-04
Rph_48_17 p_48_17 p_49_17 5.017838e-04
Rpv_48_17 p_48_17 p_48_18 5.017838e-04
Rph_48_18 p_48_18 p_49_18 5.017838e-04
Rpv_48_18 p_48_18 p_48_19 5.017838e-04
Rph_48_19 p_48_19 p_49_19 5.017838e-04
Rpv_48_19 p_48_19 p_48_20 5.017838e-04
Rph_48_20 p_48_20 p_49_20 5.017838e-04
Rpv_48_20 p_48_20 p_48_21 5.017838e-04
Rph_48_21 p_48_21 p_49_21 5.017838e-04
Rpv_48_21 p_48_21 p_48_22 5.017838e-04
Rph_48_22 p_48_22 p_49_22 5.017838e-04
Rpv_48_22 p_48_22 p_48_23 5.017838e-04
Rph_48_23 p_48_23 p_49_23 5.017838e-04
Rpv_48_23 p_48_23 p_48_24 5.017838e-04
Rph_48_24 p_48_24 p_49_24 5.017838e-04
Rpv_48_24 p_48_24 p_48_25 5.017838e-04
Rph_48_25 p_48_25 p_49_25 5.017838e-04
Rpv_48_25 p_48_25 p_48_26 5.017838e-04
Rph_48_26 p_48_26 p_49_26 5.017838e-04
Rpv_48_26 p_48_26 p_48_27 5.017838e-04
Rph_48_27 p_48_27 p_49_27 5.017838e-04
Rpv_48_27 p_48_27 p_48_28 5.017838e-04
Rph_48_28 p_48_28 p_49_28 5.017838e-04
Rpv_48_28 p_48_28 p_48_29 5.017838e-04
Rph_48_29 p_48_29 p_49_29 5.017838e-04
Rpv_48_29 p_48_29 p_48_30 5.017838e-04
Rph_48_30 p_48_30 p_49_30 5.017838e-04
Rpv_48_30 p_48_30 p_48_31 5.017838e-04
Rph_48_31 p_48_31 p_49_31 5.017838e-04
Rpv_48_31 p_48_31 p_48_32 5.017838e-04
Rph_48_32 p_48_32 p_49_32 5.017838e-04
Rpv_48_32 p_48_32 p_48_33 5.017838e-04
Rph_48_33 p_48_33 p_49_33 5.017838e-04
Rpv_48_33 p_48_33 p_48_34 5.017838e-04
Rph_48_34 p_48_34 p_49_34 5.017838e-04
Rpv_48_34 p_48_34 p_48_35 5.017838e-04
Rph_48_35 p_48_35 p_49_35 5.017838e-04
Rpv_48_35 p_48_35 p_48_36 5.017838e-04
Rph_48_36 p_48_36 p_49_36 5.017838e-04
Rpv_48_36 p_48_36 p_48_37 5.017838e-04
Rph_48_37 p_48_37 p_49_37 5.017838e-04
Rpv_48_37 p_48_37 p_48_38 5.017838e-04
Rph_48_38 p_48_38 p_49_38 5.017838e-04
Rpv_48_38 p_48_38 p_48_39 5.017838e-04
Rph_48_39 p_48_39 p_49_39 5.017838e-04
Rpv_48_39 p_48_39 p_48_40 5.017838e-04
Rph_48_40 p_48_40 p_49_40 5.017838e-04
Rpv_48_40 p_48_40 p_48_41 5.017838e-04
Rph_48_41 p_48_41 p_49_41 5.017838e-04
Rpv_48_41 p_48_41 p_48_42 5.017838e-04
Rph_48_42 p_48_42 p_49_42 5.017838e-04
Rpv_48_42 p_48_42 p_48_43 5.017838e-04
Rph_48_43 p_48_43 p_49_43 5.017838e-04
Rpv_48_43 p_48_43 p_48_44 5.017838e-04
Rph_48_44 p_48_44 p_49_44 5.017838e-04
Rpv_48_44 p_48_44 p_48_45 5.017838e-04
Rph_48_45 p_48_45 p_49_45 5.017838e-04
Rpv_48_45 p_48_45 p_48_46 5.017838e-04
Rph_48_46 p_48_46 p_49_46 5.017838e-04
Rpv_48_46 p_48_46 p_48_47 5.017838e-04
Rph_48_47 p_48_47 p_49_47 5.017838e-04
Rpv_48_47 p_48_47 p_48_48 5.017838e-04
Rph_48_48 p_48_48 p_49_48 5.017838e-04
Rpv_48_48 p_48_48 p_48_49 5.017838e-04
Rph_48_49 p_48_49 p_49_49 5.017838e-04
Rpv_48_49 p_48_49 p_48_50 5.017838e-04
Rph_48_50 p_48_50 p_49_50 5.017838e-04
Rpv_48_50 p_48_50 p_48_51 5.017838e-04
Rph_48_51 p_48_51 p_49_51 5.017838e-04
Rpv_48_51 p_48_51 p_48_52 5.017838e-04
Rph_48_52 p_48_52 p_49_52 5.017838e-04
Rpv_48_52 p_48_52 p_48_53 5.017838e-04
Rph_48_53 p_48_53 p_49_53 5.017838e-04
Rpv_48_53 p_48_53 p_48_54 5.017838e-04
Rph_48_54 p_48_54 p_49_54 5.017838e-04
Rpv_48_54 p_48_54 p_48_55 5.017838e-04
Rph_48_55 p_48_55 p_49_55 5.017838e-04
Rpv_48_55 p_48_55 p_48_56 5.017838e-04
Rph_48_56 p_48_56 p_49_56 5.017838e-04
Rpv_48_56 p_48_56 p_48_57 5.017838e-04
Rph_48_57 p_48_57 p_49_57 5.017838e-04
Rpv_48_57 p_48_57 p_48_58 5.017838e-04
Rph_48_58 p_48_58 p_49_58 5.017838e-04
Rpv_48_58 p_48_58 p_48_59 5.017838e-04
Rph_48_59 p_48_59 p_49_59 5.017838e-04
Rpv_48_59 p_48_59 p_48_60 5.017838e-04
Rph_48_60 p_48_60 p_49_60 5.017838e-04
Rpv_48_60 p_48_60 p_48_61 5.017838e-04
Rph_48_61 p_48_61 p_49_61 5.017838e-04
Rpv_48_61 p_48_61 p_48_62 5.017838e-04
Rph_48_62 p_48_62 p_49_62 5.017838e-04
Rpv_48_62 p_48_62 p_48_63 5.017838e-04
Rph_48_63 p_48_63 p_49_63 5.017838e-04
Rpv_48_63 p_48_63 p_48_64 5.017838e-04
Rph_48_64 p_48_64 p_49_64 5.017838e-04
Rpv_48_64 p_48_64 p_48_65 5.017838e-04
Rph_48_65 p_48_65 p_49_65 5.017838e-04
Rpv_48_65 p_48_65 p_48_66 5.017838e-04
Rph_48_66 p_48_66 p_49_66 5.017838e-04
Rpv_48_66 p_48_66 p_48_67 5.017838e-04
Rph_48_67 p_48_67 p_49_67 5.017838e-04
Rpv_48_67 p_48_67 p_48_68 5.017838e-04
Rph_48_68 p_48_68 p_49_68 5.017838e-04
Rpv_48_68 p_48_68 p_48_69 5.017838e-04
Rph_48_69 p_48_69 p_49_69 5.017838e-04
Rpv_48_69 p_48_69 p_48_70 5.017838e-04
Rph_48_70 p_48_70 p_49_70 5.017838e-04
Rpv_48_70 p_48_70 p_48_71 5.017838e-04
Rph_48_71 p_48_71 p_49_71 5.017838e-04
Rph_49_0 p_49_0 p_50_0 5.017838e-04
Rpv_49_0 p_49_0 p_49_1 5.017838e-04
Rph_49_1 p_49_1 p_50_1 5.017838e-04
Rpv_49_1 p_49_1 p_49_2 5.017838e-04
Rph_49_2 p_49_2 p_50_2 5.017838e-04
Rpv_49_2 p_49_2 p_49_3 5.017838e-04
Rph_49_3 p_49_3 p_50_3 5.017838e-04
Rpv_49_3 p_49_3 p_49_4 5.017838e-04
Rph_49_4 p_49_4 p_50_4 5.017838e-04
Rpv_49_4 p_49_4 p_49_5 5.017838e-04
Rph_49_5 p_49_5 p_50_5 5.017838e-04
Rpv_49_5 p_49_5 p_49_6 5.017838e-04
Rph_49_6 p_49_6 p_50_6 5.017838e-04
Rpv_49_6 p_49_6 p_49_7 5.017838e-04
Rph_49_7 p_49_7 p_50_7 5.017838e-04
Rpv_49_7 p_49_7 p_49_8 5.017838e-04
Rph_49_8 p_49_8 p_50_8 5.017838e-04
Rpv_49_8 p_49_8 p_49_9 5.017838e-04
Rph_49_9 p_49_9 p_50_9 5.017838e-04
Rpv_49_9 p_49_9 p_49_10 5.017838e-04
Rph_49_10 p_49_10 p_50_10 5.017838e-04
Rpv_49_10 p_49_10 p_49_11 5.017838e-04
Rph_49_11 p_49_11 p_50_11 5.017838e-04
Rpv_49_11 p_49_11 p_49_12 5.017838e-04
Rph_49_12 p_49_12 p_50_12 5.017838e-04
Rpv_49_12 p_49_12 p_49_13 5.017838e-04
Rph_49_13 p_49_13 p_50_13 5.017838e-04
Rpv_49_13 p_49_13 p_49_14 5.017838e-04
Rph_49_14 p_49_14 p_50_14 5.017838e-04
Rpv_49_14 p_49_14 p_49_15 5.017838e-04
Rph_49_15 p_49_15 p_50_15 5.017838e-04
Rpv_49_15 p_49_15 p_49_16 5.017838e-04
Rph_49_16 p_49_16 p_50_16 5.017838e-04
Rpv_49_16 p_49_16 p_49_17 5.017838e-04
Rph_49_17 p_49_17 p_50_17 5.017838e-04
Rpv_49_17 p_49_17 p_49_18 5.017838e-04
Rph_49_18 p_49_18 p_50_18 5.017838e-04
Rpv_49_18 p_49_18 p_49_19 5.017838e-04
Rph_49_19 p_49_19 p_50_19 5.017838e-04
Rpv_49_19 p_49_19 p_49_20 5.017838e-04
Rph_49_20 p_49_20 p_50_20 5.017838e-04
Rpv_49_20 p_49_20 p_49_21 5.017838e-04
Rph_49_21 p_49_21 p_50_21 5.017838e-04
Rpv_49_21 p_49_21 p_49_22 5.017838e-04
Rph_49_22 p_49_22 p_50_22 5.017838e-04
Rpv_49_22 p_49_22 p_49_23 5.017838e-04
Rph_49_23 p_49_23 p_50_23 5.017838e-04
Rpv_49_23 p_49_23 p_49_24 5.017838e-04
Rph_49_24 p_49_24 p_50_24 5.017838e-04
Rpv_49_24 p_49_24 p_49_25 5.017838e-04
Rph_49_25 p_49_25 p_50_25 5.017838e-04
Rpv_49_25 p_49_25 p_49_26 5.017838e-04
Rph_49_26 p_49_26 p_50_26 5.017838e-04
Rpv_49_26 p_49_26 p_49_27 5.017838e-04
Rph_49_27 p_49_27 p_50_27 5.017838e-04
Rpv_49_27 p_49_27 p_49_28 5.017838e-04
Rph_49_28 p_49_28 p_50_28 5.017838e-04
Rpv_49_28 p_49_28 p_49_29 5.017838e-04
Rph_49_29 p_49_29 p_50_29 5.017838e-04
Rpv_49_29 p_49_29 p_49_30 5.017838e-04
Rph_49_30 p_49_30 p_50_30 5.017838e-04
Rpv_49_30 p_49_30 p_49_31 5.017838e-04
Rph_49_31 p_49_31 p_50_31 5.017838e-04
Rpv_49_31 p_49_31 p_49_32 5.017838e-04
Rph_49_32 p_49_32 p_50_32 5.017838e-04
Rpv_49_32 p_49_32 p_49_33 5.017838e-04
Rph_49_33 p_49_33 p_50_33 5.017838e-04
Rpv_49_33 p_49_33 p_49_34 5.017838e-04
Rph_49_34 p_49_34 p_50_34 5.017838e-04
Rpv_49_34 p_49_34 p_49_35 5.017838e-04
Rph_49_35 p_49_35 p_50_35 5.017838e-04
Rpv_49_35 p_49_35 p_49_36 5.017838e-04
Rph_49_36 p_49_36 p_50_36 5.017838e-04
Rpv_49_36 p_49_36 p_49_37 5.017838e-04
Rph_49_37 p_49_37 p_50_37 5.017838e-04
Rpv_49_37 p_49_37 p_49_38 5.017838e-04
Rph_49_38 p_49_38 p_50_38 5.017838e-04
Rpv_49_38 p_49_38 p_49_39 5.017838e-04
Rph_49_39 p_49_39 p_50_39 5.017838e-04
Rpv_49_39 p_49_39 p_49_40 5.017838e-04
Rph_49_40 p_49_40 p_50_40 5.017838e-04
Rpv_49_40 p_49_40 p_49_41 5.017838e-04
Rph_49_41 p_49_41 p_50_41 5.017838e-04
Rpv_49_41 p_49_41 p_49_42 5.017838e-04
Rph_49_42 p_49_42 p_50_42 5.017838e-04
Rpv_49_42 p_49_42 p_49_43 5.017838e-04
Rph_49_43 p_49_43 p_50_43 5.017838e-04
Rpv_49_43 p_49_43 p_49_44 5.017838e-04
Rph_49_44 p_49_44 p_50_44 5.017838e-04
Rpv_49_44 p_49_44 p_49_45 5.017838e-04
Rph_49_45 p_49_45 p_50_45 5.017838e-04
Rpv_49_45 p_49_45 p_49_46 5.017838e-04
Rph_49_46 p_49_46 p_50_46 5.017838e-04
Rpv_49_46 p_49_46 p_49_47 5.017838e-04
Rph_49_47 p_49_47 p_50_47 5.017838e-04
Rpv_49_47 p_49_47 p_49_48 5.017838e-04
Rph_49_48 p_49_48 p_50_48 5.017838e-04
Rpv_49_48 p_49_48 p_49_49 5.017838e-04
Rph_49_49 p_49_49 p_50_49 5.017838e-04
Rpv_49_49 p_49_49 p_49_50 5.017838e-04
Rph_49_50 p_49_50 p_50_50 5.017838e-04
Rpv_49_50 p_49_50 p_49_51 5.017838e-04
Rph_49_51 p_49_51 p_50_51 5.017838e-04
Rpv_49_51 p_49_51 p_49_52 5.017838e-04
Rph_49_52 p_49_52 p_50_52 5.017838e-04
Rpv_49_52 p_49_52 p_49_53 5.017838e-04
Rph_49_53 p_49_53 p_50_53 5.017838e-04
Rpv_49_53 p_49_53 p_49_54 5.017838e-04
Rph_49_54 p_49_54 p_50_54 5.017838e-04
Rpv_49_54 p_49_54 p_49_55 5.017838e-04
Rph_49_55 p_49_55 p_50_55 5.017838e-04
Rpv_49_55 p_49_55 p_49_56 5.017838e-04
Rph_49_56 p_49_56 p_50_56 5.017838e-04
Rpv_49_56 p_49_56 p_49_57 5.017838e-04
Rph_49_57 p_49_57 p_50_57 5.017838e-04
Rpv_49_57 p_49_57 p_49_58 5.017838e-04
Rph_49_58 p_49_58 p_50_58 5.017838e-04
Rpv_49_58 p_49_58 p_49_59 5.017838e-04
Rph_49_59 p_49_59 p_50_59 5.017838e-04
Rpv_49_59 p_49_59 p_49_60 5.017838e-04
Rph_49_60 p_49_60 p_50_60 5.017838e-04
Rpv_49_60 p_49_60 p_49_61 5.017838e-04
Rph_49_61 p_49_61 p_50_61 5.017838e-04
Rpv_49_61 p_49_61 p_49_62 5.017838e-04
Rph_49_62 p_49_62 p_50_62 5.017838e-04
Rpv_49_62 p_49_62 p_49_63 5.017838e-04
Rph_49_63 p_49_63 p_50_63 5.017838e-04
Rpv_49_63 p_49_63 p_49_64 5.017838e-04
Rph_49_64 p_49_64 p_50_64 5.017838e-04
Rpv_49_64 p_49_64 p_49_65 5.017838e-04
Rph_49_65 p_49_65 p_50_65 5.017838e-04
Rpv_49_65 p_49_65 p_49_66 5.017838e-04
Rph_49_66 p_49_66 p_50_66 5.017838e-04
Rpv_49_66 p_49_66 p_49_67 5.017838e-04
Rph_49_67 p_49_67 p_50_67 5.017838e-04
Rpv_49_67 p_49_67 p_49_68 5.017838e-04
Rph_49_68 p_49_68 p_50_68 5.017838e-04
Rpv_49_68 p_49_68 p_49_69 5.017838e-04
Rph_49_69 p_49_69 p_50_69 5.017838e-04
Rpv_49_69 p_49_69 p_49_70 5.017838e-04
Rph_49_70 p_49_70 p_50_70 5.017838e-04
Rpv_49_70 p_49_70 p_49_71 5.017838e-04
Rph_49_71 p_49_71 p_50_71 5.017838e-04
Rph_50_0 p_50_0 p_51_0 5.017838e-04
Rpv_50_0 p_50_0 p_50_1 5.017838e-04
Rph_50_1 p_50_1 p_51_1 5.017838e-04
Rpv_50_1 p_50_1 p_50_2 5.017838e-04
Rph_50_2 p_50_2 p_51_2 5.017838e-04
Rpv_50_2 p_50_2 p_50_3 5.017838e-04
Rph_50_3 p_50_3 p_51_3 5.017838e-04
Rpv_50_3 p_50_3 p_50_4 5.017838e-04
Rph_50_4 p_50_4 p_51_4 5.017838e-04
Rpv_50_4 p_50_4 p_50_5 5.017838e-04
Rph_50_5 p_50_5 p_51_5 5.017838e-04
Rpv_50_5 p_50_5 p_50_6 5.017838e-04
Rph_50_6 p_50_6 p_51_6 5.017838e-04
Rpv_50_6 p_50_6 p_50_7 5.017838e-04
Rph_50_7 p_50_7 p_51_7 5.017838e-04
Rpv_50_7 p_50_7 p_50_8 5.017838e-04
Rph_50_8 p_50_8 p_51_8 5.017838e-04
Rpv_50_8 p_50_8 p_50_9 5.017838e-04
Rph_50_9 p_50_9 p_51_9 5.017838e-04
Rpv_50_9 p_50_9 p_50_10 5.017838e-04
Rph_50_10 p_50_10 p_51_10 5.017838e-04
Rpv_50_10 p_50_10 p_50_11 5.017838e-04
Rph_50_11 p_50_11 p_51_11 5.017838e-04
Rpv_50_11 p_50_11 p_50_12 5.017838e-04
Rph_50_12 p_50_12 p_51_12 5.017838e-04
Rpv_50_12 p_50_12 p_50_13 5.017838e-04
Rph_50_13 p_50_13 p_51_13 5.017838e-04
Rpv_50_13 p_50_13 p_50_14 5.017838e-04
Rph_50_14 p_50_14 p_51_14 5.017838e-04
Rpv_50_14 p_50_14 p_50_15 5.017838e-04
Rph_50_15 p_50_15 p_51_15 5.017838e-04
Rpv_50_15 p_50_15 p_50_16 5.017838e-04
Rph_50_16 p_50_16 p_51_16 5.017838e-04
Rpv_50_16 p_50_16 p_50_17 5.017838e-04
Rph_50_17 p_50_17 p_51_17 5.017838e-04
Rpv_50_17 p_50_17 p_50_18 5.017838e-04
Rph_50_18 p_50_18 p_51_18 5.017838e-04
Rpv_50_18 p_50_18 p_50_19 5.017838e-04
Rph_50_19 p_50_19 p_51_19 5.017838e-04
Rpv_50_19 p_50_19 p_50_20 5.017838e-04
Rph_50_20 p_50_20 p_51_20 5.017838e-04
Rpv_50_20 p_50_20 p_50_21 5.017838e-04
Rph_50_21 p_50_21 p_51_21 5.017838e-04
Rpv_50_21 p_50_21 p_50_22 5.017838e-04
Rph_50_22 p_50_22 p_51_22 5.017838e-04
Rpv_50_22 p_50_22 p_50_23 5.017838e-04
Rph_50_23 p_50_23 p_51_23 5.017838e-04
Rpv_50_23 p_50_23 p_50_24 5.017838e-04
Rph_50_24 p_50_24 p_51_24 5.017838e-04
Rpv_50_24 p_50_24 p_50_25 5.017838e-04
Rph_50_25 p_50_25 p_51_25 5.017838e-04
Rpv_50_25 p_50_25 p_50_26 5.017838e-04
Rph_50_26 p_50_26 p_51_26 5.017838e-04
Rpv_50_26 p_50_26 p_50_27 5.017838e-04
Rph_50_27 p_50_27 p_51_27 5.017838e-04
Rpv_50_27 p_50_27 p_50_28 5.017838e-04
Rph_50_28 p_50_28 p_51_28 5.017838e-04
Rpv_50_28 p_50_28 p_50_29 5.017838e-04
Rph_50_29 p_50_29 p_51_29 5.017838e-04
Rpv_50_29 p_50_29 p_50_30 5.017838e-04
Rph_50_30 p_50_30 p_51_30 5.017838e-04
Rpv_50_30 p_50_30 p_50_31 5.017838e-04
Rph_50_31 p_50_31 p_51_31 5.017838e-04
Rpv_50_31 p_50_31 p_50_32 5.017838e-04
Rph_50_32 p_50_32 p_51_32 5.017838e-04
Rpv_50_32 p_50_32 p_50_33 5.017838e-04
Rph_50_33 p_50_33 p_51_33 5.017838e-04
Rpv_50_33 p_50_33 p_50_34 5.017838e-04
Rph_50_34 p_50_34 p_51_34 5.017838e-04
Rpv_50_34 p_50_34 p_50_35 5.017838e-04
Rph_50_35 p_50_35 p_51_35 5.017838e-04
Rpv_50_35 p_50_35 p_50_36 5.017838e-04
Rph_50_36 p_50_36 p_51_36 5.017838e-04
Rpv_50_36 p_50_36 p_50_37 5.017838e-04
Rph_50_37 p_50_37 p_51_37 5.017838e-04
Rpv_50_37 p_50_37 p_50_38 5.017838e-04
Rph_50_38 p_50_38 p_51_38 5.017838e-04
Rpv_50_38 p_50_38 p_50_39 5.017838e-04
Rph_50_39 p_50_39 p_51_39 5.017838e-04
Rpv_50_39 p_50_39 p_50_40 5.017838e-04
Rph_50_40 p_50_40 p_51_40 5.017838e-04
Rpv_50_40 p_50_40 p_50_41 5.017838e-04
Rph_50_41 p_50_41 p_51_41 5.017838e-04
Rpv_50_41 p_50_41 p_50_42 5.017838e-04
Rph_50_42 p_50_42 p_51_42 5.017838e-04
Rpv_50_42 p_50_42 p_50_43 5.017838e-04
Rph_50_43 p_50_43 p_51_43 5.017838e-04
Rpv_50_43 p_50_43 p_50_44 5.017838e-04
Rph_50_44 p_50_44 p_51_44 5.017838e-04
Rpv_50_44 p_50_44 p_50_45 5.017838e-04
Rph_50_45 p_50_45 p_51_45 5.017838e-04
Rpv_50_45 p_50_45 p_50_46 5.017838e-04
Rph_50_46 p_50_46 p_51_46 5.017838e-04
Rpv_50_46 p_50_46 p_50_47 5.017838e-04
Rph_50_47 p_50_47 p_51_47 5.017838e-04
Rpv_50_47 p_50_47 p_50_48 5.017838e-04
Rph_50_48 p_50_48 p_51_48 5.017838e-04
Rpv_50_48 p_50_48 p_50_49 5.017838e-04
Rph_50_49 p_50_49 p_51_49 5.017838e-04
Rpv_50_49 p_50_49 p_50_50 5.017838e-04
Rph_50_50 p_50_50 p_51_50 5.017838e-04
Rpv_50_50 p_50_50 p_50_51 5.017838e-04
Rph_50_51 p_50_51 p_51_51 5.017838e-04
Rpv_50_51 p_50_51 p_50_52 5.017838e-04
Rph_50_52 p_50_52 p_51_52 5.017838e-04
Rpv_50_52 p_50_52 p_50_53 5.017838e-04
Rph_50_53 p_50_53 p_51_53 5.017838e-04
Rpv_50_53 p_50_53 p_50_54 5.017838e-04
Rph_50_54 p_50_54 p_51_54 5.017838e-04
Rpv_50_54 p_50_54 p_50_55 5.017838e-04
Rph_50_55 p_50_55 p_51_55 5.017838e-04
Rpv_50_55 p_50_55 p_50_56 5.017838e-04
Rph_50_56 p_50_56 p_51_56 5.017838e-04
Rpv_50_56 p_50_56 p_50_57 5.017838e-04
Rph_50_57 p_50_57 p_51_57 5.017838e-04
Rpv_50_57 p_50_57 p_50_58 5.017838e-04
Rph_50_58 p_50_58 p_51_58 5.017838e-04
Rpv_50_58 p_50_58 p_50_59 5.017838e-04
Rph_50_59 p_50_59 p_51_59 5.017838e-04
Rpv_50_59 p_50_59 p_50_60 5.017838e-04
Rph_50_60 p_50_60 p_51_60 5.017838e-04
Rpv_50_60 p_50_60 p_50_61 5.017838e-04
Rph_50_61 p_50_61 p_51_61 5.017838e-04
Rpv_50_61 p_50_61 p_50_62 5.017838e-04
Rph_50_62 p_50_62 p_51_62 5.017838e-04
Rpv_50_62 p_50_62 p_50_63 5.017838e-04
Rph_50_63 p_50_63 p_51_63 5.017838e-04
Rpv_50_63 p_50_63 p_50_64 5.017838e-04
Rph_50_64 p_50_64 p_51_64 5.017838e-04
Rpv_50_64 p_50_64 p_50_65 5.017838e-04
Rph_50_65 p_50_65 p_51_65 5.017838e-04
Rpv_50_65 p_50_65 p_50_66 5.017838e-04
Rph_50_66 p_50_66 p_51_66 5.017838e-04
Rpv_50_66 p_50_66 p_50_67 5.017838e-04
Rph_50_67 p_50_67 p_51_67 5.017838e-04
Rpv_50_67 p_50_67 p_50_68 5.017838e-04
Rph_50_68 p_50_68 p_51_68 5.017838e-04
Rpv_50_68 p_50_68 p_50_69 5.017838e-04
Rph_50_69 p_50_69 p_51_69 5.017838e-04
Rpv_50_69 p_50_69 p_50_70 5.017838e-04
Rph_50_70 p_50_70 p_51_70 5.017838e-04
Rpv_50_70 p_50_70 p_50_71 5.017838e-04
Rph_50_71 p_50_71 p_51_71 5.017838e-04
Rph_51_0 p_51_0 p_52_0 5.017838e-04
Rpv_51_0 p_51_0 p_51_1 5.017838e-04
Rph_51_1 p_51_1 p_52_1 5.017838e-04
Rpv_51_1 p_51_1 p_51_2 5.017838e-04
Rph_51_2 p_51_2 p_52_2 5.017838e-04
Rpv_51_2 p_51_2 p_51_3 5.017838e-04
Rph_51_3 p_51_3 p_52_3 5.017838e-04
Rpv_51_3 p_51_3 p_51_4 5.017838e-04
Rph_51_4 p_51_4 p_52_4 5.017838e-04
Rpv_51_4 p_51_4 p_51_5 5.017838e-04
Rph_51_5 p_51_5 p_52_5 5.017838e-04
Rpv_51_5 p_51_5 p_51_6 5.017838e-04
Rph_51_6 p_51_6 p_52_6 5.017838e-04
Rpv_51_6 p_51_6 p_51_7 5.017838e-04
Rph_51_7 p_51_7 p_52_7 5.017838e-04
Rpv_51_7 p_51_7 p_51_8 5.017838e-04
Rph_51_8 p_51_8 p_52_8 5.017838e-04
Rpv_51_8 p_51_8 p_51_9 5.017838e-04
Rph_51_9 p_51_9 p_52_9 5.017838e-04
Rpv_51_9 p_51_9 p_51_10 5.017838e-04
Rph_51_10 p_51_10 p_52_10 5.017838e-04
Rpv_51_10 p_51_10 p_51_11 5.017838e-04
Rph_51_11 p_51_11 p_52_11 5.017838e-04
Rpv_51_11 p_51_11 p_51_12 5.017838e-04
Rph_51_12 p_51_12 p_52_12 5.017838e-04
Rpv_51_12 p_51_12 p_51_13 5.017838e-04
Rph_51_13 p_51_13 p_52_13 5.017838e-04
Rpv_51_13 p_51_13 p_51_14 5.017838e-04
Rph_51_14 p_51_14 p_52_14 5.017838e-04
Rpv_51_14 p_51_14 p_51_15 5.017838e-04
Rph_51_15 p_51_15 p_52_15 5.017838e-04
Rpv_51_15 p_51_15 p_51_16 5.017838e-04
Rph_51_16 p_51_16 p_52_16 5.017838e-04
Rpv_51_16 p_51_16 p_51_17 5.017838e-04
Rph_51_17 p_51_17 p_52_17 5.017838e-04
Rpv_51_17 p_51_17 p_51_18 5.017838e-04
Rph_51_18 p_51_18 p_52_18 5.017838e-04
Rpv_51_18 p_51_18 p_51_19 5.017838e-04
Rph_51_19 p_51_19 p_52_19 5.017838e-04
Rpv_51_19 p_51_19 p_51_20 5.017838e-04
Rph_51_20 p_51_20 p_52_20 5.017838e-04
Rpv_51_20 p_51_20 p_51_21 5.017838e-04
Rph_51_21 p_51_21 p_52_21 5.017838e-04
Rpv_51_21 p_51_21 p_51_22 5.017838e-04
Rph_51_22 p_51_22 p_52_22 5.017838e-04
Rpv_51_22 p_51_22 p_51_23 5.017838e-04
Rph_51_23 p_51_23 p_52_23 5.017838e-04
Rpv_51_23 p_51_23 p_51_24 5.017838e-04
Rph_51_24 p_51_24 p_52_24 5.017838e-04
Rpv_51_24 p_51_24 p_51_25 5.017838e-04
Rph_51_25 p_51_25 p_52_25 5.017838e-04
Rpv_51_25 p_51_25 p_51_26 5.017838e-04
Rph_51_26 p_51_26 p_52_26 5.017838e-04
Rpv_51_26 p_51_26 p_51_27 5.017838e-04
Rph_51_27 p_51_27 p_52_27 5.017838e-04
Rpv_51_27 p_51_27 p_51_28 5.017838e-04
Rph_51_28 p_51_28 p_52_28 5.017838e-04
Rpv_51_28 p_51_28 p_51_29 5.017838e-04
Rph_51_29 p_51_29 p_52_29 5.017838e-04
Rpv_51_29 p_51_29 p_51_30 5.017838e-04
Rph_51_30 p_51_30 p_52_30 5.017838e-04
Rpv_51_30 p_51_30 p_51_31 5.017838e-04
Rph_51_31 p_51_31 p_52_31 5.017838e-04
Rpv_51_31 p_51_31 p_51_32 5.017838e-04
Rph_51_32 p_51_32 p_52_32 5.017838e-04
Rpv_51_32 p_51_32 p_51_33 5.017838e-04
Rph_51_33 p_51_33 p_52_33 5.017838e-04
Rpv_51_33 p_51_33 p_51_34 5.017838e-04
Rph_51_34 p_51_34 p_52_34 5.017838e-04
Rpv_51_34 p_51_34 p_51_35 5.017838e-04
Rph_51_35 p_51_35 p_52_35 5.017838e-04
Rpv_51_35 p_51_35 p_51_36 5.017838e-04
Rph_51_36 p_51_36 p_52_36 5.017838e-04
Rpv_51_36 p_51_36 p_51_37 5.017838e-04
Rph_51_37 p_51_37 p_52_37 5.017838e-04
Rpv_51_37 p_51_37 p_51_38 5.017838e-04
Rph_51_38 p_51_38 p_52_38 5.017838e-04
Rpv_51_38 p_51_38 p_51_39 5.017838e-04
Rph_51_39 p_51_39 p_52_39 5.017838e-04
Rpv_51_39 p_51_39 p_51_40 5.017838e-04
Rph_51_40 p_51_40 p_52_40 5.017838e-04
Rpv_51_40 p_51_40 p_51_41 5.017838e-04
Rph_51_41 p_51_41 p_52_41 5.017838e-04
Rpv_51_41 p_51_41 p_51_42 5.017838e-04
Rph_51_42 p_51_42 p_52_42 5.017838e-04
Rpv_51_42 p_51_42 p_51_43 5.017838e-04
Rph_51_43 p_51_43 p_52_43 5.017838e-04
Rpv_51_43 p_51_43 p_51_44 5.017838e-04
Rph_51_44 p_51_44 p_52_44 5.017838e-04
Rpv_51_44 p_51_44 p_51_45 5.017838e-04
Rph_51_45 p_51_45 p_52_45 5.017838e-04
Rpv_51_45 p_51_45 p_51_46 5.017838e-04
Rph_51_46 p_51_46 p_52_46 5.017838e-04
Rpv_51_46 p_51_46 p_51_47 5.017838e-04
Rph_51_47 p_51_47 p_52_47 5.017838e-04
Rpv_51_47 p_51_47 p_51_48 5.017838e-04
Rph_51_48 p_51_48 p_52_48 5.017838e-04
Rpv_51_48 p_51_48 p_51_49 5.017838e-04
Rph_51_49 p_51_49 p_52_49 5.017838e-04
Rpv_51_49 p_51_49 p_51_50 5.017838e-04
Rph_51_50 p_51_50 p_52_50 5.017838e-04
Rpv_51_50 p_51_50 p_51_51 5.017838e-04
Rph_51_51 p_51_51 p_52_51 5.017838e-04
Rpv_51_51 p_51_51 p_51_52 5.017838e-04
Rph_51_52 p_51_52 p_52_52 5.017838e-04
Rpv_51_52 p_51_52 p_51_53 5.017838e-04
Rph_51_53 p_51_53 p_52_53 5.017838e-04
Rpv_51_53 p_51_53 p_51_54 5.017838e-04
Rph_51_54 p_51_54 p_52_54 5.017838e-04
Rpv_51_54 p_51_54 p_51_55 5.017838e-04
Rph_51_55 p_51_55 p_52_55 5.017838e-04
Rpv_51_55 p_51_55 p_51_56 5.017838e-04
Rph_51_56 p_51_56 p_52_56 5.017838e-04
Rpv_51_56 p_51_56 p_51_57 5.017838e-04
Rph_51_57 p_51_57 p_52_57 5.017838e-04
Rpv_51_57 p_51_57 p_51_58 5.017838e-04
Rph_51_58 p_51_58 p_52_58 5.017838e-04
Rpv_51_58 p_51_58 p_51_59 5.017838e-04
Rph_51_59 p_51_59 p_52_59 5.017838e-04
Rpv_51_59 p_51_59 p_51_60 5.017838e-04
Rph_51_60 p_51_60 p_52_60 5.017838e-04
Rpv_51_60 p_51_60 p_51_61 5.017838e-04
Rph_51_61 p_51_61 p_52_61 5.017838e-04
Rpv_51_61 p_51_61 p_51_62 5.017838e-04
Rph_51_62 p_51_62 p_52_62 5.017838e-04
Rpv_51_62 p_51_62 p_51_63 5.017838e-04
Rph_51_63 p_51_63 p_52_63 5.017838e-04
Rpv_51_63 p_51_63 p_51_64 5.017838e-04
Rph_51_64 p_51_64 p_52_64 5.017838e-04
Rpv_51_64 p_51_64 p_51_65 5.017838e-04
Rph_51_65 p_51_65 p_52_65 5.017838e-04
Rpv_51_65 p_51_65 p_51_66 5.017838e-04
Rph_51_66 p_51_66 p_52_66 5.017838e-04
Rpv_51_66 p_51_66 p_51_67 5.017838e-04
Rph_51_67 p_51_67 p_52_67 5.017838e-04
Rpv_51_67 p_51_67 p_51_68 5.017838e-04
Rph_51_68 p_51_68 p_52_68 5.017838e-04
Rpv_51_68 p_51_68 p_51_69 5.017838e-04
Rph_51_69 p_51_69 p_52_69 5.017838e-04
Rpv_51_69 p_51_69 p_51_70 5.017838e-04
Rph_51_70 p_51_70 p_52_70 5.017838e-04
Rpv_51_70 p_51_70 p_51_71 5.017838e-04
Rph_51_71 p_51_71 p_52_71 5.017838e-04
Rph_52_0 p_52_0 p_53_0 5.017838e-04
Rpv_52_0 p_52_0 p_52_1 5.017838e-04
Rph_52_1 p_52_1 p_53_1 5.017838e-04
Rpv_52_1 p_52_1 p_52_2 5.017838e-04
Rph_52_2 p_52_2 p_53_2 5.017838e-04
Rpv_52_2 p_52_2 p_52_3 5.017838e-04
Rph_52_3 p_52_3 p_53_3 5.017838e-04
Rpv_52_3 p_52_3 p_52_4 5.017838e-04
Rph_52_4 p_52_4 p_53_4 5.017838e-04
Rpv_52_4 p_52_4 p_52_5 5.017838e-04
Rph_52_5 p_52_5 p_53_5 5.017838e-04
Rpv_52_5 p_52_5 p_52_6 5.017838e-04
Rph_52_6 p_52_6 p_53_6 5.017838e-04
Rpv_52_6 p_52_6 p_52_7 5.017838e-04
Rph_52_7 p_52_7 p_53_7 5.017838e-04
Rpv_52_7 p_52_7 p_52_8 5.017838e-04
Rph_52_8 p_52_8 p_53_8 5.017838e-04
Rpv_52_8 p_52_8 p_52_9 5.017838e-04
Rph_52_9 p_52_9 p_53_9 5.017838e-04
Rpv_52_9 p_52_9 p_52_10 5.017838e-04
Rph_52_10 p_52_10 p_53_10 5.017838e-04
Rpv_52_10 p_52_10 p_52_11 5.017838e-04
Rph_52_11 p_52_11 p_53_11 5.017838e-04
Rpv_52_11 p_52_11 p_52_12 5.017838e-04
Rph_52_12 p_52_12 p_53_12 5.017838e-04
Rpv_52_12 p_52_12 p_52_13 5.017838e-04
Rph_52_13 p_52_13 p_53_13 5.017838e-04
Rpv_52_13 p_52_13 p_52_14 5.017838e-04
Rph_52_14 p_52_14 p_53_14 5.017838e-04
Rpv_52_14 p_52_14 p_52_15 5.017838e-04
Rph_52_15 p_52_15 p_53_15 5.017838e-04
Rpv_52_15 p_52_15 p_52_16 5.017838e-04
Rph_52_16 p_52_16 p_53_16 5.017838e-04
Rpv_52_16 p_52_16 p_52_17 5.017838e-04
Rph_52_17 p_52_17 p_53_17 5.017838e-04
Rpv_52_17 p_52_17 p_52_18 5.017838e-04
Rph_52_18 p_52_18 p_53_18 5.017838e-04
Rpv_52_18 p_52_18 p_52_19 5.017838e-04
Rph_52_19 p_52_19 p_53_19 5.017838e-04
Rpv_52_19 p_52_19 p_52_20 5.017838e-04
Rph_52_20 p_52_20 p_53_20 5.017838e-04
Rpv_52_20 p_52_20 p_52_21 5.017838e-04
Rph_52_21 p_52_21 p_53_21 5.017838e-04
Rpv_52_21 p_52_21 p_52_22 5.017838e-04
Rph_52_22 p_52_22 p_53_22 5.017838e-04
Rpv_52_22 p_52_22 p_52_23 5.017838e-04
Rph_52_23 p_52_23 p_53_23 5.017838e-04
Rpv_52_23 p_52_23 p_52_24 5.017838e-04
Rph_52_24 p_52_24 p_53_24 5.017838e-04
Rpv_52_24 p_52_24 p_52_25 5.017838e-04
Rph_52_25 p_52_25 p_53_25 5.017838e-04
Rpv_52_25 p_52_25 p_52_26 5.017838e-04
Rph_52_26 p_52_26 p_53_26 5.017838e-04
Rpv_52_26 p_52_26 p_52_27 5.017838e-04
Rph_52_27 p_52_27 p_53_27 5.017838e-04
Rpv_52_27 p_52_27 p_52_28 5.017838e-04
Rph_52_28 p_52_28 p_53_28 5.017838e-04
Rpv_52_28 p_52_28 p_52_29 5.017838e-04
Rph_52_29 p_52_29 p_53_29 5.017838e-04
Rpv_52_29 p_52_29 p_52_30 5.017838e-04
Rph_52_30 p_52_30 p_53_30 5.017838e-04
Rpv_52_30 p_52_30 p_52_31 5.017838e-04
Rph_52_31 p_52_31 p_53_31 5.017838e-04
Rpv_52_31 p_52_31 p_52_32 5.017838e-04
Rph_52_32 p_52_32 p_53_32 5.017838e-04
Rpv_52_32 p_52_32 p_52_33 5.017838e-04
Rph_52_33 p_52_33 p_53_33 5.017838e-04
Rpv_52_33 p_52_33 p_52_34 5.017838e-04
Rph_52_34 p_52_34 p_53_34 5.017838e-04
Rpv_52_34 p_52_34 p_52_35 5.017838e-04
Rph_52_35 p_52_35 p_53_35 5.017838e-04
Rpv_52_35 p_52_35 p_52_36 5.017838e-04
Rph_52_36 p_52_36 p_53_36 5.017838e-04
Rpv_52_36 p_52_36 p_52_37 5.017838e-04
Rph_52_37 p_52_37 p_53_37 5.017838e-04
Rpv_52_37 p_52_37 p_52_38 5.017838e-04
Rph_52_38 p_52_38 p_53_38 5.017838e-04
Rpv_52_38 p_52_38 p_52_39 5.017838e-04
Rph_52_39 p_52_39 p_53_39 5.017838e-04
Rpv_52_39 p_52_39 p_52_40 5.017838e-04
Rph_52_40 p_52_40 p_53_40 5.017838e-04
Rpv_52_40 p_52_40 p_52_41 5.017838e-04
Rph_52_41 p_52_41 p_53_41 5.017838e-04
Rpv_52_41 p_52_41 p_52_42 5.017838e-04
Rph_52_42 p_52_42 p_53_42 5.017838e-04
Rpv_52_42 p_52_42 p_52_43 5.017838e-04
Rph_52_43 p_52_43 p_53_43 5.017838e-04
Rpv_52_43 p_52_43 p_52_44 5.017838e-04
Rph_52_44 p_52_44 p_53_44 5.017838e-04
Rpv_52_44 p_52_44 p_52_45 5.017838e-04
Rph_52_45 p_52_45 p_53_45 5.017838e-04
Rpv_52_45 p_52_45 p_52_46 5.017838e-04
Rph_52_46 p_52_46 p_53_46 5.017838e-04
Rpv_52_46 p_52_46 p_52_47 5.017838e-04
Rph_52_47 p_52_47 p_53_47 5.017838e-04
Rpv_52_47 p_52_47 p_52_48 5.017838e-04
Rph_52_48 p_52_48 p_53_48 5.017838e-04
Rpv_52_48 p_52_48 p_52_49 5.017838e-04
Rph_52_49 p_52_49 p_53_49 5.017838e-04
Rpv_52_49 p_52_49 p_52_50 5.017838e-04
Rph_52_50 p_52_50 p_53_50 5.017838e-04
Rpv_52_50 p_52_50 p_52_51 5.017838e-04
Rph_52_51 p_52_51 p_53_51 5.017838e-04
Rpv_52_51 p_52_51 p_52_52 5.017838e-04
Rph_52_52 p_52_52 p_53_52 5.017838e-04
Rpv_52_52 p_52_52 p_52_53 5.017838e-04
Rph_52_53 p_52_53 p_53_53 5.017838e-04
Rpv_52_53 p_52_53 p_52_54 5.017838e-04
Rph_52_54 p_52_54 p_53_54 5.017838e-04
Rpv_52_54 p_52_54 p_52_55 5.017838e-04
Rph_52_55 p_52_55 p_53_55 5.017838e-04
Rpv_52_55 p_52_55 p_52_56 5.017838e-04
Rph_52_56 p_52_56 p_53_56 5.017838e-04
Rpv_52_56 p_52_56 p_52_57 5.017838e-04
Rph_52_57 p_52_57 p_53_57 5.017838e-04
Rpv_52_57 p_52_57 p_52_58 5.017838e-04
Rph_52_58 p_52_58 p_53_58 5.017838e-04
Rpv_52_58 p_52_58 p_52_59 5.017838e-04
Rph_52_59 p_52_59 p_53_59 5.017838e-04
Rpv_52_59 p_52_59 p_52_60 5.017838e-04
Rph_52_60 p_52_60 p_53_60 5.017838e-04
Rpv_52_60 p_52_60 p_52_61 5.017838e-04
Rph_52_61 p_52_61 p_53_61 5.017838e-04
Rpv_52_61 p_52_61 p_52_62 5.017838e-04
Rph_52_62 p_52_62 p_53_62 5.017838e-04
Rpv_52_62 p_52_62 p_52_63 5.017838e-04
Rph_52_63 p_52_63 p_53_63 5.017838e-04
Rpv_52_63 p_52_63 p_52_64 5.017838e-04
Rph_52_64 p_52_64 p_53_64 5.017838e-04
Rpv_52_64 p_52_64 p_52_65 5.017838e-04
Rph_52_65 p_52_65 p_53_65 5.017838e-04
Rpv_52_65 p_52_65 p_52_66 5.017838e-04
Rph_52_66 p_52_66 p_53_66 5.017838e-04
Rpv_52_66 p_52_66 p_52_67 5.017838e-04
Rph_52_67 p_52_67 p_53_67 5.017838e-04
Rpv_52_67 p_52_67 p_52_68 5.017838e-04
Rph_52_68 p_52_68 p_53_68 5.017838e-04
Rpv_52_68 p_52_68 p_52_69 5.017838e-04
Rph_52_69 p_52_69 p_53_69 5.017838e-04
Rpv_52_69 p_52_69 p_52_70 5.017838e-04
Rph_52_70 p_52_70 p_53_70 5.017838e-04
Rpv_52_70 p_52_70 p_52_71 5.017838e-04
Rph_52_71 p_52_71 p_53_71 5.017838e-04
Rph_53_0 p_53_0 p_54_0 5.017838e-04
Rpv_53_0 p_53_0 p_53_1 5.017838e-04
Rph_53_1 p_53_1 p_54_1 5.017838e-04
Rpv_53_1 p_53_1 p_53_2 5.017838e-04
Rph_53_2 p_53_2 p_54_2 5.017838e-04
Rpv_53_2 p_53_2 p_53_3 5.017838e-04
Rph_53_3 p_53_3 p_54_3 5.017838e-04
Rpv_53_3 p_53_3 p_53_4 5.017838e-04
Rph_53_4 p_53_4 p_54_4 5.017838e-04
Rpv_53_4 p_53_4 p_53_5 5.017838e-04
Rph_53_5 p_53_5 p_54_5 5.017838e-04
Rpv_53_5 p_53_5 p_53_6 5.017838e-04
Rph_53_6 p_53_6 p_54_6 5.017838e-04
Rpv_53_6 p_53_6 p_53_7 5.017838e-04
Rph_53_7 p_53_7 p_54_7 5.017838e-04
Rpv_53_7 p_53_7 p_53_8 5.017838e-04
Rph_53_8 p_53_8 p_54_8 5.017838e-04
Rpv_53_8 p_53_8 p_53_9 5.017838e-04
Rph_53_9 p_53_9 p_54_9 5.017838e-04
Rpv_53_9 p_53_9 p_53_10 5.017838e-04
Rph_53_10 p_53_10 p_54_10 5.017838e-04
Rpv_53_10 p_53_10 p_53_11 5.017838e-04
Rph_53_11 p_53_11 p_54_11 5.017838e-04
Rpv_53_11 p_53_11 p_53_12 5.017838e-04
Rph_53_12 p_53_12 p_54_12 5.017838e-04
Rpv_53_12 p_53_12 p_53_13 5.017838e-04
Rph_53_13 p_53_13 p_54_13 5.017838e-04
Rpv_53_13 p_53_13 p_53_14 5.017838e-04
Rph_53_14 p_53_14 p_54_14 5.017838e-04
Rpv_53_14 p_53_14 p_53_15 5.017838e-04
Rph_53_15 p_53_15 p_54_15 5.017838e-04
Rpv_53_15 p_53_15 p_53_16 5.017838e-04
Rph_53_16 p_53_16 p_54_16 5.017838e-04
Rpv_53_16 p_53_16 p_53_17 5.017838e-04
Rph_53_17 p_53_17 p_54_17 5.017838e-04
Rpv_53_17 p_53_17 p_53_18 5.017838e-04
Rph_53_18 p_53_18 p_54_18 5.017838e-04
Rpv_53_18 p_53_18 p_53_19 5.017838e-04
Rph_53_19 p_53_19 p_54_19 5.017838e-04
Rpv_53_19 p_53_19 p_53_20 5.017838e-04
Rph_53_20 p_53_20 p_54_20 5.017838e-04
Rpv_53_20 p_53_20 p_53_21 5.017838e-04
Rph_53_21 p_53_21 p_54_21 5.017838e-04
Rpv_53_21 p_53_21 p_53_22 5.017838e-04
Rph_53_22 p_53_22 p_54_22 5.017838e-04
Rpv_53_22 p_53_22 p_53_23 5.017838e-04
Rph_53_23 p_53_23 p_54_23 5.017838e-04
Rpv_53_23 p_53_23 p_53_24 5.017838e-04
Rph_53_24 p_53_24 p_54_24 5.017838e-04
Rpv_53_24 p_53_24 p_53_25 5.017838e-04
Rph_53_25 p_53_25 p_54_25 5.017838e-04
Rpv_53_25 p_53_25 p_53_26 5.017838e-04
Rph_53_26 p_53_26 p_54_26 5.017838e-04
Rpv_53_26 p_53_26 p_53_27 5.017838e-04
Rph_53_27 p_53_27 p_54_27 5.017838e-04
Rpv_53_27 p_53_27 p_53_28 5.017838e-04
Rph_53_28 p_53_28 p_54_28 5.017838e-04
Rpv_53_28 p_53_28 p_53_29 5.017838e-04
Rph_53_29 p_53_29 p_54_29 5.017838e-04
Rpv_53_29 p_53_29 p_53_30 5.017838e-04
Rph_53_30 p_53_30 p_54_30 5.017838e-04
Rpv_53_30 p_53_30 p_53_31 5.017838e-04
Rph_53_31 p_53_31 p_54_31 5.017838e-04
Rpv_53_31 p_53_31 p_53_32 5.017838e-04
Rph_53_32 p_53_32 p_54_32 5.017838e-04
Rpv_53_32 p_53_32 p_53_33 5.017838e-04
Rph_53_33 p_53_33 p_54_33 5.017838e-04
Rpv_53_33 p_53_33 p_53_34 5.017838e-04
Rph_53_34 p_53_34 p_54_34 5.017838e-04
Rpv_53_34 p_53_34 p_53_35 5.017838e-04
Rph_53_35 p_53_35 p_54_35 5.017838e-04
Rpv_53_35 p_53_35 p_53_36 5.017838e-04
Rph_53_36 p_53_36 p_54_36 5.017838e-04
Rpv_53_36 p_53_36 p_53_37 5.017838e-04
Rph_53_37 p_53_37 p_54_37 5.017838e-04
Rpv_53_37 p_53_37 p_53_38 5.017838e-04
Rph_53_38 p_53_38 p_54_38 5.017838e-04
Rpv_53_38 p_53_38 p_53_39 5.017838e-04
Rph_53_39 p_53_39 p_54_39 5.017838e-04
Rpv_53_39 p_53_39 p_53_40 5.017838e-04
Rph_53_40 p_53_40 p_54_40 5.017838e-04
Rpv_53_40 p_53_40 p_53_41 5.017838e-04
Rph_53_41 p_53_41 p_54_41 5.017838e-04
Rpv_53_41 p_53_41 p_53_42 5.017838e-04
Rph_53_42 p_53_42 p_54_42 5.017838e-04
Rpv_53_42 p_53_42 p_53_43 5.017838e-04
Rph_53_43 p_53_43 p_54_43 5.017838e-04
Rpv_53_43 p_53_43 p_53_44 5.017838e-04
Rph_53_44 p_53_44 p_54_44 5.017838e-04
Rpv_53_44 p_53_44 p_53_45 5.017838e-04
Rph_53_45 p_53_45 p_54_45 5.017838e-04
Rpv_53_45 p_53_45 p_53_46 5.017838e-04
Rph_53_46 p_53_46 p_54_46 5.017838e-04
Rpv_53_46 p_53_46 p_53_47 5.017838e-04
Rph_53_47 p_53_47 p_54_47 5.017838e-04
Rpv_53_47 p_53_47 p_53_48 5.017838e-04
Rph_53_48 p_53_48 p_54_48 5.017838e-04
Rpv_53_48 p_53_48 p_53_49 5.017838e-04
Rph_53_49 p_53_49 p_54_49 5.017838e-04
Rpv_53_49 p_53_49 p_53_50 5.017838e-04
Rph_53_50 p_53_50 p_54_50 5.017838e-04
Rpv_53_50 p_53_50 p_53_51 5.017838e-04
Rph_53_51 p_53_51 p_54_51 5.017838e-04
Rpv_53_51 p_53_51 p_53_52 5.017838e-04
Rph_53_52 p_53_52 p_54_52 5.017838e-04
Rpv_53_52 p_53_52 p_53_53 5.017838e-04
Rph_53_53 p_53_53 p_54_53 5.017838e-04
Rpv_53_53 p_53_53 p_53_54 5.017838e-04
Rph_53_54 p_53_54 p_54_54 5.017838e-04
Rpv_53_54 p_53_54 p_53_55 5.017838e-04
Rph_53_55 p_53_55 p_54_55 5.017838e-04
Rpv_53_55 p_53_55 p_53_56 5.017838e-04
Rph_53_56 p_53_56 p_54_56 5.017838e-04
Rpv_53_56 p_53_56 p_53_57 5.017838e-04
Rph_53_57 p_53_57 p_54_57 5.017838e-04
Rpv_53_57 p_53_57 p_53_58 5.017838e-04
Rph_53_58 p_53_58 p_54_58 5.017838e-04
Rpv_53_58 p_53_58 p_53_59 5.017838e-04
Rph_53_59 p_53_59 p_54_59 5.017838e-04
Rpv_53_59 p_53_59 p_53_60 5.017838e-04
Rph_53_60 p_53_60 p_54_60 5.017838e-04
Rpv_53_60 p_53_60 p_53_61 5.017838e-04
Rph_53_61 p_53_61 p_54_61 5.017838e-04
Rpv_53_61 p_53_61 p_53_62 5.017838e-04
Rph_53_62 p_53_62 p_54_62 5.017838e-04
Rpv_53_62 p_53_62 p_53_63 5.017838e-04
Rph_53_63 p_53_63 p_54_63 5.017838e-04
Rpv_53_63 p_53_63 p_53_64 5.017838e-04
Rph_53_64 p_53_64 p_54_64 5.017838e-04
Rpv_53_64 p_53_64 p_53_65 5.017838e-04
Rph_53_65 p_53_65 p_54_65 5.017838e-04
Rpv_53_65 p_53_65 p_53_66 5.017838e-04
Rph_53_66 p_53_66 p_54_66 5.017838e-04
Rpv_53_66 p_53_66 p_53_67 5.017838e-04
Rph_53_67 p_53_67 p_54_67 5.017838e-04
Rpv_53_67 p_53_67 p_53_68 5.017838e-04
Rph_53_68 p_53_68 p_54_68 5.017838e-04
Rpv_53_68 p_53_68 p_53_69 5.017838e-04
Rph_53_69 p_53_69 p_54_69 5.017838e-04
Rpv_53_69 p_53_69 p_53_70 5.017838e-04
Rph_53_70 p_53_70 p_54_70 5.017838e-04
Rpv_53_70 p_53_70 p_53_71 5.017838e-04
Rph_53_71 p_53_71 p_54_71 5.017838e-04
Rph_54_0 p_54_0 p_55_0 5.017838e-04
Rpv_54_0 p_54_0 p_54_1 5.017838e-04
Rph_54_1 p_54_1 p_55_1 5.017838e-04
Rpv_54_1 p_54_1 p_54_2 5.017838e-04
Rph_54_2 p_54_2 p_55_2 5.017838e-04
Rpv_54_2 p_54_2 p_54_3 5.017838e-04
Rph_54_3 p_54_3 p_55_3 5.017838e-04
Rpv_54_3 p_54_3 p_54_4 5.017838e-04
Rph_54_4 p_54_4 p_55_4 5.017838e-04
Rpv_54_4 p_54_4 p_54_5 5.017838e-04
Rph_54_5 p_54_5 p_55_5 5.017838e-04
Rpv_54_5 p_54_5 p_54_6 5.017838e-04
Rph_54_6 p_54_6 p_55_6 5.017838e-04
Rpv_54_6 p_54_6 p_54_7 5.017838e-04
Rph_54_7 p_54_7 p_55_7 5.017838e-04
Rpv_54_7 p_54_7 p_54_8 5.017838e-04
Rph_54_8 p_54_8 p_55_8 5.017838e-04
Rpv_54_8 p_54_8 p_54_9 5.017838e-04
Rph_54_9 p_54_9 p_55_9 5.017838e-04
Rpv_54_9 p_54_9 p_54_10 5.017838e-04
Rph_54_10 p_54_10 p_55_10 5.017838e-04
Rpv_54_10 p_54_10 p_54_11 5.017838e-04
Rph_54_11 p_54_11 p_55_11 5.017838e-04
Rpv_54_11 p_54_11 p_54_12 5.017838e-04
Rph_54_12 p_54_12 p_55_12 5.017838e-04
Rpv_54_12 p_54_12 p_54_13 5.017838e-04
Rph_54_13 p_54_13 p_55_13 5.017838e-04
Rpv_54_13 p_54_13 p_54_14 5.017838e-04
Rph_54_14 p_54_14 p_55_14 5.017838e-04
Rpv_54_14 p_54_14 p_54_15 5.017838e-04
Rph_54_15 p_54_15 p_55_15 5.017838e-04
Rpv_54_15 p_54_15 p_54_16 5.017838e-04
Rph_54_16 p_54_16 p_55_16 5.017838e-04
Rpv_54_16 p_54_16 p_54_17 5.017838e-04
Rph_54_17 p_54_17 p_55_17 5.017838e-04
Rpv_54_17 p_54_17 p_54_18 5.017838e-04
Rph_54_18 p_54_18 p_55_18 5.017838e-04
Rpv_54_18 p_54_18 p_54_19 5.017838e-04
Rph_54_19 p_54_19 p_55_19 5.017838e-04
Rpv_54_19 p_54_19 p_54_20 5.017838e-04
Rph_54_20 p_54_20 p_55_20 5.017838e-04
Rpv_54_20 p_54_20 p_54_21 5.017838e-04
Rph_54_21 p_54_21 p_55_21 5.017838e-04
Rpv_54_21 p_54_21 p_54_22 5.017838e-04
Rph_54_22 p_54_22 p_55_22 5.017838e-04
Rpv_54_22 p_54_22 p_54_23 5.017838e-04
Rph_54_23 p_54_23 p_55_23 5.017838e-04
Rpv_54_23 p_54_23 p_54_24 5.017838e-04
Rph_54_24 p_54_24 p_55_24 5.017838e-04
Rpv_54_24 p_54_24 p_54_25 5.017838e-04
Rph_54_25 p_54_25 p_55_25 5.017838e-04
Rpv_54_25 p_54_25 p_54_26 5.017838e-04
Rph_54_26 p_54_26 p_55_26 5.017838e-04
Rpv_54_26 p_54_26 p_54_27 5.017838e-04
Rph_54_27 p_54_27 p_55_27 5.017838e-04
Rpv_54_27 p_54_27 p_54_28 5.017838e-04
Rph_54_28 p_54_28 p_55_28 5.017838e-04
Rpv_54_28 p_54_28 p_54_29 5.017838e-04
Rph_54_29 p_54_29 p_55_29 5.017838e-04
Rpv_54_29 p_54_29 p_54_30 5.017838e-04
Rph_54_30 p_54_30 p_55_30 5.017838e-04
Rpv_54_30 p_54_30 p_54_31 5.017838e-04
Rph_54_31 p_54_31 p_55_31 5.017838e-04
Rpv_54_31 p_54_31 p_54_32 5.017838e-04
Rph_54_32 p_54_32 p_55_32 5.017838e-04
Rpv_54_32 p_54_32 p_54_33 5.017838e-04
Rph_54_33 p_54_33 p_55_33 5.017838e-04
Rpv_54_33 p_54_33 p_54_34 5.017838e-04
Rph_54_34 p_54_34 p_55_34 5.017838e-04
Rpv_54_34 p_54_34 p_54_35 5.017838e-04
Rph_54_35 p_54_35 p_55_35 5.017838e-04
Rpv_54_35 p_54_35 p_54_36 5.017838e-04
Rph_54_36 p_54_36 p_55_36 5.017838e-04
Rpv_54_36 p_54_36 p_54_37 5.017838e-04
Rph_54_37 p_54_37 p_55_37 5.017838e-04
Rpv_54_37 p_54_37 p_54_38 5.017838e-04
Rph_54_38 p_54_38 p_55_38 5.017838e-04
Rpv_54_38 p_54_38 p_54_39 5.017838e-04
Rph_54_39 p_54_39 p_55_39 5.017838e-04
Rpv_54_39 p_54_39 p_54_40 5.017838e-04
Rph_54_40 p_54_40 p_55_40 5.017838e-04
Rpv_54_40 p_54_40 p_54_41 5.017838e-04
Rph_54_41 p_54_41 p_55_41 5.017838e-04
Rpv_54_41 p_54_41 p_54_42 5.017838e-04
Rph_54_42 p_54_42 p_55_42 5.017838e-04
Rpv_54_42 p_54_42 p_54_43 5.017838e-04
Rph_54_43 p_54_43 p_55_43 5.017838e-04
Rpv_54_43 p_54_43 p_54_44 5.017838e-04
Rph_54_44 p_54_44 p_55_44 5.017838e-04
Rpv_54_44 p_54_44 p_54_45 5.017838e-04
Rph_54_45 p_54_45 p_55_45 5.017838e-04
Rpv_54_45 p_54_45 p_54_46 5.017838e-04
Rph_54_46 p_54_46 p_55_46 5.017838e-04
Rpv_54_46 p_54_46 p_54_47 5.017838e-04
Rph_54_47 p_54_47 p_55_47 5.017838e-04
Rpv_54_47 p_54_47 p_54_48 5.017838e-04
Rph_54_48 p_54_48 p_55_48 5.017838e-04
Rpv_54_48 p_54_48 p_54_49 5.017838e-04
Rph_54_49 p_54_49 p_55_49 5.017838e-04
Rpv_54_49 p_54_49 p_54_50 5.017838e-04
Rph_54_50 p_54_50 p_55_50 5.017838e-04
Rpv_54_50 p_54_50 p_54_51 5.017838e-04
Rph_54_51 p_54_51 p_55_51 5.017838e-04
Rpv_54_51 p_54_51 p_54_52 5.017838e-04
Rph_54_52 p_54_52 p_55_52 5.017838e-04
Rpv_54_52 p_54_52 p_54_53 5.017838e-04
Rph_54_53 p_54_53 p_55_53 5.017838e-04
Rpv_54_53 p_54_53 p_54_54 5.017838e-04
Rph_54_54 p_54_54 p_55_54 5.017838e-04
Rpv_54_54 p_54_54 p_54_55 5.017838e-04
Rph_54_55 p_54_55 p_55_55 5.017838e-04
Rpv_54_55 p_54_55 p_54_56 5.017838e-04
Rph_54_56 p_54_56 p_55_56 5.017838e-04
Rpv_54_56 p_54_56 p_54_57 5.017838e-04
Rph_54_57 p_54_57 p_55_57 5.017838e-04
Rpv_54_57 p_54_57 p_54_58 5.017838e-04
Rph_54_58 p_54_58 p_55_58 5.017838e-04
Rpv_54_58 p_54_58 p_54_59 5.017838e-04
Rph_54_59 p_54_59 p_55_59 5.017838e-04
Rpv_54_59 p_54_59 p_54_60 5.017838e-04
Rph_54_60 p_54_60 p_55_60 5.017838e-04
Rpv_54_60 p_54_60 p_54_61 5.017838e-04
Rph_54_61 p_54_61 p_55_61 5.017838e-04
Rpv_54_61 p_54_61 p_54_62 5.017838e-04
Rph_54_62 p_54_62 p_55_62 5.017838e-04
Rpv_54_62 p_54_62 p_54_63 5.017838e-04
Rph_54_63 p_54_63 p_55_63 5.017838e-04
Rpv_54_63 p_54_63 p_54_64 5.017838e-04
Rph_54_64 p_54_64 p_55_64 5.017838e-04
Rpv_54_64 p_54_64 p_54_65 5.017838e-04
Rph_54_65 p_54_65 p_55_65 5.017838e-04
Rpv_54_65 p_54_65 p_54_66 5.017838e-04
Rph_54_66 p_54_66 p_55_66 5.017838e-04
Rpv_54_66 p_54_66 p_54_67 5.017838e-04
Rph_54_67 p_54_67 p_55_67 5.017838e-04
Rpv_54_67 p_54_67 p_54_68 5.017838e-04
Rph_54_68 p_54_68 p_55_68 5.017838e-04
Rpv_54_68 p_54_68 p_54_69 5.017838e-04
Rph_54_69 p_54_69 p_55_69 5.017838e-04
Rpv_54_69 p_54_69 p_54_70 5.017838e-04
Rph_54_70 p_54_70 p_55_70 5.017838e-04
Rpv_54_70 p_54_70 p_54_71 5.017838e-04
Rph_54_71 p_54_71 p_55_71 5.017838e-04
Rph_55_0 p_55_0 p_56_0 5.017838e-04
Rpv_55_0 p_55_0 p_55_1 5.017838e-04
Rph_55_1 p_55_1 p_56_1 5.017838e-04
Rpv_55_1 p_55_1 p_55_2 5.017838e-04
Rph_55_2 p_55_2 p_56_2 5.017838e-04
Rpv_55_2 p_55_2 p_55_3 5.017838e-04
Rph_55_3 p_55_3 p_56_3 5.017838e-04
Rpv_55_3 p_55_3 p_55_4 5.017838e-04
Rph_55_4 p_55_4 p_56_4 5.017838e-04
Rpv_55_4 p_55_4 p_55_5 5.017838e-04
Rph_55_5 p_55_5 p_56_5 5.017838e-04
Rpv_55_5 p_55_5 p_55_6 5.017838e-04
Rph_55_6 p_55_6 p_56_6 5.017838e-04
Rpv_55_6 p_55_6 p_55_7 5.017838e-04
Rph_55_7 p_55_7 p_56_7 5.017838e-04
Rpv_55_7 p_55_7 p_55_8 5.017838e-04
Rph_55_8 p_55_8 p_56_8 5.017838e-04
Rpv_55_8 p_55_8 p_55_9 5.017838e-04
Rph_55_9 p_55_9 p_56_9 5.017838e-04
Rpv_55_9 p_55_9 p_55_10 5.017838e-04
Rph_55_10 p_55_10 p_56_10 5.017838e-04
Rpv_55_10 p_55_10 p_55_11 5.017838e-04
Rph_55_11 p_55_11 p_56_11 5.017838e-04
Rpv_55_11 p_55_11 p_55_12 5.017838e-04
Rph_55_12 p_55_12 p_56_12 5.017838e-04
Rpv_55_12 p_55_12 p_55_13 5.017838e-04
Rph_55_13 p_55_13 p_56_13 5.017838e-04
Rpv_55_13 p_55_13 p_55_14 5.017838e-04
Rph_55_14 p_55_14 p_56_14 5.017838e-04
Rpv_55_14 p_55_14 p_55_15 5.017838e-04
Rph_55_15 p_55_15 p_56_15 5.017838e-04
Rpv_55_15 p_55_15 p_55_16 5.017838e-04
Rph_55_16 p_55_16 p_56_16 5.017838e-04
Rpv_55_16 p_55_16 p_55_17 5.017838e-04
Rph_55_17 p_55_17 p_56_17 5.017838e-04
Rpv_55_17 p_55_17 p_55_18 5.017838e-04
Rph_55_18 p_55_18 p_56_18 5.017838e-04
Rpv_55_18 p_55_18 p_55_19 5.017838e-04
Rph_55_19 p_55_19 p_56_19 5.017838e-04
Rpv_55_19 p_55_19 p_55_20 5.017838e-04
Rph_55_20 p_55_20 p_56_20 5.017838e-04
Rpv_55_20 p_55_20 p_55_21 5.017838e-04
Rph_55_21 p_55_21 p_56_21 5.017838e-04
Rpv_55_21 p_55_21 p_55_22 5.017838e-04
Rph_55_22 p_55_22 p_56_22 5.017838e-04
Rpv_55_22 p_55_22 p_55_23 5.017838e-04
Rph_55_23 p_55_23 p_56_23 5.017838e-04
Rpv_55_23 p_55_23 p_55_24 5.017838e-04
Rph_55_24 p_55_24 p_56_24 5.017838e-04
Rpv_55_24 p_55_24 p_55_25 5.017838e-04
Rph_55_25 p_55_25 p_56_25 5.017838e-04
Rpv_55_25 p_55_25 p_55_26 5.017838e-04
Rph_55_26 p_55_26 p_56_26 5.017838e-04
Rpv_55_26 p_55_26 p_55_27 5.017838e-04
Rph_55_27 p_55_27 p_56_27 5.017838e-04
Rpv_55_27 p_55_27 p_55_28 5.017838e-04
Rph_55_28 p_55_28 p_56_28 5.017838e-04
Rpv_55_28 p_55_28 p_55_29 5.017838e-04
Rph_55_29 p_55_29 p_56_29 5.017838e-04
Rpv_55_29 p_55_29 p_55_30 5.017838e-04
Rph_55_30 p_55_30 p_56_30 5.017838e-04
Rpv_55_30 p_55_30 p_55_31 5.017838e-04
Rph_55_31 p_55_31 p_56_31 5.017838e-04
Rpv_55_31 p_55_31 p_55_32 5.017838e-04
Rph_55_32 p_55_32 p_56_32 5.017838e-04
Rpv_55_32 p_55_32 p_55_33 5.017838e-04
Rph_55_33 p_55_33 p_56_33 5.017838e-04
Rpv_55_33 p_55_33 p_55_34 5.017838e-04
Rph_55_34 p_55_34 p_56_34 5.017838e-04
Rpv_55_34 p_55_34 p_55_35 5.017838e-04
Rph_55_35 p_55_35 p_56_35 5.017838e-04
Rpv_55_35 p_55_35 p_55_36 5.017838e-04
Rph_55_36 p_55_36 p_56_36 5.017838e-04
Rpv_55_36 p_55_36 p_55_37 5.017838e-04
Rph_55_37 p_55_37 p_56_37 5.017838e-04
Rpv_55_37 p_55_37 p_55_38 5.017838e-04
Rph_55_38 p_55_38 p_56_38 5.017838e-04
Rpv_55_38 p_55_38 p_55_39 5.017838e-04
Rph_55_39 p_55_39 p_56_39 5.017838e-04
Rpv_55_39 p_55_39 p_55_40 5.017838e-04
Rph_55_40 p_55_40 p_56_40 5.017838e-04
Rpv_55_40 p_55_40 p_55_41 5.017838e-04
Rph_55_41 p_55_41 p_56_41 5.017838e-04
Rpv_55_41 p_55_41 p_55_42 5.017838e-04
Rph_55_42 p_55_42 p_56_42 5.017838e-04
Rpv_55_42 p_55_42 p_55_43 5.017838e-04
Rph_55_43 p_55_43 p_56_43 5.017838e-04
Rpv_55_43 p_55_43 p_55_44 5.017838e-04
Rph_55_44 p_55_44 p_56_44 5.017838e-04
Rpv_55_44 p_55_44 p_55_45 5.017838e-04
Rph_55_45 p_55_45 p_56_45 5.017838e-04
Rpv_55_45 p_55_45 p_55_46 5.017838e-04
Rph_55_46 p_55_46 p_56_46 5.017838e-04
Rpv_55_46 p_55_46 p_55_47 5.017838e-04
Rph_55_47 p_55_47 p_56_47 5.017838e-04
Rpv_55_47 p_55_47 p_55_48 5.017838e-04
Rph_55_48 p_55_48 p_56_48 5.017838e-04
Rpv_55_48 p_55_48 p_55_49 5.017838e-04
Rph_55_49 p_55_49 p_56_49 5.017838e-04
Rpv_55_49 p_55_49 p_55_50 5.017838e-04
Rph_55_50 p_55_50 p_56_50 5.017838e-04
Rpv_55_50 p_55_50 p_55_51 5.017838e-04
Rph_55_51 p_55_51 p_56_51 5.017838e-04
Rpv_55_51 p_55_51 p_55_52 5.017838e-04
Rph_55_52 p_55_52 p_56_52 5.017838e-04
Rpv_55_52 p_55_52 p_55_53 5.017838e-04
Rph_55_53 p_55_53 p_56_53 5.017838e-04
Rpv_55_53 p_55_53 p_55_54 5.017838e-04
Rph_55_54 p_55_54 p_56_54 5.017838e-04
Rpv_55_54 p_55_54 p_55_55 5.017838e-04
Rph_55_55 p_55_55 p_56_55 5.017838e-04
Rpv_55_55 p_55_55 p_55_56 5.017838e-04
Rph_55_56 p_55_56 p_56_56 5.017838e-04
Rpv_55_56 p_55_56 p_55_57 5.017838e-04
Rph_55_57 p_55_57 p_56_57 5.017838e-04
Rpv_55_57 p_55_57 p_55_58 5.017838e-04
Rph_55_58 p_55_58 p_56_58 5.017838e-04
Rpv_55_58 p_55_58 p_55_59 5.017838e-04
Rph_55_59 p_55_59 p_56_59 5.017838e-04
Rpv_55_59 p_55_59 p_55_60 5.017838e-04
Rph_55_60 p_55_60 p_56_60 5.017838e-04
Rpv_55_60 p_55_60 p_55_61 5.017838e-04
Rph_55_61 p_55_61 p_56_61 5.017838e-04
Rpv_55_61 p_55_61 p_55_62 5.017838e-04
Rph_55_62 p_55_62 p_56_62 5.017838e-04
Rpv_55_62 p_55_62 p_55_63 5.017838e-04
Rph_55_63 p_55_63 p_56_63 5.017838e-04
Rpv_55_63 p_55_63 p_55_64 5.017838e-04
Rph_55_64 p_55_64 p_56_64 5.017838e-04
Rpv_55_64 p_55_64 p_55_65 5.017838e-04
Rph_55_65 p_55_65 p_56_65 5.017838e-04
Rpv_55_65 p_55_65 p_55_66 5.017838e-04
Rph_55_66 p_55_66 p_56_66 5.017838e-04
Rpv_55_66 p_55_66 p_55_67 5.017838e-04
Rph_55_67 p_55_67 p_56_67 5.017838e-04
Rpv_55_67 p_55_67 p_55_68 5.017838e-04
Rph_55_68 p_55_68 p_56_68 5.017838e-04
Rpv_55_68 p_55_68 p_55_69 5.017838e-04
Rph_55_69 p_55_69 p_56_69 5.017838e-04
Rpv_55_69 p_55_69 p_55_70 5.017838e-04
Rph_55_70 p_55_70 p_56_70 5.017838e-04
Rpv_55_70 p_55_70 p_55_71 5.017838e-04
Rph_55_71 p_55_71 p_56_71 5.017838e-04
Rph_56_0 p_56_0 p_57_0 5.017838e-04
Rpv_56_0 p_56_0 p_56_1 5.017838e-04
Rph_56_1 p_56_1 p_57_1 5.017838e-04
Rpv_56_1 p_56_1 p_56_2 5.017838e-04
Rph_56_2 p_56_2 p_57_2 5.017838e-04
Rpv_56_2 p_56_2 p_56_3 5.017838e-04
Rph_56_3 p_56_3 p_57_3 5.017838e-04
Rpv_56_3 p_56_3 p_56_4 5.017838e-04
Rph_56_4 p_56_4 p_57_4 5.017838e-04
Rpv_56_4 p_56_4 p_56_5 5.017838e-04
Rph_56_5 p_56_5 p_57_5 5.017838e-04
Rpv_56_5 p_56_5 p_56_6 5.017838e-04
Rph_56_6 p_56_6 p_57_6 5.017838e-04
Rpv_56_6 p_56_6 p_56_7 5.017838e-04
Rph_56_7 p_56_7 p_57_7 5.017838e-04
Rpv_56_7 p_56_7 p_56_8 5.017838e-04
Rph_56_8 p_56_8 p_57_8 5.017838e-04
Rpv_56_8 p_56_8 p_56_9 5.017838e-04
Rph_56_9 p_56_9 p_57_9 5.017838e-04
Rpv_56_9 p_56_9 p_56_10 5.017838e-04
Rph_56_10 p_56_10 p_57_10 5.017838e-04
Rpv_56_10 p_56_10 p_56_11 5.017838e-04
Rph_56_11 p_56_11 p_57_11 5.017838e-04
Rpv_56_11 p_56_11 p_56_12 5.017838e-04
Rph_56_12 p_56_12 p_57_12 5.017838e-04
Rpv_56_12 p_56_12 p_56_13 5.017838e-04
Rph_56_13 p_56_13 p_57_13 5.017838e-04
Rpv_56_13 p_56_13 p_56_14 5.017838e-04
Rph_56_14 p_56_14 p_57_14 5.017838e-04
Rpv_56_14 p_56_14 p_56_15 5.017838e-04
Rph_56_15 p_56_15 p_57_15 5.017838e-04
Rpv_56_15 p_56_15 p_56_16 5.017838e-04
Rph_56_16 p_56_16 p_57_16 5.017838e-04
Rpv_56_16 p_56_16 p_56_17 5.017838e-04
Rph_56_17 p_56_17 p_57_17 5.017838e-04
Rpv_56_17 p_56_17 p_56_18 5.017838e-04
Rph_56_18 p_56_18 p_57_18 5.017838e-04
Rpv_56_18 p_56_18 p_56_19 5.017838e-04
Rph_56_19 p_56_19 p_57_19 5.017838e-04
Rpv_56_19 p_56_19 p_56_20 5.017838e-04
Rph_56_20 p_56_20 p_57_20 5.017838e-04
Rpv_56_20 p_56_20 p_56_21 5.017838e-04
Rph_56_21 p_56_21 p_57_21 5.017838e-04
Rpv_56_21 p_56_21 p_56_22 5.017838e-04
Rph_56_22 p_56_22 p_57_22 5.017838e-04
Rpv_56_22 p_56_22 p_56_23 5.017838e-04
Rph_56_23 p_56_23 p_57_23 5.017838e-04
Rpv_56_23 p_56_23 p_56_24 5.017838e-04
Rph_56_24 p_56_24 p_57_24 5.017838e-04
Rpv_56_24 p_56_24 p_56_25 5.017838e-04
Rph_56_25 p_56_25 p_57_25 5.017838e-04
Rpv_56_25 p_56_25 p_56_26 5.017838e-04
Rph_56_26 p_56_26 p_57_26 5.017838e-04
Rpv_56_26 p_56_26 p_56_27 5.017838e-04
Rph_56_27 p_56_27 p_57_27 5.017838e-04
Rpv_56_27 p_56_27 p_56_28 5.017838e-04
Rph_56_28 p_56_28 p_57_28 5.017838e-04
Rpv_56_28 p_56_28 p_56_29 5.017838e-04
Rph_56_29 p_56_29 p_57_29 5.017838e-04
Rpv_56_29 p_56_29 p_56_30 5.017838e-04
Rph_56_30 p_56_30 p_57_30 5.017838e-04
Rpv_56_30 p_56_30 p_56_31 5.017838e-04
Rph_56_31 p_56_31 p_57_31 5.017838e-04
Rpv_56_31 p_56_31 p_56_32 5.017838e-04
Rph_56_32 p_56_32 p_57_32 5.017838e-04
Rpv_56_32 p_56_32 p_56_33 5.017838e-04
Rph_56_33 p_56_33 p_57_33 5.017838e-04
Rpv_56_33 p_56_33 p_56_34 5.017838e-04
Rph_56_34 p_56_34 p_57_34 5.017838e-04
Rpv_56_34 p_56_34 p_56_35 5.017838e-04
Rph_56_35 p_56_35 p_57_35 5.017838e-04
Rpv_56_35 p_56_35 p_56_36 5.017838e-04
Rph_56_36 p_56_36 p_57_36 5.017838e-04
Rpv_56_36 p_56_36 p_56_37 5.017838e-04
Rph_56_37 p_56_37 p_57_37 5.017838e-04
Rpv_56_37 p_56_37 p_56_38 5.017838e-04
Rph_56_38 p_56_38 p_57_38 5.017838e-04
Rpv_56_38 p_56_38 p_56_39 5.017838e-04
Rph_56_39 p_56_39 p_57_39 5.017838e-04
Rpv_56_39 p_56_39 p_56_40 5.017838e-04
Rph_56_40 p_56_40 p_57_40 5.017838e-04
Rpv_56_40 p_56_40 p_56_41 5.017838e-04
Rph_56_41 p_56_41 p_57_41 5.017838e-04
Rpv_56_41 p_56_41 p_56_42 5.017838e-04
Rph_56_42 p_56_42 p_57_42 5.017838e-04
Rpv_56_42 p_56_42 p_56_43 5.017838e-04
Rph_56_43 p_56_43 p_57_43 5.017838e-04
Rpv_56_43 p_56_43 p_56_44 5.017838e-04
Rph_56_44 p_56_44 p_57_44 5.017838e-04
Rpv_56_44 p_56_44 p_56_45 5.017838e-04
Rph_56_45 p_56_45 p_57_45 5.017838e-04
Rpv_56_45 p_56_45 p_56_46 5.017838e-04
Rph_56_46 p_56_46 p_57_46 5.017838e-04
Rpv_56_46 p_56_46 p_56_47 5.017838e-04
Rph_56_47 p_56_47 p_57_47 5.017838e-04
Rpv_56_47 p_56_47 p_56_48 5.017838e-04
Rph_56_48 p_56_48 p_57_48 5.017838e-04
Rpv_56_48 p_56_48 p_56_49 5.017838e-04
Rph_56_49 p_56_49 p_57_49 5.017838e-04
Rpv_56_49 p_56_49 p_56_50 5.017838e-04
Rph_56_50 p_56_50 p_57_50 5.017838e-04
Rpv_56_50 p_56_50 p_56_51 5.017838e-04
Rph_56_51 p_56_51 p_57_51 5.017838e-04
Rpv_56_51 p_56_51 p_56_52 5.017838e-04
Rph_56_52 p_56_52 p_57_52 5.017838e-04
Rpv_56_52 p_56_52 p_56_53 5.017838e-04
Rph_56_53 p_56_53 p_57_53 5.017838e-04
Rpv_56_53 p_56_53 p_56_54 5.017838e-04
Rph_56_54 p_56_54 p_57_54 5.017838e-04
Rpv_56_54 p_56_54 p_56_55 5.017838e-04
Rph_56_55 p_56_55 p_57_55 5.017838e-04
Rpv_56_55 p_56_55 p_56_56 5.017838e-04
Rph_56_56 p_56_56 p_57_56 5.017838e-04
Rpv_56_56 p_56_56 p_56_57 5.017838e-04
Rph_56_57 p_56_57 p_57_57 5.017838e-04
Rpv_56_57 p_56_57 p_56_58 5.017838e-04
Rph_56_58 p_56_58 p_57_58 5.017838e-04
Rpv_56_58 p_56_58 p_56_59 5.017838e-04
Rph_56_59 p_56_59 p_57_59 5.017838e-04
Rpv_56_59 p_56_59 p_56_60 5.017838e-04
Rph_56_60 p_56_60 p_57_60 5.017838e-04
Rpv_56_60 p_56_60 p_56_61 5.017838e-04
Rph_56_61 p_56_61 p_57_61 5.017838e-04
Rpv_56_61 p_56_61 p_56_62 5.017838e-04
Rph_56_62 p_56_62 p_57_62 5.017838e-04
Rpv_56_62 p_56_62 p_56_63 5.017838e-04
Rph_56_63 p_56_63 p_57_63 5.017838e-04
Rpv_56_63 p_56_63 p_56_64 5.017838e-04
Rph_56_64 p_56_64 p_57_64 5.017838e-04
Rpv_56_64 p_56_64 p_56_65 5.017838e-04
Rph_56_65 p_56_65 p_57_65 5.017838e-04
Rpv_56_65 p_56_65 p_56_66 5.017838e-04
Rph_56_66 p_56_66 p_57_66 5.017838e-04
Rpv_56_66 p_56_66 p_56_67 5.017838e-04
Rph_56_67 p_56_67 p_57_67 5.017838e-04
Rpv_56_67 p_56_67 p_56_68 5.017838e-04
Rph_56_68 p_56_68 p_57_68 5.017838e-04
Rpv_56_68 p_56_68 p_56_69 5.017838e-04
Rph_56_69 p_56_69 p_57_69 5.017838e-04
Rpv_56_69 p_56_69 p_56_70 5.017838e-04
Rph_56_70 p_56_70 p_57_70 5.017838e-04
Rpv_56_70 p_56_70 p_56_71 5.017838e-04
Rph_56_71 p_56_71 p_57_71 5.017838e-04
Rph_57_0 p_57_0 p_58_0 5.017838e-04
Rpv_57_0 p_57_0 p_57_1 5.017838e-04
Rph_57_1 p_57_1 p_58_1 5.017838e-04
Rpv_57_1 p_57_1 p_57_2 5.017838e-04
Rph_57_2 p_57_2 p_58_2 5.017838e-04
Rpv_57_2 p_57_2 p_57_3 5.017838e-04
Rph_57_3 p_57_3 p_58_3 5.017838e-04
Rpv_57_3 p_57_3 p_57_4 5.017838e-04
Rph_57_4 p_57_4 p_58_4 5.017838e-04
Rpv_57_4 p_57_4 p_57_5 5.017838e-04
Rph_57_5 p_57_5 p_58_5 5.017838e-04
Rpv_57_5 p_57_5 p_57_6 5.017838e-04
Rph_57_6 p_57_6 p_58_6 5.017838e-04
Rpv_57_6 p_57_6 p_57_7 5.017838e-04
Rph_57_7 p_57_7 p_58_7 5.017838e-04
Rpv_57_7 p_57_7 p_57_8 5.017838e-04
Rph_57_8 p_57_8 p_58_8 5.017838e-04
Rpv_57_8 p_57_8 p_57_9 5.017838e-04
Rph_57_9 p_57_9 p_58_9 5.017838e-04
Rpv_57_9 p_57_9 p_57_10 5.017838e-04
Rph_57_10 p_57_10 p_58_10 5.017838e-04
Rpv_57_10 p_57_10 p_57_11 5.017838e-04
Rph_57_11 p_57_11 p_58_11 5.017838e-04
Rpv_57_11 p_57_11 p_57_12 5.017838e-04
Rph_57_12 p_57_12 p_58_12 5.017838e-04
Rpv_57_12 p_57_12 p_57_13 5.017838e-04
Rph_57_13 p_57_13 p_58_13 5.017838e-04
Rpv_57_13 p_57_13 p_57_14 5.017838e-04
Rph_57_14 p_57_14 p_58_14 5.017838e-04
Rpv_57_14 p_57_14 p_57_15 5.017838e-04
Rph_57_15 p_57_15 p_58_15 5.017838e-04
Rpv_57_15 p_57_15 p_57_16 5.017838e-04
Rph_57_16 p_57_16 p_58_16 5.017838e-04
Rpv_57_16 p_57_16 p_57_17 5.017838e-04
Rph_57_17 p_57_17 p_58_17 5.017838e-04
Rpv_57_17 p_57_17 p_57_18 5.017838e-04
Rph_57_18 p_57_18 p_58_18 5.017838e-04
Rpv_57_18 p_57_18 p_57_19 5.017838e-04
Rph_57_19 p_57_19 p_58_19 5.017838e-04
Rpv_57_19 p_57_19 p_57_20 5.017838e-04
Rph_57_20 p_57_20 p_58_20 5.017838e-04
Rpv_57_20 p_57_20 p_57_21 5.017838e-04
Rph_57_21 p_57_21 p_58_21 5.017838e-04
Rpv_57_21 p_57_21 p_57_22 5.017838e-04
Rph_57_22 p_57_22 p_58_22 5.017838e-04
Rpv_57_22 p_57_22 p_57_23 5.017838e-04
Rph_57_23 p_57_23 p_58_23 5.017838e-04
Rpv_57_23 p_57_23 p_57_24 5.017838e-04
Rph_57_24 p_57_24 p_58_24 5.017838e-04
Rpv_57_24 p_57_24 p_57_25 5.017838e-04
Rph_57_25 p_57_25 p_58_25 5.017838e-04
Rpv_57_25 p_57_25 p_57_26 5.017838e-04
Rph_57_26 p_57_26 p_58_26 5.017838e-04
Rpv_57_26 p_57_26 p_57_27 5.017838e-04
Rph_57_27 p_57_27 p_58_27 5.017838e-04
Rpv_57_27 p_57_27 p_57_28 5.017838e-04
Rph_57_28 p_57_28 p_58_28 5.017838e-04
Rpv_57_28 p_57_28 p_57_29 5.017838e-04
Rph_57_29 p_57_29 p_58_29 5.017838e-04
Rpv_57_29 p_57_29 p_57_30 5.017838e-04
Rph_57_30 p_57_30 p_58_30 5.017838e-04
Rpv_57_30 p_57_30 p_57_31 5.017838e-04
Rph_57_31 p_57_31 p_58_31 5.017838e-04
Rpv_57_31 p_57_31 p_57_32 5.017838e-04
Rph_57_32 p_57_32 p_58_32 5.017838e-04
Rpv_57_32 p_57_32 p_57_33 5.017838e-04
Rph_57_33 p_57_33 p_58_33 5.017838e-04
Rpv_57_33 p_57_33 p_57_34 5.017838e-04
Rph_57_34 p_57_34 p_58_34 5.017838e-04
Rpv_57_34 p_57_34 p_57_35 5.017838e-04
Rph_57_35 p_57_35 p_58_35 5.017838e-04
Rpv_57_35 p_57_35 p_57_36 5.017838e-04
Rph_57_36 p_57_36 p_58_36 5.017838e-04
Rpv_57_36 p_57_36 p_57_37 5.017838e-04
Rph_57_37 p_57_37 p_58_37 5.017838e-04
Rpv_57_37 p_57_37 p_57_38 5.017838e-04
Rph_57_38 p_57_38 p_58_38 5.017838e-04
Rpv_57_38 p_57_38 p_57_39 5.017838e-04
Rph_57_39 p_57_39 p_58_39 5.017838e-04
Rpv_57_39 p_57_39 p_57_40 5.017838e-04
Rph_57_40 p_57_40 p_58_40 5.017838e-04
Rpv_57_40 p_57_40 p_57_41 5.017838e-04
Rph_57_41 p_57_41 p_58_41 5.017838e-04
Rpv_57_41 p_57_41 p_57_42 5.017838e-04
Rph_57_42 p_57_42 p_58_42 5.017838e-04
Rpv_57_42 p_57_42 p_57_43 5.017838e-04
Rph_57_43 p_57_43 p_58_43 5.017838e-04
Rpv_57_43 p_57_43 p_57_44 5.017838e-04
Rph_57_44 p_57_44 p_58_44 5.017838e-04
Rpv_57_44 p_57_44 p_57_45 5.017838e-04
Rph_57_45 p_57_45 p_58_45 5.017838e-04
Rpv_57_45 p_57_45 p_57_46 5.017838e-04
Rph_57_46 p_57_46 p_58_46 5.017838e-04
Rpv_57_46 p_57_46 p_57_47 5.017838e-04
Rph_57_47 p_57_47 p_58_47 5.017838e-04
Rpv_57_47 p_57_47 p_57_48 5.017838e-04
Rph_57_48 p_57_48 p_58_48 5.017838e-04
Rpv_57_48 p_57_48 p_57_49 5.017838e-04
Rph_57_49 p_57_49 p_58_49 5.017838e-04
Rpv_57_49 p_57_49 p_57_50 5.017838e-04
Rph_57_50 p_57_50 p_58_50 5.017838e-04
Rpv_57_50 p_57_50 p_57_51 5.017838e-04
Rph_57_51 p_57_51 p_58_51 5.017838e-04
Rpv_57_51 p_57_51 p_57_52 5.017838e-04
Rph_57_52 p_57_52 p_58_52 5.017838e-04
Rpv_57_52 p_57_52 p_57_53 5.017838e-04
Rph_57_53 p_57_53 p_58_53 5.017838e-04
Rpv_57_53 p_57_53 p_57_54 5.017838e-04
Rph_57_54 p_57_54 p_58_54 5.017838e-04
Rpv_57_54 p_57_54 p_57_55 5.017838e-04
Rph_57_55 p_57_55 p_58_55 5.017838e-04
Rpv_57_55 p_57_55 p_57_56 5.017838e-04
Rph_57_56 p_57_56 p_58_56 5.017838e-04
Rpv_57_56 p_57_56 p_57_57 5.017838e-04
Rph_57_57 p_57_57 p_58_57 5.017838e-04
Rpv_57_57 p_57_57 p_57_58 5.017838e-04
Rph_57_58 p_57_58 p_58_58 5.017838e-04
Rpv_57_58 p_57_58 p_57_59 5.017838e-04
Rph_57_59 p_57_59 p_58_59 5.017838e-04
Rpv_57_59 p_57_59 p_57_60 5.017838e-04
Rph_57_60 p_57_60 p_58_60 5.017838e-04
Rpv_57_60 p_57_60 p_57_61 5.017838e-04
Rph_57_61 p_57_61 p_58_61 5.017838e-04
Rpv_57_61 p_57_61 p_57_62 5.017838e-04
Rph_57_62 p_57_62 p_58_62 5.017838e-04
Rpv_57_62 p_57_62 p_57_63 5.017838e-04
Rph_57_63 p_57_63 p_58_63 5.017838e-04
Rpv_57_63 p_57_63 p_57_64 5.017838e-04
Rph_57_64 p_57_64 p_58_64 5.017838e-04
Rpv_57_64 p_57_64 p_57_65 5.017838e-04
Rph_57_65 p_57_65 p_58_65 5.017838e-04
Rpv_57_65 p_57_65 p_57_66 5.017838e-04
Rph_57_66 p_57_66 p_58_66 5.017838e-04
Rpv_57_66 p_57_66 p_57_67 5.017838e-04
Rph_57_67 p_57_67 p_58_67 5.017838e-04
Rpv_57_67 p_57_67 p_57_68 5.017838e-04
Rph_57_68 p_57_68 p_58_68 5.017838e-04
Rpv_57_68 p_57_68 p_57_69 5.017838e-04
Rph_57_69 p_57_69 p_58_69 5.017838e-04
Rpv_57_69 p_57_69 p_57_70 5.017838e-04
Rph_57_70 p_57_70 p_58_70 5.017838e-04
Rpv_57_70 p_57_70 p_57_71 5.017838e-04
Rph_57_71 p_57_71 p_58_71 5.017838e-04
Rph_58_0 p_58_0 p_59_0 5.017838e-04
Rpv_58_0 p_58_0 p_58_1 5.017838e-04
Rph_58_1 p_58_1 p_59_1 5.017838e-04
Rpv_58_1 p_58_1 p_58_2 5.017838e-04
Rph_58_2 p_58_2 p_59_2 5.017838e-04
Rpv_58_2 p_58_2 p_58_3 5.017838e-04
Rph_58_3 p_58_3 p_59_3 5.017838e-04
Rpv_58_3 p_58_3 p_58_4 5.017838e-04
Rph_58_4 p_58_4 p_59_4 5.017838e-04
Rpv_58_4 p_58_4 p_58_5 5.017838e-04
Rph_58_5 p_58_5 p_59_5 5.017838e-04
Rpv_58_5 p_58_5 p_58_6 5.017838e-04
Rph_58_6 p_58_6 p_59_6 5.017838e-04
Rpv_58_6 p_58_6 p_58_7 5.017838e-04
Rph_58_7 p_58_7 p_59_7 5.017838e-04
Rpv_58_7 p_58_7 p_58_8 5.017838e-04
Rph_58_8 p_58_8 p_59_8 5.017838e-04
Rpv_58_8 p_58_8 p_58_9 5.017838e-04
Rph_58_9 p_58_9 p_59_9 5.017838e-04
Rpv_58_9 p_58_9 p_58_10 5.017838e-04
Rph_58_10 p_58_10 p_59_10 5.017838e-04
Rpv_58_10 p_58_10 p_58_11 5.017838e-04
Rph_58_11 p_58_11 p_59_11 5.017838e-04
Rpv_58_11 p_58_11 p_58_12 5.017838e-04
Rph_58_12 p_58_12 p_59_12 5.017838e-04
Rpv_58_12 p_58_12 p_58_13 5.017838e-04
Rph_58_13 p_58_13 p_59_13 5.017838e-04
Rpv_58_13 p_58_13 p_58_14 5.017838e-04
Rph_58_14 p_58_14 p_59_14 5.017838e-04
Rpv_58_14 p_58_14 p_58_15 5.017838e-04
Rph_58_15 p_58_15 p_59_15 5.017838e-04
Rpv_58_15 p_58_15 p_58_16 5.017838e-04
Rph_58_16 p_58_16 p_59_16 5.017838e-04
Rpv_58_16 p_58_16 p_58_17 5.017838e-04
Rph_58_17 p_58_17 p_59_17 5.017838e-04
Rpv_58_17 p_58_17 p_58_18 5.017838e-04
Rph_58_18 p_58_18 p_59_18 5.017838e-04
Rpv_58_18 p_58_18 p_58_19 5.017838e-04
Rph_58_19 p_58_19 p_59_19 5.017838e-04
Rpv_58_19 p_58_19 p_58_20 5.017838e-04
Rph_58_20 p_58_20 p_59_20 5.017838e-04
Rpv_58_20 p_58_20 p_58_21 5.017838e-04
Rph_58_21 p_58_21 p_59_21 5.017838e-04
Rpv_58_21 p_58_21 p_58_22 5.017838e-04
Rph_58_22 p_58_22 p_59_22 5.017838e-04
Rpv_58_22 p_58_22 p_58_23 5.017838e-04
Rph_58_23 p_58_23 p_59_23 5.017838e-04
Rpv_58_23 p_58_23 p_58_24 5.017838e-04
Rph_58_24 p_58_24 p_59_24 5.017838e-04
Rpv_58_24 p_58_24 p_58_25 5.017838e-04
Rph_58_25 p_58_25 p_59_25 5.017838e-04
Rpv_58_25 p_58_25 p_58_26 5.017838e-04
Rph_58_26 p_58_26 p_59_26 5.017838e-04
Rpv_58_26 p_58_26 p_58_27 5.017838e-04
Rph_58_27 p_58_27 p_59_27 5.017838e-04
Rpv_58_27 p_58_27 p_58_28 5.017838e-04
Rph_58_28 p_58_28 p_59_28 5.017838e-04
Rpv_58_28 p_58_28 p_58_29 5.017838e-04
Rph_58_29 p_58_29 p_59_29 5.017838e-04
Rpv_58_29 p_58_29 p_58_30 5.017838e-04
Rph_58_30 p_58_30 p_59_30 5.017838e-04
Rpv_58_30 p_58_30 p_58_31 5.017838e-04
Rph_58_31 p_58_31 p_59_31 5.017838e-04
Rpv_58_31 p_58_31 p_58_32 5.017838e-04
Rph_58_32 p_58_32 p_59_32 5.017838e-04
Rpv_58_32 p_58_32 p_58_33 5.017838e-04
Rph_58_33 p_58_33 p_59_33 5.017838e-04
Rpv_58_33 p_58_33 p_58_34 5.017838e-04
Rph_58_34 p_58_34 p_59_34 5.017838e-04
Rpv_58_34 p_58_34 p_58_35 5.017838e-04
Rph_58_35 p_58_35 p_59_35 5.017838e-04
Rpv_58_35 p_58_35 p_58_36 5.017838e-04
Rph_58_36 p_58_36 p_59_36 5.017838e-04
Rpv_58_36 p_58_36 p_58_37 5.017838e-04
Rph_58_37 p_58_37 p_59_37 5.017838e-04
Rpv_58_37 p_58_37 p_58_38 5.017838e-04
Rph_58_38 p_58_38 p_59_38 5.017838e-04
Rpv_58_38 p_58_38 p_58_39 5.017838e-04
Rph_58_39 p_58_39 p_59_39 5.017838e-04
Rpv_58_39 p_58_39 p_58_40 5.017838e-04
Rph_58_40 p_58_40 p_59_40 5.017838e-04
Rpv_58_40 p_58_40 p_58_41 5.017838e-04
Rph_58_41 p_58_41 p_59_41 5.017838e-04
Rpv_58_41 p_58_41 p_58_42 5.017838e-04
Rph_58_42 p_58_42 p_59_42 5.017838e-04
Rpv_58_42 p_58_42 p_58_43 5.017838e-04
Rph_58_43 p_58_43 p_59_43 5.017838e-04
Rpv_58_43 p_58_43 p_58_44 5.017838e-04
Rph_58_44 p_58_44 p_59_44 5.017838e-04
Rpv_58_44 p_58_44 p_58_45 5.017838e-04
Rph_58_45 p_58_45 p_59_45 5.017838e-04
Rpv_58_45 p_58_45 p_58_46 5.017838e-04
Rph_58_46 p_58_46 p_59_46 5.017838e-04
Rpv_58_46 p_58_46 p_58_47 5.017838e-04
Rph_58_47 p_58_47 p_59_47 5.017838e-04
Rpv_58_47 p_58_47 p_58_48 5.017838e-04
Rph_58_48 p_58_48 p_59_48 5.017838e-04
Rpv_58_48 p_58_48 p_58_49 5.017838e-04
Rph_58_49 p_58_49 p_59_49 5.017838e-04
Rpv_58_49 p_58_49 p_58_50 5.017838e-04
Rph_58_50 p_58_50 p_59_50 5.017838e-04
Rpv_58_50 p_58_50 p_58_51 5.017838e-04
Rph_58_51 p_58_51 p_59_51 5.017838e-04
Rpv_58_51 p_58_51 p_58_52 5.017838e-04
Rph_58_52 p_58_52 p_59_52 5.017838e-04
Rpv_58_52 p_58_52 p_58_53 5.017838e-04
Rph_58_53 p_58_53 p_59_53 5.017838e-04
Rpv_58_53 p_58_53 p_58_54 5.017838e-04
Rph_58_54 p_58_54 p_59_54 5.017838e-04
Rpv_58_54 p_58_54 p_58_55 5.017838e-04
Rph_58_55 p_58_55 p_59_55 5.017838e-04
Rpv_58_55 p_58_55 p_58_56 5.017838e-04
Rph_58_56 p_58_56 p_59_56 5.017838e-04
Rpv_58_56 p_58_56 p_58_57 5.017838e-04
Rph_58_57 p_58_57 p_59_57 5.017838e-04
Rpv_58_57 p_58_57 p_58_58 5.017838e-04
Rph_58_58 p_58_58 p_59_58 5.017838e-04
Rpv_58_58 p_58_58 p_58_59 5.017838e-04
Rph_58_59 p_58_59 p_59_59 5.017838e-04
Rpv_58_59 p_58_59 p_58_60 5.017838e-04
Rph_58_60 p_58_60 p_59_60 5.017838e-04
Rpv_58_60 p_58_60 p_58_61 5.017838e-04
Rph_58_61 p_58_61 p_59_61 5.017838e-04
Rpv_58_61 p_58_61 p_58_62 5.017838e-04
Rph_58_62 p_58_62 p_59_62 5.017838e-04
Rpv_58_62 p_58_62 p_58_63 5.017838e-04
Rph_58_63 p_58_63 p_59_63 5.017838e-04
Rpv_58_63 p_58_63 p_58_64 5.017838e-04
Rph_58_64 p_58_64 p_59_64 5.017838e-04
Rpv_58_64 p_58_64 p_58_65 5.017838e-04
Rph_58_65 p_58_65 p_59_65 5.017838e-04
Rpv_58_65 p_58_65 p_58_66 5.017838e-04
Rph_58_66 p_58_66 p_59_66 5.017838e-04
Rpv_58_66 p_58_66 p_58_67 5.017838e-04
Rph_58_67 p_58_67 p_59_67 5.017838e-04
Rpv_58_67 p_58_67 p_58_68 5.017838e-04
Rph_58_68 p_58_68 p_59_68 5.017838e-04
Rpv_58_68 p_58_68 p_58_69 5.017838e-04
Rph_58_69 p_58_69 p_59_69 5.017838e-04
Rpv_58_69 p_58_69 p_58_70 5.017838e-04
Rph_58_70 p_58_70 p_59_70 5.017838e-04
Rpv_58_70 p_58_70 p_58_71 5.017838e-04
Rph_58_71 p_58_71 p_59_71 5.017838e-04
Rph_59_0 p_59_0 p_60_0 5.017838e-04
Rpv_59_0 p_59_0 p_59_1 5.017838e-04
Rph_59_1 p_59_1 p_60_1 5.017838e-04
Rpv_59_1 p_59_1 p_59_2 5.017838e-04
Rph_59_2 p_59_2 p_60_2 5.017838e-04
Rpv_59_2 p_59_2 p_59_3 5.017838e-04
Rph_59_3 p_59_3 p_60_3 5.017838e-04
Rpv_59_3 p_59_3 p_59_4 5.017838e-04
Rph_59_4 p_59_4 p_60_4 5.017838e-04
Rpv_59_4 p_59_4 p_59_5 5.017838e-04
Rph_59_5 p_59_5 p_60_5 5.017838e-04
Rpv_59_5 p_59_5 p_59_6 5.017838e-04
Rph_59_6 p_59_6 p_60_6 5.017838e-04
Rpv_59_6 p_59_6 p_59_7 5.017838e-04
Rph_59_7 p_59_7 p_60_7 5.017838e-04
Rpv_59_7 p_59_7 p_59_8 5.017838e-04
Rph_59_8 p_59_8 p_60_8 5.017838e-04
Rpv_59_8 p_59_8 p_59_9 5.017838e-04
Rph_59_9 p_59_9 p_60_9 5.017838e-04
Rpv_59_9 p_59_9 p_59_10 5.017838e-04
Rph_59_10 p_59_10 p_60_10 5.017838e-04
Rpv_59_10 p_59_10 p_59_11 5.017838e-04
Rph_59_11 p_59_11 p_60_11 5.017838e-04
Rpv_59_11 p_59_11 p_59_12 5.017838e-04
Rph_59_12 p_59_12 p_60_12 5.017838e-04
Rpv_59_12 p_59_12 p_59_13 5.017838e-04
Rph_59_13 p_59_13 p_60_13 5.017838e-04
Rpv_59_13 p_59_13 p_59_14 5.017838e-04
Rph_59_14 p_59_14 p_60_14 5.017838e-04
Rpv_59_14 p_59_14 p_59_15 5.017838e-04
Rph_59_15 p_59_15 p_60_15 5.017838e-04
Rpv_59_15 p_59_15 p_59_16 5.017838e-04
Rph_59_16 p_59_16 p_60_16 5.017838e-04
Rpv_59_16 p_59_16 p_59_17 5.017838e-04
Rph_59_17 p_59_17 p_60_17 5.017838e-04
Rpv_59_17 p_59_17 p_59_18 5.017838e-04
Rph_59_18 p_59_18 p_60_18 5.017838e-04
Rpv_59_18 p_59_18 p_59_19 5.017838e-04
Rph_59_19 p_59_19 p_60_19 5.017838e-04
Rpv_59_19 p_59_19 p_59_20 5.017838e-04
Rph_59_20 p_59_20 p_60_20 5.017838e-04
Rpv_59_20 p_59_20 p_59_21 5.017838e-04
Rph_59_21 p_59_21 p_60_21 5.017838e-04
Rpv_59_21 p_59_21 p_59_22 5.017838e-04
Rph_59_22 p_59_22 p_60_22 5.017838e-04
Rpv_59_22 p_59_22 p_59_23 5.017838e-04
Rph_59_23 p_59_23 p_60_23 5.017838e-04
Rpv_59_23 p_59_23 p_59_24 5.017838e-04
Rph_59_24 p_59_24 p_60_24 5.017838e-04
Rpv_59_24 p_59_24 p_59_25 5.017838e-04
Rph_59_25 p_59_25 p_60_25 5.017838e-04
Rpv_59_25 p_59_25 p_59_26 5.017838e-04
Rph_59_26 p_59_26 p_60_26 5.017838e-04
Rpv_59_26 p_59_26 p_59_27 5.017838e-04
Rph_59_27 p_59_27 p_60_27 5.017838e-04
Rpv_59_27 p_59_27 p_59_28 5.017838e-04
Rph_59_28 p_59_28 p_60_28 5.017838e-04
Rpv_59_28 p_59_28 p_59_29 5.017838e-04
Rph_59_29 p_59_29 p_60_29 5.017838e-04
Rpv_59_29 p_59_29 p_59_30 5.017838e-04
Rph_59_30 p_59_30 p_60_30 5.017838e-04
Rpv_59_30 p_59_30 p_59_31 5.017838e-04
Rph_59_31 p_59_31 p_60_31 5.017838e-04
Rpv_59_31 p_59_31 p_59_32 5.017838e-04
Rph_59_32 p_59_32 p_60_32 5.017838e-04
Rpv_59_32 p_59_32 p_59_33 5.017838e-04
Rph_59_33 p_59_33 p_60_33 5.017838e-04
Rpv_59_33 p_59_33 p_59_34 5.017838e-04
Rph_59_34 p_59_34 p_60_34 5.017838e-04
Rpv_59_34 p_59_34 p_59_35 5.017838e-04
Rph_59_35 p_59_35 p_60_35 5.017838e-04
Rpv_59_35 p_59_35 p_59_36 5.017838e-04
Rph_59_36 p_59_36 p_60_36 5.017838e-04
Rpv_59_36 p_59_36 p_59_37 5.017838e-04
Rph_59_37 p_59_37 p_60_37 5.017838e-04
Rpv_59_37 p_59_37 p_59_38 5.017838e-04
Rph_59_38 p_59_38 p_60_38 5.017838e-04
Rpv_59_38 p_59_38 p_59_39 5.017838e-04
Rph_59_39 p_59_39 p_60_39 5.017838e-04
Rpv_59_39 p_59_39 p_59_40 5.017838e-04
Rph_59_40 p_59_40 p_60_40 5.017838e-04
Rpv_59_40 p_59_40 p_59_41 5.017838e-04
Rph_59_41 p_59_41 p_60_41 5.017838e-04
Rpv_59_41 p_59_41 p_59_42 5.017838e-04
Rph_59_42 p_59_42 p_60_42 5.017838e-04
Rpv_59_42 p_59_42 p_59_43 5.017838e-04
Rph_59_43 p_59_43 p_60_43 5.017838e-04
Rpv_59_43 p_59_43 p_59_44 5.017838e-04
Rph_59_44 p_59_44 p_60_44 5.017838e-04
Rpv_59_44 p_59_44 p_59_45 5.017838e-04
Rph_59_45 p_59_45 p_60_45 5.017838e-04
Rpv_59_45 p_59_45 p_59_46 5.017838e-04
Rph_59_46 p_59_46 p_60_46 5.017838e-04
Rpv_59_46 p_59_46 p_59_47 5.017838e-04
Rph_59_47 p_59_47 p_60_47 5.017838e-04
Rpv_59_47 p_59_47 p_59_48 5.017838e-04
Rph_59_48 p_59_48 p_60_48 5.017838e-04
Rpv_59_48 p_59_48 p_59_49 5.017838e-04
Rph_59_49 p_59_49 p_60_49 5.017838e-04
Rpv_59_49 p_59_49 p_59_50 5.017838e-04
Rph_59_50 p_59_50 p_60_50 5.017838e-04
Rpv_59_50 p_59_50 p_59_51 5.017838e-04
Rph_59_51 p_59_51 p_60_51 5.017838e-04
Rpv_59_51 p_59_51 p_59_52 5.017838e-04
Rph_59_52 p_59_52 p_60_52 5.017838e-04
Rpv_59_52 p_59_52 p_59_53 5.017838e-04
Rph_59_53 p_59_53 p_60_53 5.017838e-04
Rpv_59_53 p_59_53 p_59_54 5.017838e-04
Rph_59_54 p_59_54 p_60_54 5.017838e-04
Rpv_59_54 p_59_54 p_59_55 5.017838e-04
Rph_59_55 p_59_55 p_60_55 5.017838e-04
Rpv_59_55 p_59_55 p_59_56 5.017838e-04
Rph_59_56 p_59_56 p_60_56 5.017838e-04
Rpv_59_56 p_59_56 p_59_57 5.017838e-04
Rph_59_57 p_59_57 p_60_57 5.017838e-04
Rpv_59_57 p_59_57 p_59_58 5.017838e-04
Rph_59_58 p_59_58 p_60_58 5.017838e-04
Rpv_59_58 p_59_58 p_59_59 5.017838e-04
Rph_59_59 p_59_59 p_60_59 5.017838e-04
Rpv_59_59 p_59_59 p_59_60 5.017838e-04
Rph_59_60 p_59_60 p_60_60 5.017838e-04
Rpv_59_60 p_59_60 p_59_61 5.017838e-04
Rph_59_61 p_59_61 p_60_61 5.017838e-04
Rpv_59_61 p_59_61 p_59_62 5.017838e-04
Rph_59_62 p_59_62 p_60_62 5.017838e-04
Rpv_59_62 p_59_62 p_59_63 5.017838e-04
Rph_59_63 p_59_63 p_60_63 5.017838e-04
Rpv_59_63 p_59_63 p_59_64 5.017838e-04
Rph_59_64 p_59_64 p_60_64 5.017838e-04
Rpv_59_64 p_59_64 p_59_65 5.017838e-04
Rph_59_65 p_59_65 p_60_65 5.017838e-04
Rpv_59_65 p_59_65 p_59_66 5.017838e-04
Rph_59_66 p_59_66 p_60_66 5.017838e-04
Rpv_59_66 p_59_66 p_59_67 5.017838e-04
Rph_59_67 p_59_67 p_60_67 5.017838e-04
Rpv_59_67 p_59_67 p_59_68 5.017838e-04
Rph_59_68 p_59_68 p_60_68 5.017838e-04
Rpv_59_68 p_59_68 p_59_69 5.017838e-04
Rph_59_69 p_59_69 p_60_69 5.017838e-04
Rpv_59_69 p_59_69 p_59_70 5.017838e-04
Rph_59_70 p_59_70 p_60_70 5.017838e-04
Rpv_59_70 p_59_70 p_59_71 5.017838e-04
Rph_59_71 p_59_71 p_60_71 5.017838e-04
Rph_60_0 p_60_0 p_61_0 5.017838e-04
Rpv_60_0 p_60_0 p_60_1 5.017838e-04
Rph_60_1 p_60_1 p_61_1 5.017838e-04
Rpv_60_1 p_60_1 p_60_2 5.017838e-04
Rph_60_2 p_60_2 p_61_2 5.017838e-04
Rpv_60_2 p_60_2 p_60_3 5.017838e-04
Rph_60_3 p_60_3 p_61_3 5.017838e-04
Rpv_60_3 p_60_3 p_60_4 5.017838e-04
Rph_60_4 p_60_4 p_61_4 5.017838e-04
Rpv_60_4 p_60_4 p_60_5 5.017838e-04
Rph_60_5 p_60_5 p_61_5 5.017838e-04
Rpv_60_5 p_60_5 p_60_6 5.017838e-04
Rph_60_6 p_60_6 p_61_6 5.017838e-04
Rpv_60_6 p_60_6 p_60_7 5.017838e-04
Rph_60_7 p_60_7 p_61_7 5.017838e-04
Rpv_60_7 p_60_7 p_60_8 5.017838e-04
Rph_60_8 p_60_8 p_61_8 5.017838e-04
Rpv_60_8 p_60_8 p_60_9 5.017838e-04
Rph_60_9 p_60_9 p_61_9 5.017838e-04
Rpv_60_9 p_60_9 p_60_10 5.017838e-04
Rph_60_10 p_60_10 p_61_10 5.017838e-04
Rpv_60_10 p_60_10 p_60_11 5.017838e-04
Rph_60_11 p_60_11 p_61_11 5.017838e-04
Rpv_60_11 p_60_11 p_60_12 5.017838e-04
Rph_60_12 p_60_12 p_61_12 5.017838e-04
Rpv_60_12 p_60_12 p_60_13 5.017838e-04
Rph_60_13 p_60_13 p_61_13 5.017838e-04
Rpv_60_13 p_60_13 p_60_14 5.017838e-04
Rph_60_14 p_60_14 p_61_14 5.017838e-04
Rpv_60_14 p_60_14 p_60_15 5.017838e-04
Rph_60_15 p_60_15 p_61_15 5.017838e-04
Rpv_60_15 p_60_15 p_60_16 5.017838e-04
Rph_60_16 p_60_16 p_61_16 5.017838e-04
Rpv_60_16 p_60_16 p_60_17 5.017838e-04
Rph_60_17 p_60_17 p_61_17 5.017838e-04
Rpv_60_17 p_60_17 p_60_18 5.017838e-04
Rph_60_18 p_60_18 p_61_18 5.017838e-04
Rpv_60_18 p_60_18 p_60_19 5.017838e-04
Rph_60_19 p_60_19 p_61_19 5.017838e-04
Rpv_60_19 p_60_19 p_60_20 5.017838e-04
Rph_60_20 p_60_20 p_61_20 5.017838e-04
Rpv_60_20 p_60_20 p_60_21 5.017838e-04
Rph_60_21 p_60_21 p_61_21 5.017838e-04
Rpv_60_21 p_60_21 p_60_22 5.017838e-04
Rph_60_22 p_60_22 p_61_22 5.017838e-04
Rpv_60_22 p_60_22 p_60_23 5.017838e-04
Rph_60_23 p_60_23 p_61_23 5.017838e-04
Rpv_60_23 p_60_23 p_60_24 5.017838e-04
Rph_60_24 p_60_24 p_61_24 5.017838e-04
Rpv_60_24 p_60_24 p_60_25 5.017838e-04
Rph_60_25 p_60_25 p_61_25 5.017838e-04
Rpv_60_25 p_60_25 p_60_26 5.017838e-04
Rph_60_26 p_60_26 p_61_26 5.017838e-04
Rpv_60_26 p_60_26 p_60_27 5.017838e-04
Rph_60_27 p_60_27 p_61_27 5.017838e-04
Rpv_60_27 p_60_27 p_60_28 5.017838e-04
Rph_60_28 p_60_28 p_61_28 5.017838e-04
Rpv_60_28 p_60_28 p_60_29 5.017838e-04
Rph_60_29 p_60_29 p_61_29 5.017838e-04
Rpv_60_29 p_60_29 p_60_30 5.017838e-04
Rph_60_30 p_60_30 p_61_30 5.017838e-04
Rpv_60_30 p_60_30 p_60_31 5.017838e-04
Rph_60_31 p_60_31 p_61_31 5.017838e-04
Rpv_60_31 p_60_31 p_60_32 5.017838e-04
Rph_60_32 p_60_32 p_61_32 5.017838e-04
Rpv_60_32 p_60_32 p_60_33 5.017838e-04
Rph_60_33 p_60_33 p_61_33 5.017838e-04
Rpv_60_33 p_60_33 p_60_34 5.017838e-04
Rph_60_34 p_60_34 p_61_34 5.017838e-04
Rpv_60_34 p_60_34 p_60_35 5.017838e-04
Rph_60_35 p_60_35 p_61_35 5.017838e-04
Rpv_60_35 p_60_35 p_60_36 5.017838e-04
Rph_60_36 p_60_36 p_61_36 5.017838e-04
Rpv_60_36 p_60_36 p_60_37 5.017838e-04
Rph_60_37 p_60_37 p_61_37 5.017838e-04
Rpv_60_37 p_60_37 p_60_38 5.017838e-04
Rph_60_38 p_60_38 p_61_38 5.017838e-04
Rpv_60_38 p_60_38 p_60_39 5.017838e-04
Rph_60_39 p_60_39 p_61_39 5.017838e-04
Rpv_60_39 p_60_39 p_60_40 5.017838e-04
Rph_60_40 p_60_40 p_61_40 5.017838e-04
Rpv_60_40 p_60_40 p_60_41 5.017838e-04
Rph_60_41 p_60_41 p_61_41 5.017838e-04
Rpv_60_41 p_60_41 p_60_42 5.017838e-04
Rph_60_42 p_60_42 p_61_42 5.017838e-04
Rpv_60_42 p_60_42 p_60_43 5.017838e-04
Rph_60_43 p_60_43 p_61_43 5.017838e-04
Rpv_60_43 p_60_43 p_60_44 5.017838e-04
Rph_60_44 p_60_44 p_61_44 5.017838e-04
Rpv_60_44 p_60_44 p_60_45 5.017838e-04
Rph_60_45 p_60_45 p_61_45 5.017838e-04
Rpv_60_45 p_60_45 p_60_46 5.017838e-04
Rph_60_46 p_60_46 p_61_46 5.017838e-04
Rpv_60_46 p_60_46 p_60_47 5.017838e-04
Rph_60_47 p_60_47 p_61_47 5.017838e-04
Rpv_60_47 p_60_47 p_60_48 5.017838e-04
Rph_60_48 p_60_48 p_61_48 5.017838e-04
Rpv_60_48 p_60_48 p_60_49 5.017838e-04
Rph_60_49 p_60_49 p_61_49 5.017838e-04
Rpv_60_49 p_60_49 p_60_50 5.017838e-04
Rph_60_50 p_60_50 p_61_50 5.017838e-04
Rpv_60_50 p_60_50 p_60_51 5.017838e-04
Rph_60_51 p_60_51 p_61_51 5.017838e-04
Rpv_60_51 p_60_51 p_60_52 5.017838e-04
Rph_60_52 p_60_52 p_61_52 5.017838e-04
Rpv_60_52 p_60_52 p_60_53 5.017838e-04
Rph_60_53 p_60_53 p_61_53 5.017838e-04
Rpv_60_53 p_60_53 p_60_54 5.017838e-04
Rph_60_54 p_60_54 p_61_54 5.017838e-04
Rpv_60_54 p_60_54 p_60_55 5.017838e-04
Rph_60_55 p_60_55 p_61_55 5.017838e-04
Rpv_60_55 p_60_55 p_60_56 5.017838e-04
Rph_60_56 p_60_56 p_61_56 5.017838e-04
Rpv_60_56 p_60_56 p_60_57 5.017838e-04
Rph_60_57 p_60_57 p_61_57 5.017838e-04
Rpv_60_57 p_60_57 p_60_58 5.017838e-04
Rph_60_58 p_60_58 p_61_58 5.017838e-04
Rpv_60_58 p_60_58 p_60_59 5.017838e-04
Rph_60_59 p_60_59 p_61_59 5.017838e-04
Rpv_60_59 p_60_59 p_60_60 5.017838e-04
Rph_60_60 p_60_60 p_61_60 5.017838e-04
Rpv_60_60 p_60_60 p_60_61 5.017838e-04
Rph_60_61 p_60_61 p_61_61 5.017838e-04
Rpv_60_61 p_60_61 p_60_62 5.017838e-04
Rph_60_62 p_60_62 p_61_62 5.017838e-04
Rpv_60_62 p_60_62 p_60_63 5.017838e-04
Rph_60_63 p_60_63 p_61_63 5.017838e-04
Rpv_60_63 p_60_63 p_60_64 5.017838e-04
Rph_60_64 p_60_64 p_61_64 5.017838e-04
Rpv_60_64 p_60_64 p_60_65 5.017838e-04
Rph_60_65 p_60_65 p_61_65 5.017838e-04
Rpv_60_65 p_60_65 p_60_66 5.017838e-04
Rph_60_66 p_60_66 p_61_66 5.017838e-04
Rpv_60_66 p_60_66 p_60_67 5.017838e-04
Rph_60_67 p_60_67 p_61_67 5.017838e-04
Rpv_60_67 p_60_67 p_60_68 5.017838e-04
Rph_60_68 p_60_68 p_61_68 5.017838e-04
Rpv_60_68 p_60_68 p_60_69 5.017838e-04
Rph_60_69 p_60_69 p_61_69 5.017838e-04
Rpv_60_69 p_60_69 p_60_70 5.017838e-04
Rph_60_70 p_60_70 p_61_70 5.017838e-04
Rpv_60_70 p_60_70 p_60_71 5.017838e-04
Rph_60_71 p_60_71 p_61_71 5.017838e-04
Rph_61_0 p_61_0 p_62_0 5.017838e-04
Rpv_61_0 p_61_0 p_61_1 5.017838e-04
Rph_61_1 p_61_1 p_62_1 5.017838e-04
Rpv_61_1 p_61_1 p_61_2 5.017838e-04
Rph_61_2 p_61_2 p_62_2 5.017838e-04
Rpv_61_2 p_61_2 p_61_3 5.017838e-04
Rph_61_3 p_61_3 p_62_3 5.017838e-04
Rpv_61_3 p_61_3 p_61_4 5.017838e-04
Rph_61_4 p_61_4 p_62_4 5.017838e-04
Rpv_61_4 p_61_4 p_61_5 5.017838e-04
Rph_61_5 p_61_5 p_62_5 5.017838e-04
Rpv_61_5 p_61_5 p_61_6 5.017838e-04
Rph_61_6 p_61_6 p_62_6 5.017838e-04
Rpv_61_6 p_61_6 p_61_7 5.017838e-04
Rph_61_7 p_61_7 p_62_7 5.017838e-04
Rpv_61_7 p_61_7 p_61_8 5.017838e-04
Rph_61_8 p_61_8 p_62_8 5.017838e-04
Rpv_61_8 p_61_8 p_61_9 5.017838e-04
Rph_61_9 p_61_9 p_62_9 5.017838e-04
Rpv_61_9 p_61_9 p_61_10 5.017838e-04
Rph_61_10 p_61_10 p_62_10 5.017838e-04
Rpv_61_10 p_61_10 p_61_11 5.017838e-04
Rph_61_11 p_61_11 p_62_11 5.017838e-04
Rpv_61_11 p_61_11 p_61_12 5.017838e-04
Rph_61_12 p_61_12 p_62_12 5.017838e-04
Rpv_61_12 p_61_12 p_61_13 5.017838e-04
Rph_61_13 p_61_13 p_62_13 5.017838e-04
Rpv_61_13 p_61_13 p_61_14 5.017838e-04
Rph_61_14 p_61_14 p_62_14 5.017838e-04
Rpv_61_14 p_61_14 p_61_15 5.017838e-04
Rph_61_15 p_61_15 p_62_15 5.017838e-04
Rpv_61_15 p_61_15 p_61_16 5.017838e-04
Rph_61_16 p_61_16 p_62_16 5.017838e-04
Rpv_61_16 p_61_16 p_61_17 5.017838e-04
Rph_61_17 p_61_17 p_62_17 5.017838e-04
Rpv_61_17 p_61_17 p_61_18 5.017838e-04
Rph_61_18 p_61_18 p_62_18 5.017838e-04
Rpv_61_18 p_61_18 p_61_19 5.017838e-04
Rph_61_19 p_61_19 p_62_19 5.017838e-04
Rpv_61_19 p_61_19 p_61_20 5.017838e-04
Rph_61_20 p_61_20 p_62_20 5.017838e-04
Rpv_61_20 p_61_20 p_61_21 5.017838e-04
Rph_61_21 p_61_21 p_62_21 5.017838e-04
Rpv_61_21 p_61_21 p_61_22 5.017838e-04
Rph_61_22 p_61_22 p_62_22 5.017838e-04
Rpv_61_22 p_61_22 p_61_23 5.017838e-04
Rph_61_23 p_61_23 p_62_23 5.017838e-04
Rpv_61_23 p_61_23 p_61_24 5.017838e-04
Rph_61_24 p_61_24 p_62_24 5.017838e-04
Rpv_61_24 p_61_24 p_61_25 5.017838e-04
Rph_61_25 p_61_25 p_62_25 5.017838e-04
Rpv_61_25 p_61_25 p_61_26 5.017838e-04
Rph_61_26 p_61_26 p_62_26 5.017838e-04
Rpv_61_26 p_61_26 p_61_27 5.017838e-04
Rph_61_27 p_61_27 p_62_27 5.017838e-04
Rpv_61_27 p_61_27 p_61_28 5.017838e-04
Rph_61_28 p_61_28 p_62_28 5.017838e-04
Rpv_61_28 p_61_28 p_61_29 5.017838e-04
Rph_61_29 p_61_29 p_62_29 5.017838e-04
Rpv_61_29 p_61_29 p_61_30 5.017838e-04
Rph_61_30 p_61_30 p_62_30 5.017838e-04
Rpv_61_30 p_61_30 p_61_31 5.017838e-04
Rph_61_31 p_61_31 p_62_31 5.017838e-04
Rpv_61_31 p_61_31 p_61_32 5.017838e-04
Rph_61_32 p_61_32 p_62_32 5.017838e-04
Rpv_61_32 p_61_32 p_61_33 5.017838e-04
Rph_61_33 p_61_33 p_62_33 5.017838e-04
Rpv_61_33 p_61_33 p_61_34 5.017838e-04
Rph_61_34 p_61_34 p_62_34 5.017838e-04
Rpv_61_34 p_61_34 p_61_35 5.017838e-04
Rph_61_35 p_61_35 p_62_35 5.017838e-04
Rpv_61_35 p_61_35 p_61_36 5.017838e-04
Rph_61_36 p_61_36 p_62_36 5.017838e-04
Rpv_61_36 p_61_36 p_61_37 5.017838e-04
Rph_61_37 p_61_37 p_62_37 5.017838e-04
Rpv_61_37 p_61_37 p_61_38 5.017838e-04
Rph_61_38 p_61_38 p_62_38 5.017838e-04
Rpv_61_38 p_61_38 p_61_39 5.017838e-04
Rph_61_39 p_61_39 p_62_39 5.017838e-04
Rpv_61_39 p_61_39 p_61_40 5.017838e-04
Rph_61_40 p_61_40 p_62_40 5.017838e-04
Rpv_61_40 p_61_40 p_61_41 5.017838e-04
Rph_61_41 p_61_41 p_62_41 5.017838e-04
Rpv_61_41 p_61_41 p_61_42 5.017838e-04
Rph_61_42 p_61_42 p_62_42 5.017838e-04
Rpv_61_42 p_61_42 p_61_43 5.017838e-04
Rph_61_43 p_61_43 p_62_43 5.017838e-04
Rpv_61_43 p_61_43 p_61_44 5.017838e-04
Rph_61_44 p_61_44 p_62_44 5.017838e-04
Rpv_61_44 p_61_44 p_61_45 5.017838e-04
Rph_61_45 p_61_45 p_62_45 5.017838e-04
Rpv_61_45 p_61_45 p_61_46 5.017838e-04
Rph_61_46 p_61_46 p_62_46 5.017838e-04
Rpv_61_46 p_61_46 p_61_47 5.017838e-04
Rph_61_47 p_61_47 p_62_47 5.017838e-04
Rpv_61_47 p_61_47 p_61_48 5.017838e-04
Rph_61_48 p_61_48 p_62_48 5.017838e-04
Rpv_61_48 p_61_48 p_61_49 5.017838e-04
Rph_61_49 p_61_49 p_62_49 5.017838e-04
Rpv_61_49 p_61_49 p_61_50 5.017838e-04
Rph_61_50 p_61_50 p_62_50 5.017838e-04
Rpv_61_50 p_61_50 p_61_51 5.017838e-04
Rph_61_51 p_61_51 p_62_51 5.017838e-04
Rpv_61_51 p_61_51 p_61_52 5.017838e-04
Rph_61_52 p_61_52 p_62_52 5.017838e-04
Rpv_61_52 p_61_52 p_61_53 5.017838e-04
Rph_61_53 p_61_53 p_62_53 5.017838e-04
Rpv_61_53 p_61_53 p_61_54 5.017838e-04
Rph_61_54 p_61_54 p_62_54 5.017838e-04
Rpv_61_54 p_61_54 p_61_55 5.017838e-04
Rph_61_55 p_61_55 p_62_55 5.017838e-04
Rpv_61_55 p_61_55 p_61_56 5.017838e-04
Rph_61_56 p_61_56 p_62_56 5.017838e-04
Rpv_61_56 p_61_56 p_61_57 5.017838e-04
Rph_61_57 p_61_57 p_62_57 5.017838e-04
Rpv_61_57 p_61_57 p_61_58 5.017838e-04
Rph_61_58 p_61_58 p_62_58 5.017838e-04
Rpv_61_58 p_61_58 p_61_59 5.017838e-04
Rph_61_59 p_61_59 p_62_59 5.017838e-04
Rpv_61_59 p_61_59 p_61_60 5.017838e-04
Rph_61_60 p_61_60 p_62_60 5.017838e-04
Rpv_61_60 p_61_60 p_61_61 5.017838e-04
Rph_61_61 p_61_61 p_62_61 5.017838e-04
Rpv_61_61 p_61_61 p_61_62 5.017838e-04
Rph_61_62 p_61_62 p_62_62 5.017838e-04
Rpv_61_62 p_61_62 p_61_63 5.017838e-04
Rph_61_63 p_61_63 p_62_63 5.017838e-04
Rpv_61_63 p_61_63 p_61_64 5.017838e-04
Rph_61_64 p_61_64 p_62_64 5.017838e-04
Rpv_61_64 p_61_64 p_61_65 5.017838e-04
Rph_61_65 p_61_65 p_62_65 5.017838e-04
Rpv_61_65 p_61_65 p_61_66 5.017838e-04
Rph_61_66 p_61_66 p_62_66 5.017838e-04
Rpv_61_66 p_61_66 p_61_67 5.017838e-04
Rph_61_67 p_61_67 p_62_67 5.017838e-04
Rpv_61_67 p_61_67 p_61_68 5.017838e-04
Rph_61_68 p_61_68 p_62_68 5.017838e-04
Rpv_61_68 p_61_68 p_61_69 5.017838e-04
Rph_61_69 p_61_69 p_62_69 5.017838e-04
Rpv_61_69 p_61_69 p_61_70 5.017838e-04
Rph_61_70 p_61_70 p_62_70 5.017838e-04
Rpv_61_70 p_61_70 p_61_71 5.017838e-04
Rph_61_71 p_61_71 p_62_71 5.017838e-04
Rph_62_0 p_62_0 p_63_0 5.017838e-04
Rpv_62_0 p_62_0 p_62_1 5.017838e-04
Rph_62_1 p_62_1 p_63_1 5.017838e-04
Rpv_62_1 p_62_1 p_62_2 5.017838e-04
Rph_62_2 p_62_2 p_63_2 5.017838e-04
Rpv_62_2 p_62_2 p_62_3 5.017838e-04
Rph_62_3 p_62_3 p_63_3 5.017838e-04
Rpv_62_3 p_62_3 p_62_4 5.017838e-04
Rph_62_4 p_62_4 p_63_4 5.017838e-04
Rpv_62_4 p_62_4 p_62_5 5.017838e-04
Rph_62_5 p_62_5 p_63_5 5.017838e-04
Rpv_62_5 p_62_5 p_62_6 5.017838e-04
Rph_62_6 p_62_6 p_63_6 5.017838e-04
Rpv_62_6 p_62_6 p_62_7 5.017838e-04
Rph_62_7 p_62_7 p_63_7 5.017838e-04
Rpv_62_7 p_62_7 p_62_8 5.017838e-04
Rph_62_8 p_62_8 p_63_8 5.017838e-04
Rpv_62_8 p_62_8 p_62_9 5.017838e-04
Rph_62_9 p_62_9 p_63_9 5.017838e-04
Rpv_62_9 p_62_9 p_62_10 5.017838e-04
Rph_62_10 p_62_10 p_63_10 5.017838e-04
Rpv_62_10 p_62_10 p_62_11 5.017838e-04
Rph_62_11 p_62_11 p_63_11 5.017838e-04
Rpv_62_11 p_62_11 p_62_12 5.017838e-04
Rph_62_12 p_62_12 p_63_12 5.017838e-04
Rpv_62_12 p_62_12 p_62_13 5.017838e-04
Rph_62_13 p_62_13 p_63_13 5.017838e-04
Rpv_62_13 p_62_13 p_62_14 5.017838e-04
Rph_62_14 p_62_14 p_63_14 5.017838e-04
Rpv_62_14 p_62_14 p_62_15 5.017838e-04
Rph_62_15 p_62_15 p_63_15 5.017838e-04
Rpv_62_15 p_62_15 p_62_16 5.017838e-04
Rph_62_16 p_62_16 p_63_16 5.017838e-04
Rpv_62_16 p_62_16 p_62_17 5.017838e-04
Rph_62_17 p_62_17 p_63_17 5.017838e-04
Rpv_62_17 p_62_17 p_62_18 5.017838e-04
Rph_62_18 p_62_18 p_63_18 5.017838e-04
Rpv_62_18 p_62_18 p_62_19 5.017838e-04
Rph_62_19 p_62_19 p_63_19 5.017838e-04
Rpv_62_19 p_62_19 p_62_20 5.017838e-04
Rph_62_20 p_62_20 p_63_20 5.017838e-04
Rpv_62_20 p_62_20 p_62_21 5.017838e-04
Rph_62_21 p_62_21 p_63_21 5.017838e-04
Rpv_62_21 p_62_21 p_62_22 5.017838e-04
Rph_62_22 p_62_22 p_63_22 5.017838e-04
Rpv_62_22 p_62_22 p_62_23 5.017838e-04
Rph_62_23 p_62_23 p_63_23 5.017838e-04
Rpv_62_23 p_62_23 p_62_24 5.017838e-04
Rph_62_24 p_62_24 p_63_24 5.017838e-04
Rpv_62_24 p_62_24 p_62_25 5.017838e-04
Rph_62_25 p_62_25 p_63_25 5.017838e-04
Rpv_62_25 p_62_25 p_62_26 5.017838e-04
Rph_62_26 p_62_26 p_63_26 5.017838e-04
Rpv_62_26 p_62_26 p_62_27 5.017838e-04
Rph_62_27 p_62_27 p_63_27 5.017838e-04
Rpv_62_27 p_62_27 p_62_28 5.017838e-04
Rph_62_28 p_62_28 p_63_28 5.017838e-04
Rpv_62_28 p_62_28 p_62_29 5.017838e-04
Rph_62_29 p_62_29 p_63_29 5.017838e-04
Rpv_62_29 p_62_29 p_62_30 5.017838e-04
Rph_62_30 p_62_30 p_63_30 5.017838e-04
Rpv_62_30 p_62_30 p_62_31 5.017838e-04
Rph_62_31 p_62_31 p_63_31 5.017838e-04
Rpv_62_31 p_62_31 p_62_32 5.017838e-04
Rph_62_32 p_62_32 p_63_32 5.017838e-04
Rpv_62_32 p_62_32 p_62_33 5.017838e-04
Rph_62_33 p_62_33 p_63_33 5.017838e-04
Rpv_62_33 p_62_33 p_62_34 5.017838e-04
Rph_62_34 p_62_34 p_63_34 5.017838e-04
Rpv_62_34 p_62_34 p_62_35 5.017838e-04
Rph_62_35 p_62_35 p_63_35 5.017838e-04
Rpv_62_35 p_62_35 p_62_36 5.017838e-04
Rph_62_36 p_62_36 p_63_36 5.017838e-04
Rpv_62_36 p_62_36 p_62_37 5.017838e-04
Rph_62_37 p_62_37 p_63_37 5.017838e-04
Rpv_62_37 p_62_37 p_62_38 5.017838e-04
Rph_62_38 p_62_38 p_63_38 5.017838e-04
Rpv_62_38 p_62_38 p_62_39 5.017838e-04
Rph_62_39 p_62_39 p_63_39 5.017838e-04
Rpv_62_39 p_62_39 p_62_40 5.017838e-04
Rph_62_40 p_62_40 p_63_40 5.017838e-04
Rpv_62_40 p_62_40 p_62_41 5.017838e-04
Rph_62_41 p_62_41 p_63_41 5.017838e-04
Rpv_62_41 p_62_41 p_62_42 5.017838e-04
Rph_62_42 p_62_42 p_63_42 5.017838e-04
Rpv_62_42 p_62_42 p_62_43 5.017838e-04
Rph_62_43 p_62_43 p_63_43 5.017838e-04
Rpv_62_43 p_62_43 p_62_44 5.017838e-04
Rph_62_44 p_62_44 p_63_44 5.017838e-04
Rpv_62_44 p_62_44 p_62_45 5.017838e-04
Rph_62_45 p_62_45 p_63_45 5.017838e-04
Rpv_62_45 p_62_45 p_62_46 5.017838e-04
Rph_62_46 p_62_46 p_63_46 5.017838e-04
Rpv_62_46 p_62_46 p_62_47 5.017838e-04
Rph_62_47 p_62_47 p_63_47 5.017838e-04
Rpv_62_47 p_62_47 p_62_48 5.017838e-04
Rph_62_48 p_62_48 p_63_48 5.017838e-04
Rpv_62_48 p_62_48 p_62_49 5.017838e-04
Rph_62_49 p_62_49 p_63_49 5.017838e-04
Rpv_62_49 p_62_49 p_62_50 5.017838e-04
Rph_62_50 p_62_50 p_63_50 5.017838e-04
Rpv_62_50 p_62_50 p_62_51 5.017838e-04
Rph_62_51 p_62_51 p_63_51 5.017838e-04
Rpv_62_51 p_62_51 p_62_52 5.017838e-04
Rph_62_52 p_62_52 p_63_52 5.017838e-04
Rpv_62_52 p_62_52 p_62_53 5.017838e-04
Rph_62_53 p_62_53 p_63_53 5.017838e-04
Rpv_62_53 p_62_53 p_62_54 5.017838e-04
Rph_62_54 p_62_54 p_63_54 5.017838e-04
Rpv_62_54 p_62_54 p_62_55 5.017838e-04
Rph_62_55 p_62_55 p_63_55 5.017838e-04
Rpv_62_55 p_62_55 p_62_56 5.017838e-04
Rph_62_56 p_62_56 p_63_56 5.017838e-04
Rpv_62_56 p_62_56 p_62_57 5.017838e-04
Rph_62_57 p_62_57 p_63_57 5.017838e-04
Rpv_62_57 p_62_57 p_62_58 5.017838e-04
Rph_62_58 p_62_58 p_63_58 5.017838e-04
Rpv_62_58 p_62_58 p_62_59 5.017838e-04
Rph_62_59 p_62_59 p_63_59 5.017838e-04
Rpv_62_59 p_62_59 p_62_60 5.017838e-04
Rph_62_60 p_62_60 p_63_60 5.017838e-04
Rpv_62_60 p_62_60 p_62_61 5.017838e-04
Rph_62_61 p_62_61 p_63_61 5.017838e-04
Rpv_62_61 p_62_61 p_62_62 5.017838e-04
Rph_62_62 p_62_62 p_63_62 5.017838e-04
Rpv_62_62 p_62_62 p_62_63 5.017838e-04
Rph_62_63 p_62_63 p_63_63 5.017838e-04
Rpv_62_63 p_62_63 p_62_64 5.017838e-04
Rph_62_64 p_62_64 p_63_64 5.017838e-04
Rpv_62_64 p_62_64 p_62_65 5.017838e-04
Rph_62_65 p_62_65 p_63_65 5.017838e-04
Rpv_62_65 p_62_65 p_62_66 5.017838e-04
Rph_62_66 p_62_66 p_63_66 5.017838e-04
Rpv_62_66 p_62_66 p_62_67 5.017838e-04
Rph_62_67 p_62_67 p_63_67 5.017838e-04
Rpv_62_67 p_62_67 p_62_68 5.017838e-04
Rph_62_68 p_62_68 p_63_68 5.017838e-04
Rpv_62_68 p_62_68 p_62_69 5.017838e-04
Rph_62_69 p_62_69 p_63_69 5.017838e-04
Rpv_62_69 p_62_69 p_62_70 5.017838e-04
Rph_62_70 p_62_70 p_63_70 5.017838e-04
Rpv_62_70 p_62_70 p_62_71 5.017838e-04
Rph_62_71 p_62_71 p_63_71 5.017838e-04
Rpv_63_0 p_63_0 p_63_1 5.017838e-04
Rpv_63_1 p_63_1 p_63_2 5.017838e-04
Rpv_63_2 p_63_2 p_63_3 5.017838e-04
Rpv_63_3 p_63_3 p_63_4 5.017838e-04
Rpv_63_4 p_63_4 p_63_5 5.017838e-04
Rpv_63_5 p_63_5 p_63_6 5.017838e-04
Rpv_63_6 p_63_6 p_63_7 5.017838e-04
Rpv_63_7 p_63_7 p_63_8 5.017838e-04
Rpv_63_8 p_63_8 p_63_9 5.017838e-04
Rpv_63_9 p_63_9 p_63_10 5.017838e-04
Rpv_63_10 p_63_10 p_63_11 5.017838e-04
Rpv_63_11 p_63_11 p_63_12 5.017838e-04
Rpv_63_12 p_63_12 p_63_13 5.017838e-04
Rpv_63_13 p_63_13 p_63_14 5.017838e-04
Rpv_63_14 p_63_14 p_63_15 5.017838e-04
Rpv_63_15 p_63_15 p_63_16 5.017838e-04
Rpv_63_16 p_63_16 p_63_17 5.017838e-04
Rpv_63_17 p_63_17 p_63_18 5.017838e-04
Rpv_63_18 p_63_18 p_63_19 5.017838e-04
Rpv_63_19 p_63_19 p_63_20 5.017838e-04
Rpv_63_20 p_63_20 p_63_21 5.017838e-04
Rpv_63_21 p_63_21 p_63_22 5.017838e-04
Rpv_63_22 p_63_22 p_63_23 5.017838e-04
Rpv_63_23 p_63_23 p_63_24 5.017838e-04
Rpv_63_24 p_63_24 p_63_25 5.017838e-04
Rpv_63_25 p_63_25 p_63_26 5.017838e-04
Rpv_63_26 p_63_26 p_63_27 5.017838e-04
Rpv_63_27 p_63_27 p_63_28 5.017838e-04
Rpv_63_28 p_63_28 p_63_29 5.017838e-04
Rpv_63_29 p_63_29 p_63_30 5.017838e-04
Rpv_63_30 p_63_30 p_63_31 5.017838e-04
Rpv_63_31 p_63_31 p_63_32 5.017838e-04
Rpv_63_32 p_63_32 p_63_33 5.017838e-04
Rpv_63_33 p_63_33 p_63_34 5.017838e-04
Rpv_63_34 p_63_34 p_63_35 5.017838e-04
Rpv_63_35 p_63_35 p_63_36 5.017838e-04
Rpv_63_36 p_63_36 p_63_37 5.017838e-04
Rpv_63_37 p_63_37 p_63_38 5.017838e-04
Rpv_63_38 p_63_38 p_63_39 5.017838e-04
Rpv_63_39 p_63_39 p_63_40 5.017838e-04
Rpv_63_40 p_63_40 p_63_41 5.017838e-04
Rpv_63_41 p_63_41 p_63_42 5.017838e-04
Rpv_63_42 p_63_42 p_63_43 5.017838e-04
Rpv_63_43 p_63_43 p_63_44 5.017838e-04
Rpv_63_44 p_63_44 p_63_45 5.017838e-04
Rpv_63_45 p_63_45 p_63_46 5.017838e-04
Rpv_63_46 p_63_46 p_63_47 5.017838e-04
Rpv_63_47 p_63_47 p_63_48 5.017838e-04
Rpv_63_48 p_63_48 p_63_49 5.017838e-04
Rpv_63_49 p_63_49 p_63_50 5.017838e-04
Rpv_63_50 p_63_50 p_63_51 5.017838e-04
Rpv_63_51 p_63_51 p_63_52 5.017838e-04
Rpv_63_52 p_63_52 p_63_53 5.017838e-04
Rpv_63_53 p_63_53 p_63_54 5.017838e-04
Rpv_63_54 p_63_54 p_63_55 5.017838e-04
Rpv_63_55 p_63_55 p_63_56 5.017838e-04
Rpv_63_56 p_63_56 p_63_57 5.017838e-04
Rpv_63_57 p_63_57 p_63_58 5.017838e-04
Rpv_63_58 p_63_58 p_63_59 5.017838e-04
Rpv_63_59 p_63_59 p_63_60 5.017838e-04
Rpv_63_60 p_63_60 p_63_61 5.017838e-04
Rpv_63_61 p_63_61 p_63_62 5.017838e-04
Rpv_63_62 p_63_62 p_63_63 5.017838e-04
Rpv_63_63 p_63_63 p_63_64 5.017838e-04
Rpv_63_64 p_63_64 p_63_65 5.017838e-04
Rpv_63_65 p_63_65 p_63_66 5.017838e-04
Rpv_63_66 p_63_66 p_63_67 5.017838e-04
Rpv_63_67 p_63_67 p_63_68 5.017838e-04
Rpv_63_68 p_63_68 p_63_69 5.017838e-04
Rpv_63_69 p_63_69 p_63_70 5.017838e-04
Rpv_63_70 p_63_70 p_63_71 5.017838e-04
Rgh_0_0 g_0_0 g_1_0 4.993426e-04
Rgv_0_0 g_0_0 g_0_1 4.993426e-04
Rgh_0_1 g_0_1 g_1_1 4.993426e-04
Rgv_0_1 g_0_1 g_0_2 4.993426e-04
Rgh_0_2 g_0_2 g_1_2 4.993426e-04
Rgv_0_2 g_0_2 g_0_3 4.993426e-04
Rgh_0_3 g_0_3 g_1_3 4.993426e-04
Rgv_0_3 g_0_3 g_0_4 4.993426e-04
Rgh_0_4 g_0_4 g_1_4 4.993426e-04
Rgv_0_4 g_0_4 g_0_5 4.993426e-04
Rgh_0_5 g_0_5 g_1_5 4.993426e-04
Rgv_0_5 g_0_5 g_0_6 4.993426e-04
Rgh_0_6 g_0_6 g_1_6 4.993426e-04
Rgv_0_6 g_0_6 g_0_7 4.993426e-04
Rgh_0_7 g_0_7 g_1_7 4.993426e-04
Rgv_0_7 g_0_7 g_0_8 4.993426e-04
Rgh_0_8 g_0_8 g_1_8 4.993426e-04
Rgv_0_8 g_0_8 g_0_9 4.993426e-04
Rgh_0_9 g_0_9 g_1_9 4.993426e-04
Rgv_0_9 g_0_9 g_0_10 4.993426e-04
Rgh_0_10 g_0_10 g_1_10 4.993426e-04
Rgv_0_10 g_0_10 g_0_11 4.993426e-04
Rgh_0_11 g_0_11 g_1_11 4.993426e-04
Rgv_0_11 g_0_11 g_0_12 4.993426e-04
Rgh_0_12 g_0_12 g_1_12 4.993426e-04
Rgv_0_12 g_0_12 g_0_13 4.993426e-04
Rgh_0_13 g_0_13 g_1_13 4.993426e-04
Rgv_0_13 g_0_13 g_0_14 4.993426e-04
Rgh_0_14 g_0_14 g_1_14 4.993426e-04
Rgv_0_14 g_0_14 g_0_15 4.993426e-04
Rgh_0_15 g_0_15 g_1_15 4.993426e-04
Rgv_0_15 g_0_15 g_0_16 4.993426e-04
Rgh_0_16 g_0_16 g_1_16 4.993426e-04
Rgv_0_16 g_0_16 g_0_17 4.993426e-04
Rgh_0_17 g_0_17 g_1_17 4.993426e-04
Rgv_0_17 g_0_17 g_0_18 4.993426e-04
Rgh_0_18 g_0_18 g_1_18 4.993426e-04
Rgv_0_18 g_0_18 g_0_19 4.993426e-04
Rgh_0_19 g_0_19 g_1_19 4.993426e-04
Rgv_0_19 g_0_19 g_0_20 4.993426e-04
Rgh_0_20 g_0_20 g_1_20 4.993426e-04
Rgv_0_20 g_0_20 g_0_21 4.993426e-04
Rgh_0_21 g_0_21 g_1_21 4.993426e-04
Rgv_0_21 g_0_21 g_0_22 4.993426e-04
Rgh_0_22 g_0_22 g_1_22 4.993426e-04
Rgv_0_22 g_0_22 g_0_23 4.993426e-04
Rgh_0_23 g_0_23 g_1_23 4.993426e-04
Rgv_0_23 g_0_23 g_0_24 4.993426e-04
Rgh_0_24 g_0_24 g_1_24 4.993426e-04
Rgv_0_24 g_0_24 g_0_25 4.993426e-04
Rgh_0_25 g_0_25 g_1_25 4.993426e-04
Rgv_0_25 g_0_25 g_0_26 4.993426e-04
Rgh_0_26 g_0_26 g_1_26 4.993426e-04
Rgv_0_26 g_0_26 g_0_27 4.993426e-04
Rgh_0_27 g_0_27 g_1_27 4.993426e-04
Rgv_0_27 g_0_27 g_0_28 4.993426e-04
Rgh_0_28 g_0_28 g_1_28 4.993426e-04
Rgv_0_28 g_0_28 g_0_29 4.993426e-04
Rgh_0_29 g_0_29 g_1_29 4.993426e-04
Rgv_0_29 g_0_29 g_0_30 4.993426e-04
Rgh_0_30 g_0_30 g_1_30 4.993426e-04
Rgv_0_30 g_0_30 g_0_31 4.993426e-04
Rgh_0_31 g_0_31 g_1_31 4.993426e-04
Rgv_0_31 g_0_31 g_0_32 4.993426e-04
Rgh_0_32 g_0_32 g_1_32 4.993426e-04
Rgv_0_32 g_0_32 g_0_33 4.993426e-04
Rgh_0_33 g_0_33 g_1_33 4.993426e-04
Rgv_0_33 g_0_33 g_0_34 4.993426e-04
Rgh_0_34 g_0_34 g_1_34 4.993426e-04
Rgv_0_34 g_0_34 g_0_35 4.993426e-04
Rgh_0_35 g_0_35 g_1_35 4.993426e-04
Rgv_0_35 g_0_35 g_0_36 4.993426e-04
Rgh_0_36 g_0_36 g_1_36 4.993426e-04
Rgv_0_36 g_0_36 g_0_37 4.993426e-04
Rgh_0_37 g_0_37 g_1_37 4.993426e-04
Rgv_0_37 g_0_37 g_0_38 4.993426e-04
Rgh_0_38 g_0_38 g_1_38 4.993426e-04
Rgv_0_38 g_0_38 g_0_39 4.993426e-04
Rgh_0_39 g_0_39 g_1_39 4.993426e-04
Rgv_0_39 g_0_39 g_0_40 4.993426e-04
Rgh_0_40 g_0_40 g_1_40 4.993426e-04
Rgv_0_40 g_0_40 g_0_41 4.993426e-04
Rgh_0_41 g_0_41 g_1_41 4.993426e-04
Rgv_0_41 g_0_41 g_0_42 4.993426e-04
Rgh_0_42 g_0_42 g_1_42 4.993426e-04
Rgv_0_42 g_0_42 g_0_43 4.993426e-04
Rgh_0_43 g_0_43 g_1_43 4.993426e-04
Rgv_0_43 g_0_43 g_0_44 4.993426e-04
Rgh_0_44 g_0_44 g_1_44 4.993426e-04
Rgv_0_44 g_0_44 g_0_45 4.993426e-04
Rgh_0_45 g_0_45 g_1_45 4.993426e-04
Rgv_0_45 g_0_45 g_0_46 4.993426e-04
Rgh_0_46 g_0_46 g_1_46 4.993426e-04
Rgv_0_46 g_0_46 g_0_47 4.993426e-04
Rgh_0_47 g_0_47 g_1_47 4.993426e-04
Rgv_0_47 g_0_47 g_0_48 4.993426e-04
Rgh_0_48 g_0_48 g_1_48 4.993426e-04
Rgv_0_48 g_0_48 g_0_49 4.993426e-04
Rgh_0_49 g_0_49 g_1_49 4.993426e-04
Rgv_0_49 g_0_49 g_0_50 4.993426e-04
Rgh_0_50 g_0_50 g_1_50 4.993426e-04
Rgv_0_50 g_0_50 g_0_51 4.993426e-04
Rgh_0_51 g_0_51 g_1_51 4.993426e-04
Rgv_0_51 g_0_51 g_0_52 4.993426e-04
Rgh_0_52 g_0_52 g_1_52 4.993426e-04
Rgv_0_52 g_0_52 g_0_53 4.993426e-04
Rgh_0_53 g_0_53 g_1_53 4.993426e-04
Rgv_0_53 g_0_53 g_0_54 4.993426e-04
Rgh_0_54 g_0_54 g_1_54 4.993426e-04
Rgv_0_54 g_0_54 g_0_55 4.993426e-04
Rgh_0_55 g_0_55 g_1_55 4.993426e-04
Rgv_0_55 g_0_55 g_0_56 4.993426e-04
Rgh_0_56 g_0_56 g_1_56 4.993426e-04
Rgv_0_56 g_0_56 g_0_57 4.993426e-04
Rgh_0_57 g_0_57 g_1_57 4.993426e-04
Rgv_0_57 g_0_57 g_0_58 4.993426e-04
Rgh_0_58 g_0_58 g_1_58 4.993426e-04
Rgv_0_58 g_0_58 g_0_59 4.993426e-04
Rgh_0_59 g_0_59 g_1_59 4.993426e-04
Rgv_0_59 g_0_59 g_0_60 4.993426e-04
Rgh_0_60 g_0_60 g_1_60 4.993426e-04
Rgv_0_60 g_0_60 g_0_61 4.993426e-04
Rgh_0_61 g_0_61 g_1_61 4.993426e-04
Rgv_0_61 g_0_61 g_0_62 4.993426e-04
Rgh_0_62 g_0_62 g_1_62 4.993426e-04
Rgv_0_62 g_0_62 g_0_63 4.993426e-04
Rgh_0_63 g_0_63 g_1_63 4.993426e-04
Rgv_0_63 g_0_63 g_0_64 4.993426e-04
Rgh_0_64 g_0_64 g_1_64 4.993426e-04
Rgv_0_64 g_0_64 g_0_65 4.993426e-04
Rgh_0_65 g_0_65 g_1_65 4.993426e-04
Rgv_0_65 g_0_65 g_0_66 4.993426e-04
Rgh_0_66 g_0_66 g_1_66 4.993426e-04
Rgv_0_66 g_0_66 g_0_67 4.993426e-04
Rgh_0_67 g_0_67 g_1_67 4.993426e-04
Rgv_0_67 g_0_67 g_0_68 4.993426e-04
Rgh_0_68 g_0_68 g_1_68 4.993426e-04
Rgv_0_68 g_0_68 g_0_69 4.993426e-04
Rgh_0_69 g_0_69 g_1_69 4.993426e-04
Rgv_0_69 g_0_69 g_0_70 4.993426e-04
Rgh_0_70 g_0_70 g_1_70 4.993426e-04
Rgv_0_70 g_0_70 g_0_71 4.993426e-04
Rgh_0_71 g_0_71 g_1_71 4.993426e-04
Rgh_1_0 g_1_0 g_2_0 4.993426e-04
Rgv_1_0 g_1_0 g_1_1 4.993426e-04
Rgh_1_1 g_1_1 g_2_1 4.993426e-04
Rgv_1_1 g_1_1 g_1_2 4.993426e-04
Rgh_1_2 g_1_2 g_2_2 4.993426e-04
Rgv_1_2 g_1_2 g_1_3 4.993426e-04
Rgh_1_3 g_1_3 g_2_3 4.993426e-04
Rgv_1_3 g_1_3 g_1_4 4.993426e-04
Rgh_1_4 g_1_4 g_2_4 4.993426e-04
Rgv_1_4 g_1_4 g_1_5 4.993426e-04
Rgh_1_5 g_1_5 g_2_5 4.993426e-04
Rgv_1_5 g_1_5 g_1_6 4.993426e-04
Rgh_1_6 g_1_6 g_2_6 4.993426e-04
Rgv_1_6 g_1_6 g_1_7 4.993426e-04
Rgh_1_7 g_1_7 g_2_7 4.993426e-04
Rgv_1_7 g_1_7 g_1_8 4.993426e-04
Rgh_1_8 g_1_8 g_2_8 4.993426e-04
Rgv_1_8 g_1_8 g_1_9 4.993426e-04
Rgh_1_9 g_1_9 g_2_9 4.993426e-04
Rgv_1_9 g_1_9 g_1_10 4.993426e-04
Rgh_1_10 g_1_10 g_2_10 4.993426e-04
Rgv_1_10 g_1_10 g_1_11 4.993426e-04
Rgh_1_11 g_1_11 g_2_11 4.993426e-04
Rgv_1_11 g_1_11 g_1_12 4.993426e-04
Rgh_1_12 g_1_12 g_2_12 4.993426e-04
Rgv_1_12 g_1_12 g_1_13 4.993426e-04
Rgh_1_13 g_1_13 g_2_13 4.993426e-04
Rgv_1_13 g_1_13 g_1_14 4.993426e-04
Rgh_1_14 g_1_14 g_2_14 4.993426e-04
Rgv_1_14 g_1_14 g_1_15 4.993426e-04
Rgh_1_15 g_1_15 g_2_15 4.993426e-04
Rgv_1_15 g_1_15 g_1_16 4.993426e-04
Rgh_1_16 g_1_16 g_2_16 4.993426e-04
Rgv_1_16 g_1_16 g_1_17 4.993426e-04
Rgh_1_17 g_1_17 g_2_17 4.993426e-04
Rgv_1_17 g_1_17 g_1_18 4.993426e-04
Rgh_1_18 g_1_18 g_2_18 4.993426e-04
Rgv_1_18 g_1_18 g_1_19 4.993426e-04
Rgh_1_19 g_1_19 g_2_19 4.993426e-04
Rgv_1_19 g_1_19 g_1_20 4.993426e-04
Rgh_1_20 g_1_20 g_2_20 4.993426e-04
Rgv_1_20 g_1_20 g_1_21 4.993426e-04
Rgh_1_21 g_1_21 g_2_21 4.993426e-04
Rgv_1_21 g_1_21 g_1_22 4.993426e-04
Rgh_1_22 g_1_22 g_2_22 4.993426e-04
Rgv_1_22 g_1_22 g_1_23 4.993426e-04
Rgh_1_23 g_1_23 g_2_23 4.993426e-04
Rgv_1_23 g_1_23 g_1_24 4.993426e-04
Rgh_1_24 g_1_24 g_2_24 4.993426e-04
Rgv_1_24 g_1_24 g_1_25 4.993426e-04
Rgh_1_25 g_1_25 g_2_25 4.993426e-04
Rgv_1_25 g_1_25 g_1_26 4.993426e-04
Rgh_1_26 g_1_26 g_2_26 4.993426e-04
Rgv_1_26 g_1_26 g_1_27 4.993426e-04
Rgh_1_27 g_1_27 g_2_27 4.993426e-04
Rgv_1_27 g_1_27 g_1_28 4.993426e-04
Rgh_1_28 g_1_28 g_2_28 4.993426e-04
Rgv_1_28 g_1_28 g_1_29 4.993426e-04
Rgh_1_29 g_1_29 g_2_29 4.993426e-04
Rgv_1_29 g_1_29 g_1_30 4.993426e-04
Rgh_1_30 g_1_30 g_2_30 4.993426e-04
Rgv_1_30 g_1_30 g_1_31 4.993426e-04
Rgh_1_31 g_1_31 g_2_31 4.993426e-04
Rgv_1_31 g_1_31 g_1_32 4.993426e-04
Rgh_1_32 g_1_32 g_2_32 4.993426e-04
Rgv_1_32 g_1_32 g_1_33 4.993426e-04
Rgh_1_33 g_1_33 g_2_33 4.993426e-04
Rgv_1_33 g_1_33 g_1_34 4.993426e-04
Rgh_1_34 g_1_34 g_2_34 4.993426e-04
Rgv_1_34 g_1_34 g_1_35 4.993426e-04
Rgh_1_35 g_1_35 g_2_35 4.993426e-04
Rgv_1_35 g_1_35 g_1_36 4.993426e-04
Rgh_1_36 g_1_36 g_2_36 4.993426e-04
Rgv_1_36 g_1_36 g_1_37 4.993426e-04
Rgh_1_37 g_1_37 g_2_37 4.993426e-04
Rgv_1_37 g_1_37 g_1_38 4.993426e-04
Rgh_1_38 g_1_38 g_2_38 4.993426e-04
Rgv_1_38 g_1_38 g_1_39 4.993426e-04
Rgh_1_39 g_1_39 g_2_39 4.993426e-04
Rgv_1_39 g_1_39 g_1_40 4.993426e-04
Rgh_1_40 g_1_40 g_2_40 4.993426e-04
Rgv_1_40 g_1_40 g_1_41 4.993426e-04
Rgh_1_41 g_1_41 g_2_41 4.993426e-04
Rgv_1_41 g_1_41 g_1_42 4.993426e-04
Rgh_1_42 g_1_42 g_2_42 4.993426e-04
Rgv_1_42 g_1_42 g_1_43 4.993426e-04
Rgh_1_43 g_1_43 g_2_43 4.993426e-04
Rgv_1_43 g_1_43 g_1_44 4.993426e-04
Rgh_1_44 g_1_44 g_2_44 4.993426e-04
Rgv_1_44 g_1_44 g_1_45 4.993426e-04
Rgh_1_45 g_1_45 g_2_45 4.993426e-04
Rgv_1_45 g_1_45 g_1_46 4.993426e-04
Rgh_1_46 g_1_46 g_2_46 4.993426e-04
Rgv_1_46 g_1_46 g_1_47 4.993426e-04
Rgh_1_47 g_1_47 g_2_47 4.993426e-04
Rgv_1_47 g_1_47 g_1_48 4.993426e-04
Rgh_1_48 g_1_48 g_2_48 4.993426e-04
Rgv_1_48 g_1_48 g_1_49 4.993426e-04
Rgh_1_49 g_1_49 g_2_49 4.993426e-04
Rgv_1_49 g_1_49 g_1_50 4.993426e-04
Rgh_1_50 g_1_50 g_2_50 4.993426e-04
Rgv_1_50 g_1_50 g_1_51 4.993426e-04
Rgh_1_51 g_1_51 g_2_51 4.993426e-04
Rgv_1_51 g_1_51 g_1_52 4.993426e-04
Rgh_1_52 g_1_52 g_2_52 4.993426e-04
Rgv_1_52 g_1_52 g_1_53 4.993426e-04
Rgh_1_53 g_1_53 g_2_53 4.993426e-04
Rgv_1_53 g_1_53 g_1_54 4.993426e-04
Rgh_1_54 g_1_54 g_2_54 4.993426e-04
Rgv_1_54 g_1_54 g_1_55 4.993426e-04
Rgh_1_55 g_1_55 g_2_55 4.993426e-04
Rgv_1_55 g_1_55 g_1_56 4.993426e-04
Rgh_1_56 g_1_56 g_2_56 4.993426e-04
Rgv_1_56 g_1_56 g_1_57 4.993426e-04
Rgh_1_57 g_1_57 g_2_57 4.993426e-04
Rgv_1_57 g_1_57 g_1_58 4.993426e-04
Rgh_1_58 g_1_58 g_2_58 4.993426e-04
Rgv_1_58 g_1_58 g_1_59 4.993426e-04
Rgh_1_59 g_1_59 g_2_59 4.993426e-04
Rgv_1_59 g_1_59 g_1_60 4.993426e-04
Rgh_1_60 g_1_60 g_2_60 4.993426e-04
Rgv_1_60 g_1_60 g_1_61 4.993426e-04
Rgh_1_61 g_1_61 g_2_61 4.993426e-04
Rgv_1_61 g_1_61 g_1_62 4.993426e-04
Rgh_1_62 g_1_62 g_2_62 4.993426e-04
Rgv_1_62 g_1_62 g_1_63 4.993426e-04
Rgh_1_63 g_1_63 g_2_63 4.993426e-04
Rgv_1_63 g_1_63 g_1_64 4.993426e-04
Rgh_1_64 g_1_64 g_2_64 4.993426e-04
Rgv_1_64 g_1_64 g_1_65 4.993426e-04
Rgh_1_65 g_1_65 g_2_65 4.993426e-04
Rgv_1_65 g_1_65 g_1_66 4.993426e-04
Rgh_1_66 g_1_66 g_2_66 4.993426e-04
Rgv_1_66 g_1_66 g_1_67 4.993426e-04
Rgh_1_67 g_1_67 g_2_67 4.993426e-04
Rgv_1_67 g_1_67 g_1_68 4.993426e-04
Rgh_1_68 g_1_68 g_2_68 4.993426e-04
Rgv_1_68 g_1_68 g_1_69 4.993426e-04
Rgh_1_69 g_1_69 g_2_69 4.993426e-04
Rgv_1_69 g_1_69 g_1_70 4.993426e-04
Rgh_1_70 g_1_70 g_2_70 4.993426e-04
Rgv_1_70 g_1_70 g_1_71 4.993426e-04
Rgh_1_71 g_1_71 g_2_71 4.993426e-04
Rgh_2_0 g_2_0 g_3_0 4.993426e-04
Rgv_2_0 g_2_0 g_2_1 4.993426e-04
Rgh_2_1 g_2_1 g_3_1 4.993426e-04
Rgv_2_1 g_2_1 g_2_2 4.993426e-04
Rgh_2_2 g_2_2 g_3_2 4.993426e-04
Rgv_2_2 g_2_2 g_2_3 4.993426e-04
Rgh_2_3 g_2_3 g_3_3 4.993426e-04
Rgv_2_3 g_2_3 g_2_4 4.993426e-04
Rgh_2_4 g_2_4 g_3_4 4.993426e-04
Rgv_2_4 g_2_4 g_2_5 4.993426e-04
Rgh_2_5 g_2_5 g_3_5 4.993426e-04
Rgv_2_5 g_2_5 g_2_6 4.993426e-04
Rgh_2_6 g_2_6 g_3_6 4.993426e-04
Rgv_2_6 g_2_6 g_2_7 4.993426e-04
Rgh_2_7 g_2_7 g_3_7 4.993426e-04
Rgv_2_7 g_2_7 g_2_8 4.993426e-04
Rgh_2_8 g_2_8 g_3_8 4.993426e-04
Rgv_2_8 g_2_8 g_2_9 4.993426e-04
Rgh_2_9 g_2_9 g_3_9 4.993426e-04
Rgv_2_9 g_2_9 g_2_10 4.993426e-04
Rgh_2_10 g_2_10 g_3_10 4.993426e-04
Rgv_2_10 g_2_10 g_2_11 4.993426e-04
Rgh_2_11 g_2_11 g_3_11 4.993426e-04
Rgv_2_11 g_2_11 g_2_12 4.993426e-04
Rgh_2_12 g_2_12 g_3_12 4.993426e-04
Rgv_2_12 g_2_12 g_2_13 4.993426e-04
Rgh_2_13 g_2_13 g_3_13 4.993426e-04
Rgv_2_13 g_2_13 g_2_14 4.993426e-04
Rgh_2_14 g_2_14 g_3_14 4.993426e-04
Rgv_2_14 g_2_14 g_2_15 4.993426e-04
Rgh_2_15 g_2_15 g_3_15 4.993426e-04
Rgv_2_15 g_2_15 g_2_16 4.993426e-04
Rgh_2_16 g_2_16 g_3_16 4.993426e-04
Rgv_2_16 g_2_16 g_2_17 4.993426e-04
Rgh_2_17 g_2_17 g_3_17 4.993426e-04
Rgv_2_17 g_2_17 g_2_18 4.993426e-04
Rgh_2_18 g_2_18 g_3_18 4.993426e-04
Rgv_2_18 g_2_18 g_2_19 4.993426e-04
Rgh_2_19 g_2_19 g_3_19 4.993426e-04
Rgv_2_19 g_2_19 g_2_20 4.993426e-04
Rgh_2_20 g_2_20 g_3_20 4.993426e-04
Rgv_2_20 g_2_20 g_2_21 4.993426e-04
Rgh_2_21 g_2_21 g_3_21 4.993426e-04
Rgv_2_21 g_2_21 g_2_22 4.993426e-04
Rgh_2_22 g_2_22 g_3_22 4.993426e-04
Rgv_2_22 g_2_22 g_2_23 4.993426e-04
Rgh_2_23 g_2_23 g_3_23 4.993426e-04
Rgv_2_23 g_2_23 g_2_24 4.993426e-04
Rgh_2_24 g_2_24 g_3_24 4.993426e-04
Rgv_2_24 g_2_24 g_2_25 4.993426e-04
Rgh_2_25 g_2_25 g_3_25 4.993426e-04
Rgv_2_25 g_2_25 g_2_26 4.993426e-04
Rgh_2_26 g_2_26 g_3_26 4.993426e-04
Rgv_2_26 g_2_26 g_2_27 4.993426e-04
Rgh_2_27 g_2_27 g_3_27 4.993426e-04
Rgv_2_27 g_2_27 g_2_28 4.993426e-04
Rgh_2_28 g_2_28 g_3_28 4.993426e-04
Rgv_2_28 g_2_28 g_2_29 4.993426e-04
Rgh_2_29 g_2_29 g_3_29 4.993426e-04
Rgv_2_29 g_2_29 g_2_30 4.993426e-04
Rgh_2_30 g_2_30 g_3_30 4.993426e-04
Rgv_2_30 g_2_30 g_2_31 4.993426e-04
Rgh_2_31 g_2_31 g_3_31 4.993426e-04
Rgv_2_31 g_2_31 g_2_32 4.993426e-04
Rgh_2_32 g_2_32 g_3_32 4.993426e-04
Rgv_2_32 g_2_32 g_2_33 4.993426e-04
Rgh_2_33 g_2_33 g_3_33 4.993426e-04
Rgv_2_33 g_2_33 g_2_34 4.993426e-04
Rgh_2_34 g_2_34 g_3_34 4.993426e-04
Rgv_2_34 g_2_34 g_2_35 4.993426e-04
Rgh_2_35 g_2_35 g_3_35 4.993426e-04
Rgv_2_35 g_2_35 g_2_36 4.993426e-04
Rgh_2_36 g_2_36 g_3_36 4.993426e-04
Rgv_2_36 g_2_36 g_2_37 4.993426e-04
Rgh_2_37 g_2_37 g_3_37 4.993426e-04
Rgv_2_37 g_2_37 g_2_38 4.993426e-04
Rgh_2_38 g_2_38 g_3_38 4.993426e-04
Rgv_2_38 g_2_38 g_2_39 4.993426e-04
Rgh_2_39 g_2_39 g_3_39 4.993426e-04
Rgv_2_39 g_2_39 g_2_40 4.993426e-04
Rgh_2_40 g_2_40 g_3_40 4.993426e-04
Rgv_2_40 g_2_40 g_2_41 4.993426e-04
Rgh_2_41 g_2_41 g_3_41 4.993426e-04
Rgv_2_41 g_2_41 g_2_42 4.993426e-04
Rgh_2_42 g_2_42 g_3_42 4.993426e-04
Rgv_2_42 g_2_42 g_2_43 4.993426e-04
Rgh_2_43 g_2_43 g_3_43 4.993426e-04
Rgv_2_43 g_2_43 g_2_44 4.993426e-04
Rgh_2_44 g_2_44 g_3_44 4.993426e-04
Rgv_2_44 g_2_44 g_2_45 4.993426e-04
Rgh_2_45 g_2_45 g_3_45 4.993426e-04
Rgv_2_45 g_2_45 g_2_46 4.993426e-04
Rgh_2_46 g_2_46 g_3_46 4.993426e-04
Rgv_2_46 g_2_46 g_2_47 4.993426e-04
Rgh_2_47 g_2_47 g_3_47 4.993426e-04
Rgv_2_47 g_2_47 g_2_48 4.993426e-04
Rgh_2_48 g_2_48 g_3_48 4.993426e-04
Rgv_2_48 g_2_48 g_2_49 4.993426e-04
Rgh_2_49 g_2_49 g_3_49 4.993426e-04
Rgv_2_49 g_2_49 g_2_50 4.993426e-04
Rgh_2_50 g_2_50 g_3_50 4.993426e-04
Rgv_2_50 g_2_50 g_2_51 4.993426e-04
Rgh_2_51 g_2_51 g_3_51 4.993426e-04
Rgv_2_51 g_2_51 g_2_52 4.993426e-04
Rgh_2_52 g_2_52 g_3_52 4.993426e-04
Rgv_2_52 g_2_52 g_2_53 4.993426e-04
Rgh_2_53 g_2_53 g_3_53 4.993426e-04
Rgv_2_53 g_2_53 g_2_54 4.993426e-04
Rgh_2_54 g_2_54 g_3_54 4.993426e-04
Rgv_2_54 g_2_54 g_2_55 4.993426e-04
Rgh_2_55 g_2_55 g_3_55 4.993426e-04
Rgv_2_55 g_2_55 g_2_56 4.993426e-04
Rgh_2_56 g_2_56 g_3_56 4.993426e-04
Rgv_2_56 g_2_56 g_2_57 4.993426e-04
Rgh_2_57 g_2_57 g_3_57 4.993426e-04
Rgv_2_57 g_2_57 g_2_58 4.993426e-04
Rgh_2_58 g_2_58 g_3_58 4.993426e-04
Rgv_2_58 g_2_58 g_2_59 4.993426e-04
Rgh_2_59 g_2_59 g_3_59 4.993426e-04
Rgv_2_59 g_2_59 g_2_60 4.993426e-04
Rgh_2_60 g_2_60 g_3_60 4.993426e-04
Rgv_2_60 g_2_60 g_2_61 4.993426e-04
Rgh_2_61 g_2_61 g_3_61 4.993426e-04
Rgv_2_61 g_2_61 g_2_62 4.993426e-04
Rgh_2_62 g_2_62 g_3_62 4.993426e-04
Rgv_2_62 g_2_62 g_2_63 4.993426e-04
Rgh_2_63 g_2_63 g_3_63 4.993426e-04
Rgv_2_63 g_2_63 g_2_64 4.993426e-04
Rgh_2_64 g_2_64 g_3_64 4.993426e-04
Rgv_2_64 g_2_64 g_2_65 4.993426e-04
Rgh_2_65 g_2_65 g_3_65 4.993426e-04
Rgv_2_65 g_2_65 g_2_66 4.993426e-04
Rgh_2_66 g_2_66 g_3_66 4.993426e-04
Rgv_2_66 g_2_66 g_2_67 4.993426e-04
Rgh_2_67 g_2_67 g_3_67 4.993426e-04
Rgv_2_67 g_2_67 g_2_68 4.993426e-04
Rgh_2_68 g_2_68 g_3_68 4.993426e-04
Rgv_2_68 g_2_68 g_2_69 4.993426e-04
Rgh_2_69 g_2_69 g_3_69 4.993426e-04
Rgv_2_69 g_2_69 g_2_70 4.993426e-04
Rgh_2_70 g_2_70 g_3_70 4.993426e-04
Rgv_2_70 g_2_70 g_2_71 4.993426e-04
Rgh_2_71 g_2_71 g_3_71 4.993426e-04
Rgh_3_0 g_3_0 g_4_0 4.993426e-04
Rgv_3_0 g_3_0 g_3_1 4.993426e-04
Rgh_3_1 g_3_1 g_4_1 4.993426e-04
Rgv_3_1 g_3_1 g_3_2 4.993426e-04
Rgh_3_2 g_3_2 g_4_2 4.993426e-04
Rgv_3_2 g_3_2 g_3_3 4.993426e-04
Rgh_3_3 g_3_3 g_4_3 4.993426e-04
Rgv_3_3 g_3_3 g_3_4 4.993426e-04
Rgh_3_4 g_3_4 g_4_4 4.993426e-04
Rgv_3_4 g_3_4 g_3_5 4.993426e-04
Rgh_3_5 g_3_5 g_4_5 4.993426e-04
Rgv_3_5 g_3_5 g_3_6 4.993426e-04
Rgh_3_6 g_3_6 g_4_6 4.993426e-04
Rgv_3_6 g_3_6 g_3_7 4.993426e-04
Rgh_3_7 g_3_7 g_4_7 4.993426e-04
Rgv_3_7 g_3_7 g_3_8 4.993426e-04
Rgh_3_8 g_3_8 g_4_8 4.993426e-04
Rgv_3_8 g_3_8 g_3_9 4.993426e-04
Rgh_3_9 g_3_9 g_4_9 4.993426e-04
Rgv_3_9 g_3_9 g_3_10 4.993426e-04
Rgh_3_10 g_3_10 g_4_10 4.993426e-04
Rgv_3_10 g_3_10 g_3_11 4.993426e-04
Rgh_3_11 g_3_11 g_4_11 4.993426e-04
Rgv_3_11 g_3_11 g_3_12 4.993426e-04
Rgh_3_12 g_3_12 g_4_12 4.993426e-04
Rgv_3_12 g_3_12 g_3_13 4.993426e-04
Rgh_3_13 g_3_13 g_4_13 4.993426e-04
Rgv_3_13 g_3_13 g_3_14 4.993426e-04
Rgh_3_14 g_3_14 g_4_14 4.993426e-04
Rgv_3_14 g_3_14 g_3_15 4.993426e-04
Rgh_3_15 g_3_15 g_4_15 4.993426e-04
Rgv_3_15 g_3_15 g_3_16 4.993426e-04
Rgh_3_16 g_3_16 g_4_16 4.993426e-04
Rgv_3_16 g_3_16 g_3_17 4.993426e-04
Rgh_3_17 g_3_17 g_4_17 4.993426e-04
Rgv_3_17 g_3_17 g_3_18 4.993426e-04
Rgh_3_18 g_3_18 g_4_18 4.993426e-04
Rgv_3_18 g_3_18 g_3_19 4.993426e-04
Rgh_3_19 g_3_19 g_4_19 4.993426e-04
Rgv_3_19 g_3_19 g_3_20 4.993426e-04
Rgh_3_20 g_3_20 g_4_20 4.993426e-04
Rgv_3_20 g_3_20 g_3_21 4.993426e-04
Rgh_3_21 g_3_21 g_4_21 4.993426e-04
Rgv_3_21 g_3_21 g_3_22 4.993426e-04
Rgh_3_22 g_3_22 g_4_22 4.993426e-04
Rgv_3_22 g_3_22 g_3_23 4.993426e-04
Rgh_3_23 g_3_23 g_4_23 4.993426e-04
Rgv_3_23 g_3_23 g_3_24 4.993426e-04
Rgh_3_24 g_3_24 g_4_24 4.993426e-04
Rgv_3_24 g_3_24 g_3_25 4.993426e-04
Rgh_3_25 g_3_25 g_4_25 4.993426e-04
Rgv_3_25 g_3_25 g_3_26 4.993426e-04
Rgh_3_26 g_3_26 g_4_26 4.993426e-04
Rgv_3_26 g_3_26 g_3_27 4.993426e-04
Rgh_3_27 g_3_27 g_4_27 4.993426e-04
Rgv_3_27 g_3_27 g_3_28 4.993426e-04
Rgh_3_28 g_3_28 g_4_28 4.993426e-04
Rgv_3_28 g_3_28 g_3_29 4.993426e-04
Rgh_3_29 g_3_29 g_4_29 4.993426e-04
Rgv_3_29 g_3_29 g_3_30 4.993426e-04
Rgh_3_30 g_3_30 g_4_30 4.993426e-04
Rgv_3_30 g_3_30 g_3_31 4.993426e-04
Rgh_3_31 g_3_31 g_4_31 4.993426e-04
Rgv_3_31 g_3_31 g_3_32 4.993426e-04
Rgh_3_32 g_3_32 g_4_32 4.993426e-04
Rgv_3_32 g_3_32 g_3_33 4.993426e-04
Rgh_3_33 g_3_33 g_4_33 4.993426e-04
Rgv_3_33 g_3_33 g_3_34 4.993426e-04
Rgh_3_34 g_3_34 g_4_34 4.993426e-04
Rgv_3_34 g_3_34 g_3_35 4.993426e-04
Rgh_3_35 g_3_35 g_4_35 4.993426e-04
Rgv_3_35 g_3_35 g_3_36 4.993426e-04
Rgh_3_36 g_3_36 g_4_36 4.993426e-04
Rgv_3_36 g_3_36 g_3_37 4.993426e-04
Rgh_3_37 g_3_37 g_4_37 4.993426e-04
Rgv_3_37 g_3_37 g_3_38 4.993426e-04
Rgh_3_38 g_3_38 g_4_38 4.993426e-04
Rgv_3_38 g_3_38 g_3_39 4.993426e-04
Rgh_3_39 g_3_39 g_4_39 4.993426e-04
Rgv_3_39 g_3_39 g_3_40 4.993426e-04
Rgh_3_40 g_3_40 g_4_40 4.993426e-04
Rgv_3_40 g_3_40 g_3_41 4.993426e-04
Rgh_3_41 g_3_41 g_4_41 4.993426e-04
Rgv_3_41 g_3_41 g_3_42 4.993426e-04
Rgh_3_42 g_3_42 g_4_42 4.993426e-04
Rgv_3_42 g_3_42 g_3_43 4.993426e-04
Rgh_3_43 g_3_43 g_4_43 4.993426e-04
Rgv_3_43 g_3_43 g_3_44 4.993426e-04
Rgh_3_44 g_3_44 g_4_44 4.993426e-04
Rgv_3_44 g_3_44 g_3_45 4.993426e-04
Rgh_3_45 g_3_45 g_4_45 4.993426e-04
Rgv_3_45 g_3_45 g_3_46 4.993426e-04
Rgh_3_46 g_3_46 g_4_46 4.993426e-04
Rgv_3_46 g_3_46 g_3_47 4.993426e-04
Rgh_3_47 g_3_47 g_4_47 4.993426e-04
Rgv_3_47 g_3_47 g_3_48 4.993426e-04
Rgh_3_48 g_3_48 g_4_48 4.993426e-04
Rgv_3_48 g_3_48 g_3_49 4.993426e-04
Rgh_3_49 g_3_49 g_4_49 4.993426e-04
Rgv_3_49 g_3_49 g_3_50 4.993426e-04
Rgh_3_50 g_3_50 g_4_50 4.993426e-04
Rgv_3_50 g_3_50 g_3_51 4.993426e-04
Rgh_3_51 g_3_51 g_4_51 4.993426e-04
Rgv_3_51 g_3_51 g_3_52 4.993426e-04
Rgh_3_52 g_3_52 g_4_52 4.993426e-04
Rgv_3_52 g_3_52 g_3_53 4.993426e-04
Rgh_3_53 g_3_53 g_4_53 4.993426e-04
Rgv_3_53 g_3_53 g_3_54 4.993426e-04
Rgh_3_54 g_3_54 g_4_54 4.993426e-04
Rgv_3_54 g_3_54 g_3_55 4.993426e-04
Rgh_3_55 g_3_55 g_4_55 4.993426e-04
Rgv_3_55 g_3_55 g_3_56 4.993426e-04
Rgh_3_56 g_3_56 g_4_56 4.993426e-04
Rgv_3_56 g_3_56 g_3_57 4.993426e-04
Rgh_3_57 g_3_57 g_4_57 4.993426e-04
Rgv_3_57 g_3_57 g_3_58 4.993426e-04
Rgh_3_58 g_3_58 g_4_58 4.993426e-04
Rgv_3_58 g_3_58 g_3_59 4.993426e-04
Rgh_3_59 g_3_59 g_4_59 4.993426e-04
Rgv_3_59 g_3_59 g_3_60 4.993426e-04
Rgh_3_60 g_3_60 g_4_60 4.993426e-04
Rgv_3_60 g_3_60 g_3_61 4.993426e-04
Rgh_3_61 g_3_61 g_4_61 4.993426e-04
Rgv_3_61 g_3_61 g_3_62 4.993426e-04
Rgh_3_62 g_3_62 g_4_62 4.993426e-04
Rgv_3_62 g_3_62 g_3_63 4.993426e-04
Rgh_3_63 g_3_63 g_4_63 4.993426e-04
Rgv_3_63 g_3_63 g_3_64 4.993426e-04
Rgh_3_64 g_3_64 g_4_64 4.993426e-04
Rgv_3_64 g_3_64 g_3_65 4.993426e-04
Rgh_3_65 g_3_65 g_4_65 4.993426e-04
Rgv_3_65 g_3_65 g_3_66 4.993426e-04
Rgh_3_66 g_3_66 g_4_66 4.993426e-04
Rgv_3_66 g_3_66 g_3_67 4.993426e-04
Rgh_3_67 g_3_67 g_4_67 4.993426e-04
Rgv_3_67 g_3_67 g_3_68 4.993426e-04
Rgh_3_68 g_3_68 g_4_68 4.993426e-04
Rgv_3_68 g_3_68 g_3_69 4.993426e-04
Rgh_3_69 g_3_69 g_4_69 4.993426e-04
Rgv_3_69 g_3_69 g_3_70 4.993426e-04
Rgh_3_70 g_3_70 g_4_70 4.993426e-04
Rgv_3_70 g_3_70 g_3_71 4.993426e-04
Rgh_3_71 g_3_71 g_4_71 4.993426e-04
Rgh_4_0 g_4_0 g_5_0 4.993426e-04
Rgv_4_0 g_4_0 g_4_1 4.993426e-04
Rgh_4_1 g_4_1 g_5_1 4.993426e-04
Rgv_4_1 g_4_1 g_4_2 4.993426e-04
Rgh_4_2 g_4_2 g_5_2 4.993426e-04
Rgv_4_2 g_4_2 g_4_3 4.993426e-04
Rgh_4_3 g_4_3 g_5_3 4.993426e-04
Rgv_4_3 g_4_3 g_4_4 4.993426e-04
Rgh_4_4 g_4_4 g_5_4 4.993426e-04
Rgv_4_4 g_4_4 g_4_5 4.993426e-04
Rgh_4_5 g_4_5 g_5_5 4.993426e-04
Rgv_4_5 g_4_5 g_4_6 4.993426e-04
Rgh_4_6 g_4_6 g_5_6 4.993426e-04
Rgv_4_6 g_4_6 g_4_7 4.993426e-04
Rgh_4_7 g_4_7 g_5_7 4.993426e-04
Rgv_4_7 g_4_7 g_4_8 4.993426e-04
Rgh_4_8 g_4_8 g_5_8 4.993426e-04
Rgv_4_8 g_4_8 g_4_9 4.993426e-04
Rgh_4_9 g_4_9 g_5_9 4.993426e-04
Rgv_4_9 g_4_9 g_4_10 4.993426e-04
Rgh_4_10 g_4_10 g_5_10 4.993426e-04
Rgv_4_10 g_4_10 g_4_11 4.993426e-04
Rgh_4_11 g_4_11 g_5_11 4.993426e-04
Rgv_4_11 g_4_11 g_4_12 4.993426e-04
Rgh_4_12 g_4_12 g_5_12 4.993426e-04
Rgv_4_12 g_4_12 g_4_13 4.993426e-04
Rgh_4_13 g_4_13 g_5_13 4.993426e-04
Rgv_4_13 g_4_13 g_4_14 4.993426e-04
Rgh_4_14 g_4_14 g_5_14 4.993426e-04
Rgv_4_14 g_4_14 g_4_15 4.993426e-04
Rgh_4_15 g_4_15 g_5_15 4.993426e-04
Rgv_4_15 g_4_15 g_4_16 4.993426e-04
Rgh_4_16 g_4_16 g_5_16 4.993426e-04
Rgv_4_16 g_4_16 g_4_17 4.993426e-04
Rgh_4_17 g_4_17 g_5_17 4.993426e-04
Rgv_4_17 g_4_17 g_4_18 4.993426e-04
Rgh_4_18 g_4_18 g_5_18 4.993426e-04
Rgv_4_18 g_4_18 g_4_19 4.993426e-04
Rgh_4_19 g_4_19 g_5_19 4.993426e-04
Rgv_4_19 g_4_19 g_4_20 4.993426e-04
Rgh_4_20 g_4_20 g_5_20 4.993426e-04
Rgv_4_20 g_4_20 g_4_21 4.993426e-04
Rgh_4_21 g_4_21 g_5_21 4.993426e-04
Rgv_4_21 g_4_21 g_4_22 4.993426e-04
Rgh_4_22 g_4_22 g_5_22 4.993426e-04
Rgv_4_22 g_4_22 g_4_23 4.993426e-04
Rgh_4_23 g_4_23 g_5_23 4.993426e-04
Rgv_4_23 g_4_23 g_4_24 4.993426e-04
Rgh_4_24 g_4_24 g_5_24 4.993426e-04
Rgv_4_24 g_4_24 g_4_25 4.993426e-04
Rgh_4_25 g_4_25 g_5_25 4.993426e-04
Rgv_4_25 g_4_25 g_4_26 4.993426e-04
Rgh_4_26 g_4_26 g_5_26 4.993426e-04
Rgv_4_26 g_4_26 g_4_27 4.993426e-04
Rgh_4_27 g_4_27 g_5_27 4.993426e-04
Rgv_4_27 g_4_27 g_4_28 4.993426e-04
Rgh_4_28 g_4_28 g_5_28 4.993426e-04
Rgv_4_28 g_4_28 g_4_29 4.993426e-04
Rgh_4_29 g_4_29 g_5_29 4.993426e-04
Rgv_4_29 g_4_29 g_4_30 4.993426e-04
Rgh_4_30 g_4_30 g_5_30 4.993426e-04
Rgv_4_30 g_4_30 g_4_31 4.993426e-04
Rgh_4_31 g_4_31 g_5_31 4.993426e-04
Rgv_4_31 g_4_31 g_4_32 4.993426e-04
Rgh_4_32 g_4_32 g_5_32 4.993426e-04
Rgv_4_32 g_4_32 g_4_33 4.993426e-04
Rgh_4_33 g_4_33 g_5_33 4.993426e-04
Rgv_4_33 g_4_33 g_4_34 4.993426e-04
Rgh_4_34 g_4_34 g_5_34 4.993426e-04
Rgv_4_34 g_4_34 g_4_35 4.993426e-04
Rgh_4_35 g_4_35 g_5_35 4.993426e-04
Rgv_4_35 g_4_35 g_4_36 4.993426e-04
Rgh_4_36 g_4_36 g_5_36 4.993426e-04
Rgv_4_36 g_4_36 g_4_37 4.993426e-04
Rgh_4_37 g_4_37 g_5_37 4.993426e-04
Rgv_4_37 g_4_37 g_4_38 4.993426e-04
Rgh_4_38 g_4_38 g_5_38 4.993426e-04
Rgv_4_38 g_4_38 g_4_39 4.993426e-04
Rgh_4_39 g_4_39 g_5_39 4.993426e-04
Rgv_4_39 g_4_39 g_4_40 4.993426e-04
Rgh_4_40 g_4_40 g_5_40 4.993426e-04
Rgv_4_40 g_4_40 g_4_41 4.993426e-04
Rgh_4_41 g_4_41 g_5_41 4.993426e-04
Rgv_4_41 g_4_41 g_4_42 4.993426e-04
Rgh_4_42 g_4_42 g_5_42 4.993426e-04
Rgv_4_42 g_4_42 g_4_43 4.993426e-04
Rgh_4_43 g_4_43 g_5_43 4.993426e-04
Rgv_4_43 g_4_43 g_4_44 4.993426e-04
Rgh_4_44 g_4_44 g_5_44 4.993426e-04
Rgv_4_44 g_4_44 g_4_45 4.993426e-04
Rgh_4_45 g_4_45 g_5_45 4.993426e-04
Rgv_4_45 g_4_45 g_4_46 4.993426e-04
Rgh_4_46 g_4_46 g_5_46 4.993426e-04
Rgv_4_46 g_4_46 g_4_47 4.993426e-04
Rgh_4_47 g_4_47 g_5_47 4.993426e-04
Rgv_4_47 g_4_47 g_4_48 4.993426e-04
Rgh_4_48 g_4_48 g_5_48 4.993426e-04
Rgv_4_48 g_4_48 g_4_49 4.993426e-04
Rgh_4_49 g_4_49 g_5_49 4.993426e-04
Rgv_4_49 g_4_49 g_4_50 4.993426e-04
Rgh_4_50 g_4_50 g_5_50 4.993426e-04
Rgv_4_50 g_4_50 g_4_51 4.993426e-04
Rgh_4_51 g_4_51 g_5_51 4.993426e-04
Rgv_4_51 g_4_51 g_4_52 4.993426e-04
Rgh_4_52 g_4_52 g_5_52 4.993426e-04
Rgv_4_52 g_4_52 g_4_53 4.993426e-04
Rgh_4_53 g_4_53 g_5_53 4.993426e-04
Rgv_4_53 g_4_53 g_4_54 4.993426e-04
Rgh_4_54 g_4_54 g_5_54 4.993426e-04
Rgv_4_54 g_4_54 g_4_55 4.993426e-04
Rgh_4_55 g_4_55 g_5_55 4.993426e-04
Rgv_4_55 g_4_55 g_4_56 4.993426e-04
Rgh_4_56 g_4_56 g_5_56 4.993426e-04
Rgv_4_56 g_4_56 g_4_57 4.993426e-04
Rgh_4_57 g_4_57 g_5_57 4.993426e-04
Rgv_4_57 g_4_57 g_4_58 4.993426e-04
Rgh_4_58 g_4_58 g_5_58 4.993426e-04
Rgv_4_58 g_4_58 g_4_59 4.993426e-04
Rgh_4_59 g_4_59 g_5_59 4.993426e-04
Rgv_4_59 g_4_59 g_4_60 4.993426e-04
Rgh_4_60 g_4_60 g_5_60 4.993426e-04
Rgv_4_60 g_4_60 g_4_61 4.993426e-04
Rgh_4_61 g_4_61 g_5_61 4.993426e-04
Rgv_4_61 g_4_61 g_4_62 4.993426e-04
Rgh_4_62 g_4_62 g_5_62 4.993426e-04
Rgv_4_62 g_4_62 g_4_63 4.993426e-04
Rgh_4_63 g_4_63 g_5_63 4.993426e-04
Rgv_4_63 g_4_63 g_4_64 4.993426e-04
Rgh_4_64 g_4_64 g_5_64 4.993426e-04
Rgv_4_64 g_4_64 g_4_65 4.993426e-04
Rgh_4_65 g_4_65 g_5_65 4.993426e-04
Rgv_4_65 g_4_65 g_4_66 4.993426e-04
Rgh_4_66 g_4_66 g_5_66 4.993426e-04
Rgv_4_66 g_4_66 g_4_67 4.993426e-04
Rgh_4_67 g_4_67 g_5_67 4.993426e-04
Rgv_4_67 g_4_67 g_4_68 4.993426e-04
Rgh_4_68 g_4_68 g_5_68 4.993426e-04
Rgv_4_68 g_4_68 g_4_69 4.993426e-04
Rgh_4_69 g_4_69 g_5_69 4.993426e-04
Rgv_4_69 g_4_69 g_4_70 4.993426e-04
Rgh_4_70 g_4_70 g_5_70 4.993426e-04
Rgv_4_70 g_4_70 g_4_71 4.993426e-04
Rgh_4_71 g_4_71 g_5_71 4.993426e-04
Rgh_5_0 g_5_0 g_6_0 4.993426e-04
Rgv_5_0 g_5_0 g_5_1 4.993426e-04
Rgh_5_1 g_5_1 g_6_1 4.993426e-04
Rgv_5_1 g_5_1 g_5_2 4.993426e-04
Rgh_5_2 g_5_2 g_6_2 4.993426e-04
Rgv_5_2 g_5_2 g_5_3 4.993426e-04
Rgh_5_3 g_5_3 g_6_3 4.993426e-04
Rgv_5_3 g_5_3 g_5_4 4.993426e-04
Rgh_5_4 g_5_4 g_6_4 4.993426e-04
Rgv_5_4 g_5_4 g_5_5 4.993426e-04
Rgh_5_5 g_5_5 g_6_5 4.993426e-04
Rgv_5_5 g_5_5 g_5_6 4.993426e-04
Rgh_5_6 g_5_6 g_6_6 4.993426e-04
Rgv_5_6 g_5_6 g_5_7 4.993426e-04
Rgh_5_7 g_5_7 g_6_7 4.993426e-04
Rgv_5_7 g_5_7 g_5_8 4.993426e-04
Rgh_5_8 g_5_8 g_6_8 4.993426e-04
Rgv_5_8 g_5_8 g_5_9 4.993426e-04
Rgh_5_9 g_5_9 g_6_9 4.993426e-04
Rgv_5_9 g_5_9 g_5_10 4.993426e-04
Rgh_5_10 g_5_10 g_6_10 4.993426e-04
Rgv_5_10 g_5_10 g_5_11 4.993426e-04
Rgh_5_11 g_5_11 g_6_11 4.993426e-04
Rgv_5_11 g_5_11 g_5_12 4.993426e-04
Rgh_5_12 g_5_12 g_6_12 4.993426e-04
Rgv_5_12 g_5_12 g_5_13 4.993426e-04
Rgh_5_13 g_5_13 g_6_13 4.993426e-04
Rgv_5_13 g_5_13 g_5_14 4.993426e-04
Rgh_5_14 g_5_14 g_6_14 4.993426e-04
Rgv_5_14 g_5_14 g_5_15 4.993426e-04
Rgh_5_15 g_5_15 g_6_15 4.993426e-04
Rgv_5_15 g_5_15 g_5_16 4.993426e-04
Rgh_5_16 g_5_16 g_6_16 4.993426e-04
Rgv_5_16 g_5_16 g_5_17 4.993426e-04
Rgh_5_17 g_5_17 g_6_17 4.993426e-04
Rgv_5_17 g_5_17 g_5_18 4.993426e-04
Rgh_5_18 g_5_18 g_6_18 4.993426e-04
Rgv_5_18 g_5_18 g_5_19 4.993426e-04
Rgh_5_19 g_5_19 g_6_19 4.993426e-04
Rgv_5_19 g_5_19 g_5_20 4.993426e-04
Rgh_5_20 g_5_20 g_6_20 4.993426e-04
Rgv_5_20 g_5_20 g_5_21 4.993426e-04
Rgh_5_21 g_5_21 g_6_21 4.993426e-04
Rgv_5_21 g_5_21 g_5_22 4.993426e-04
Rgh_5_22 g_5_22 g_6_22 4.993426e-04
Rgv_5_22 g_5_22 g_5_23 4.993426e-04
Rgh_5_23 g_5_23 g_6_23 4.993426e-04
Rgv_5_23 g_5_23 g_5_24 4.993426e-04
Rgh_5_24 g_5_24 g_6_24 4.993426e-04
Rgv_5_24 g_5_24 g_5_25 4.993426e-04
Rgh_5_25 g_5_25 g_6_25 4.993426e-04
Rgv_5_25 g_5_25 g_5_26 4.993426e-04
Rgh_5_26 g_5_26 g_6_26 4.993426e-04
Rgv_5_26 g_5_26 g_5_27 4.993426e-04
Rgh_5_27 g_5_27 g_6_27 4.993426e-04
Rgv_5_27 g_5_27 g_5_28 4.993426e-04
Rgh_5_28 g_5_28 g_6_28 4.993426e-04
Rgv_5_28 g_5_28 g_5_29 4.993426e-04
Rgh_5_29 g_5_29 g_6_29 4.993426e-04
Rgv_5_29 g_5_29 g_5_30 4.993426e-04
Rgh_5_30 g_5_30 g_6_30 4.993426e-04
Rgv_5_30 g_5_30 g_5_31 4.993426e-04
Rgh_5_31 g_5_31 g_6_31 4.993426e-04
Rgv_5_31 g_5_31 g_5_32 4.993426e-04
Rgh_5_32 g_5_32 g_6_32 4.993426e-04
Rgv_5_32 g_5_32 g_5_33 4.993426e-04
Rgh_5_33 g_5_33 g_6_33 4.993426e-04
Rgv_5_33 g_5_33 g_5_34 4.993426e-04
Rgh_5_34 g_5_34 g_6_34 4.993426e-04
Rgv_5_34 g_5_34 g_5_35 4.993426e-04
Rgh_5_35 g_5_35 g_6_35 4.993426e-04
Rgv_5_35 g_5_35 g_5_36 4.993426e-04
Rgh_5_36 g_5_36 g_6_36 4.993426e-04
Rgv_5_36 g_5_36 g_5_37 4.993426e-04
Rgh_5_37 g_5_37 g_6_37 4.993426e-04
Rgv_5_37 g_5_37 g_5_38 4.993426e-04
Rgh_5_38 g_5_38 g_6_38 4.993426e-04
Rgv_5_38 g_5_38 g_5_39 4.993426e-04
Rgh_5_39 g_5_39 g_6_39 4.993426e-04
Rgv_5_39 g_5_39 g_5_40 4.993426e-04
Rgh_5_40 g_5_40 g_6_40 4.993426e-04
Rgv_5_40 g_5_40 g_5_41 4.993426e-04
Rgh_5_41 g_5_41 g_6_41 4.993426e-04
Rgv_5_41 g_5_41 g_5_42 4.993426e-04
Rgh_5_42 g_5_42 g_6_42 4.993426e-04
Rgv_5_42 g_5_42 g_5_43 4.993426e-04
Rgh_5_43 g_5_43 g_6_43 4.993426e-04
Rgv_5_43 g_5_43 g_5_44 4.993426e-04
Rgh_5_44 g_5_44 g_6_44 4.993426e-04
Rgv_5_44 g_5_44 g_5_45 4.993426e-04
Rgh_5_45 g_5_45 g_6_45 4.993426e-04
Rgv_5_45 g_5_45 g_5_46 4.993426e-04
Rgh_5_46 g_5_46 g_6_46 4.993426e-04
Rgv_5_46 g_5_46 g_5_47 4.993426e-04
Rgh_5_47 g_5_47 g_6_47 4.993426e-04
Rgv_5_47 g_5_47 g_5_48 4.993426e-04
Rgh_5_48 g_5_48 g_6_48 4.993426e-04
Rgv_5_48 g_5_48 g_5_49 4.993426e-04
Rgh_5_49 g_5_49 g_6_49 4.993426e-04
Rgv_5_49 g_5_49 g_5_50 4.993426e-04
Rgh_5_50 g_5_50 g_6_50 4.993426e-04
Rgv_5_50 g_5_50 g_5_51 4.993426e-04
Rgh_5_51 g_5_51 g_6_51 4.993426e-04
Rgv_5_51 g_5_51 g_5_52 4.993426e-04
Rgh_5_52 g_5_52 g_6_52 4.993426e-04
Rgv_5_52 g_5_52 g_5_53 4.993426e-04
Rgh_5_53 g_5_53 g_6_53 4.993426e-04
Rgv_5_53 g_5_53 g_5_54 4.993426e-04
Rgh_5_54 g_5_54 g_6_54 4.993426e-04
Rgv_5_54 g_5_54 g_5_55 4.993426e-04
Rgh_5_55 g_5_55 g_6_55 4.993426e-04
Rgv_5_55 g_5_55 g_5_56 4.993426e-04
Rgh_5_56 g_5_56 g_6_56 4.993426e-04
Rgv_5_56 g_5_56 g_5_57 4.993426e-04
Rgh_5_57 g_5_57 g_6_57 4.993426e-04
Rgv_5_57 g_5_57 g_5_58 4.993426e-04
Rgh_5_58 g_5_58 g_6_58 4.993426e-04
Rgv_5_58 g_5_58 g_5_59 4.993426e-04
Rgh_5_59 g_5_59 g_6_59 4.993426e-04
Rgv_5_59 g_5_59 g_5_60 4.993426e-04
Rgh_5_60 g_5_60 g_6_60 4.993426e-04
Rgv_5_60 g_5_60 g_5_61 4.993426e-04
Rgh_5_61 g_5_61 g_6_61 4.993426e-04
Rgv_5_61 g_5_61 g_5_62 4.993426e-04
Rgh_5_62 g_5_62 g_6_62 4.993426e-04
Rgv_5_62 g_5_62 g_5_63 4.993426e-04
Rgh_5_63 g_5_63 g_6_63 4.993426e-04
Rgv_5_63 g_5_63 g_5_64 4.993426e-04
Rgh_5_64 g_5_64 g_6_64 4.993426e-04
Rgv_5_64 g_5_64 g_5_65 4.993426e-04
Rgh_5_65 g_5_65 g_6_65 4.993426e-04
Rgv_5_65 g_5_65 g_5_66 4.993426e-04
Rgh_5_66 g_5_66 g_6_66 4.993426e-04
Rgv_5_66 g_5_66 g_5_67 4.993426e-04
Rgh_5_67 g_5_67 g_6_67 4.993426e-04
Rgv_5_67 g_5_67 g_5_68 4.993426e-04
Rgh_5_68 g_5_68 g_6_68 4.993426e-04
Rgv_5_68 g_5_68 g_5_69 4.993426e-04
Rgh_5_69 g_5_69 g_6_69 4.993426e-04
Rgv_5_69 g_5_69 g_5_70 4.993426e-04
Rgh_5_70 g_5_70 g_6_70 4.993426e-04
Rgv_5_70 g_5_70 g_5_71 4.993426e-04
Rgh_5_71 g_5_71 g_6_71 4.993426e-04
Rgh_6_0 g_6_0 g_7_0 4.993426e-04
Rgv_6_0 g_6_0 g_6_1 4.993426e-04
Rgh_6_1 g_6_1 g_7_1 4.993426e-04
Rgv_6_1 g_6_1 g_6_2 4.993426e-04
Rgh_6_2 g_6_2 g_7_2 4.993426e-04
Rgv_6_2 g_6_2 g_6_3 4.993426e-04
Rgh_6_3 g_6_3 g_7_3 4.993426e-04
Rgv_6_3 g_6_3 g_6_4 4.993426e-04
Rgh_6_4 g_6_4 g_7_4 4.993426e-04
Rgv_6_4 g_6_4 g_6_5 4.993426e-04
Rgh_6_5 g_6_5 g_7_5 4.993426e-04
Rgv_6_5 g_6_5 g_6_6 4.993426e-04
Rgh_6_6 g_6_6 g_7_6 4.993426e-04
Rgv_6_6 g_6_6 g_6_7 4.993426e-04
Rgh_6_7 g_6_7 g_7_7 4.993426e-04
Rgv_6_7 g_6_7 g_6_8 4.993426e-04
Rgh_6_8 g_6_8 g_7_8 4.993426e-04
Rgv_6_8 g_6_8 g_6_9 4.993426e-04
Rgh_6_9 g_6_9 g_7_9 4.993426e-04
Rgv_6_9 g_6_9 g_6_10 4.993426e-04
Rgh_6_10 g_6_10 g_7_10 4.993426e-04
Rgv_6_10 g_6_10 g_6_11 4.993426e-04
Rgh_6_11 g_6_11 g_7_11 4.993426e-04
Rgv_6_11 g_6_11 g_6_12 4.993426e-04
Rgh_6_12 g_6_12 g_7_12 4.993426e-04
Rgv_6_12 g_6_12 g_6_13 4.993426e-04
Rgh_6_13 g_6_13 g_7_13 4.993426e-04
Rgv_6_13 g_6_13 g_6_14 4.993426e-04
Rgh_6_14 g_6_14 g_7_14 4.993426e-04
Rgv_6_14 g_6_14 g_6_15 4.993426e-04
Rgh_6_15 g_6_15 g_7_15 4.993426e-04
Rgv_6_15 g_6_15 g_6_16 4.993426e-04
Rgh_6_16 g_6_16 g_7_16 4.993426e-04
Rgv_6_16 g_6_16 g_6_17 4.993426e-04
Rgh_6_17 g_6_17 g_7_17 4.993426e-04
Rgv_6_17 g_6_17 g_6_18 4.993426e-04
Rgh_6_18 g_6_18 g_7_18 4.993426e-04
Rgv_6_18 g_6_18 g_6_19 4.993426e-04
Rgh_6_19 g_6_19 g_7_19 4.993426e-04
Rgv_6_19 g_6_19 g_6_20 4.993426e-04
Rgh_6_20 g_6_20 g_7_20 4.993426e-04
Rgv_6_20 g_6_20 g_6_21 4.993426e-04
Rgh_6_21 g_6_21 g_7_21 4.993426e-04
Rgv_6_21 g_6_21 g_6_22 4.993426e-04
Rgh_6_22 g_6_22 g_7_22 4.993426e-04
Rgv_6_22 g_6_22 g_6_23 4.993426e-04
Rgh_6_23 g_6_23 g_7_23 4.993426e-04
Rgv_6_23 g_6_23 g_6_24 4.993426e-04
Rgh_6_24 g_6_24 g_7_24 4.993426e-04
Rgv_6_24 g_6_24 g_6_25 4.993426e-04
Rgh_6_25 g_6_25 g_7_25 4.993426e-04
Rgv_6_25 g_6_25 g_6_26 4.993426e-04
Rgh_6_26 g_6_26 g_7_26 4.993426e-04
Rgv_6_26 g_6_26 g_6_27 4.993426e-04
Rgh_6_27 g_6_27 g_7_27 4.993426e-04
Rgv_6_27 g_6_27 g_6_28 4.993426e-04
Rgh_6_28 g_6_28 g_7_28 4.993426e-04
Rgv_6_28 g_6_28 g_6_29 4.993426e-04
Rgh_6_29 g_6_29 g_7_29 4.993426e-04
Rgv_6_29 g_6_29 g_6_30 4.993426e-04
Rgh_6_30 g_6_30 g_7_30 4.993426e-04
Rgv_6_30 g_6_30 g_6_31 4.993426e-04
Rgh_6_31 g_6_31 g_7_31 4.993426e-04
Rgv_6_31 g_6_31 g_6_32 4.993426e-04
Rgh_6_32 g_6_32 g_7_32 4.993426e-04
Rgv_6_32 g_6_32 g_6_33 4.993426e-04
Rgh_6_33 g_6_33 g_7_33 4.993426e-04
Rgv_6_33 g_6_33 g_6_34 4.993426e-04
Rgh_6_34 g_6_34 g_7_34 4.993426e-04
Rgv_6_34 g_6_34 g_6_35 4.993426e-04
Rgh_6_35 g_6_35 g_7_35 4.993426e-04
Rgv_6_35 g_6_35 g_6_36 4.993426e-04
Rgh_6_36 g_6_36 g_7_36 4.993426e-04
Rgv_6_36 g_6_36 g_6_37 4.993426e-04
Rgh_6_37 g_6_37 g_7_37 4.993426e-04
Rgv_6_37 g_6_37 g_6_38 4.993426e-04
Rgh_6_38 g_6_38 g_7_38 4.993426e-04
Rgv_6_38 g_6_38 g_6_39 4.993426e-04
Rgh_6_39 g_6_39 g_7_39 4.993426e-04
Rgv_6_39 g_6_39 g_6_40 4.993426e-04
Rgh_6_40 g_6_40 g_7_40 4.993426e-04
Rgv_6_40 g_6_40 g_6_41 4.993426e-04
Rgh_6_41 g_6_41 g_7_41 4.993426e-04
Rgv_6_41 g_6_41 g_6_42 4.993426e-04
Rgh_6_42 g_6_42 g_7_42 4.993426e-04
Rgv_6_42 g_6_42 g_6_43 4.993426e-04
Rgh_6_43 g_6_43 g_7_43 4.993426e-04
Rgv_6_43 g_6_43 g_6_44 4.993426e-04
Rgh_6_44 g_6_44 g_7_44 4.993426e-04
Rgv_6_44 g_6_44 g_6_45 4.993426e-04
Rgh_6_45 g_6_45 g_7_45 4.993426e-04
Rgv_6_45 g_6_45 g_6_46 4.993426e-04
Rgh_6_46 g_6_46 g_7_46 4.993426e-04
Rgv_6_46 g_6_46 g_6_47 4.993426e-04
Rgh_6_47 g_6_47 g_7_47 4.993426e-04
Rgv_6_47 g_6_47 g_6_48 4.993426e-04
Rgh_6_48 g_6_48 g_7_48 4.993426e-04
Rgv_6_48 g_6_48 g_6_49 4.993426e-04
Rgh_6_49 g_6_49 g_7_49 4.993426e-04
Rgv_6_49 g_6_49 g_6_50 4.993426e-04
Rgh_6_50 g_6_50 g_7_50 4.993426e-04
Rgv_6_50 g_6_50 g_6_51 4.993426e-04
Rgh_6_51 g_6_51 g_7_51 4.993426e-04
Rgv_6_51 g_6_51 g_6_52 4.993426e-04
Rgh_6_52 g_6_52 g_7_52 4.993426e-04
Rgv_6_52 g_6_52 g_6_53 4.993426e-04
Rgh_6_53 g_6_53 g_7_53 4.993426e-04
Rgv_6_53 g_6_53 g_6_54 4.993426e-04
Rgh_6_54 g_6_54 g_7_54 4.993426e-04
Rgv_6_54 g_6_54 g_6_55 4.993426e-04
Rgh_6_55 g_6_55 g_7_55 4.993426e-04
Rgv_6_55 g_6_55 g_6_56 4.993426e-04
Rgh_6_56 g_6_56 g_7_56 4.993426e-04
Rgv_6_56 g_6_56 g_6_57 4.993426e-04
Rgh_6_57 g_6_57 g_7_57 4.993426e-04
Rgv_6_57 g_6_57 g_6_58 4.993426e-04
Rgh_6_58 g_6_58 g_7_58 4.993426e-04
Rgv_6_58 g_6_58 g_6_59 4.993426e-04
Rgh_6_59 g_6_59 g_7_59 4.993426e-04
Rgv_6_59 g_6_59 g_6_60 4.993426e-04
Rgh_6_60 g_6_60 g_7_60 4.993426e-04
Rgv_6_60 g_6_60 g_6_61 4.993426e-04
Rgh_6_61 g_6_61 g_7_61 4.993426e-04
Rgv_6_61 g_6_61 g_6_62 4.993426e-04
Rgh_6_62 g_6_62 g_7_62 4.993426e-04
Rgv_6_62 g_6_62 g_6_63 4.993426e-04
Rgh_6_63 g_6_63 g_7_63 4.993426e-04
Rgv_6_63 g_6_63 g_6_64 4.993426e-04
Rgh_6_64 g_6_64 g_7_64 4.993426e-04
Rgv_6_64 g_6_64 g_6_65 4.993426e-04
Rgh_6_65 g_6_65 g_7_65 4.993426e-04
Rgv_6_65 g_6_65 g_6_66 4.993426e-04
Rgh_6_66 g_6_66 g_7_66 4.993426e-04
Rgv_6_66 g_6_66 g_6_67 4.993426e-04
Rgh_6_67 g_6_67 g_7_67 4.993426e-04
Rgv_6_67 g_6_67 g_6_68 4.993426e-04
Rgh_6_68 g_6_68 g_7_68 4.993426e-04
Rgv_6_68 g_6_68 g_6_69 4.993426e-04
Rgh_6_69 g_6_69 g_7_69 4.993426e-04
Rgv_6_69 g_6_69 g_6_70 4.993426e-04
Rgh_6_70 g_6_70 g_7_70 4.993426e-04
Rgv_6_70 g_6_70 g_6_71 4.993426e-04
Rgh_6_71 g_6_71 g_7_71 4.993426e-04
Rgh_7_0 g_7_0 g_8_0 4.993426e-04
Rgv_7_0 g_7_0 g_7_1 4.993426e-04
Rgh_7_1 g_7_1 g_8_1 4.993426e-04
Rgv_7_1 g_7_1 g_7_2 4.993426e-04
Rgh_7_2 g_7_2 g_8_2 4.993426e-04
Rgv_7_2 g_7_2 g_7_3 4.993426e-04
Rgh_7_3 g_7_3 g_8_3 4.993426e-04
Rgv_7_3 g_7_3 g_7_4 4.993426e-04
Rgh_7_4 g_7_4 g_8_4 4.993426e-04
Rgv_7_4 g_7_4 g_7_5 4.993426e-04
Rgh_7_5 g_7_5 g_8_5 4.993426e-04
Rgv_7_5 g_7_5 g_7_6 4.993426e-04
Rgh_7_6 g_7_6 g_8_6 4.993426e-04
Rgv_7_6 g_7_6 g_7_7 4.993426e-04
Rgh_7_7 g_7_7 g_8_7 4.993426e-04
Rgv_7_7 g_7_7 g_7_8 4.993426e-04
Rgh_7_8 g_7_8 g_8_8 4.993426e-04
Rgv_7_8 g_7_8 g_7_9 4.993426e-04
Rgh_7_9 g_7_9 g_8_9 4.993426e-04
Rgv_7_9 g_7_9 g_7_10 4.993426e-04
Rgh_7_10 g_7_10 g_8_10 4.993426e-04
Rgv_7_10 g_7_10 g_7_11 4.993426e-04
Rgh_7_11 g_7_11 g_8_11 4.993426e-04
Rgv_7_11 g_7_11 g_7_12 4.993426e-04
Rgh_7_12 g_7_12 g_8_12 4.993426e-04
Rgv_7_12 g_7_12 g_7_13 4.993426e-04
Rgh_7_13 g_7_13 g_8_13 4.993426e-04
Rgv_7_13 g_7_13 g_7_14 4.993426e-04
Rgh_7_14 g_7_14 g_8_14 4.993426e-04
Rgv_7_14 g_7_14 g_7_15 4.993426e-04
Rgh_7_15 g_7_15 g_8_15 4.993426e-04
Rgv_7_15 g_7_15 g_7_16 4.993426e-04
Rgh_7_16 g_7_16 g_8_16 4.993426e-04
Rgv_7_16 g_7_16 g_7_17 4.993426e-04
Rgh_7_17 g_7_17 g_8_17 4.993426e-04
Rgv_7_17 g_7_17 g_7_18 4.993426e-04
Rgh_7_18 g_7_18 g_8_18 4.993426e-04
Rgv_7_18 g_7_18 g_7_19 4.993426e-04
Rgh_7_19 g_7_19 g_8_19 4.993426e-04
Rgv_7_19 g_7_19 g_7_20 4.993426e-04
Rgh_7_20 g_7_20 g_8_20 4.993426e-04
Rgv_7_20 g_7_20 g_7_21 4.993426e-04
Rgh_7_21 g_7_21 g_8_21 4.993426e-04
Rgv_7_21 g_7_21 g_7_22 4.993426e-04
Rgh_7_22 g_7_22 g_8_22 4.993426e-04
Rgv_7_22 g_7_22 g_7_23 4.993426e-04
Rgh_7_23 g_7_23 g_8_23 4.993426e-04
Rgv_7_23 g_7_23 g_7_24 4.993426e-04
Rgh_7_24 g_7_24 g_8_24 4.993426e-04
Rgv_7_24 g_7_24 g_7_25 4.993426e-04
Rgh_7_25 g_7_25 g_8_25 4.993426e-04
Rgv_7_25 g_7_25 g_7_26 4.993426e-04
Rgh_7_26 g_7_26 g_8_26 4.993426e-04
Rgv_7_26 g_7_26 g_7_27 4.993426e-04
Rgh_7_27 g_7_27 g_8_27 4.993426e-04
Rgv_7_27 g_7_27 g_7_28 4.993426e-04
Rgh_7_28 g_7_28 g_8_28 4.993426e-04
Rgv_7_28 g_7_28 g_7_29 4.993426e-04
Rgh_7_29 g_7_29 g_8_29 4.993426e-04
Rgv_7_29 g_7_29 g_7_30 4.993426e-04
Rgh_7_30 g_7_30 g_8_30 4.993426e-04
Rgv_7_30 g_7_30 g_7_31 4.993426e-04
Rgh_7_31 g_7_31 g_8_31 4.993426e-04
Rgv_7_31 g_7_31 g_7_32 4.993426e-04
Rgh_7_32 g_7_32 g_8_32 4.993426e-04
Rgv_7_32 g_7_32 g_7_33 4.993426e-04
Rgh_7_33 g_7_33 g_8_33 4.993426e-04
Rgv_7_33 g_7_33 g_7_34 4.993426e-04
Rgh_7_34 g_7_34 g_8_34 4.993426e-04
Rgv_7_34 g_7_34 g_7_35 4.993426e-04
Rgh_7_35 g_7_35 g_8_35 4.993426e-04
Rgv_7_35 g_7_35 g_7_36 4.993426e-04
Rgh_7_36 g_7_36 g_8_36 4.993426e-04
Rgv_7_36 g_7_36 g_7_37 4.993426e-04
Rgh_7_37 g_7_37 g_8_37 4.993426e-04
Rgv_7_37 g_7_37 g_7_38 4.993426e-04
Rgh_7_38 g_7_38 g_8_38 4.993426e-04
Rgv_7_38 g_7_38 g_7_39 4.993426e-04
Rgh_7_39 g_7_39 g_8_39 4.993426e-04
Rgv_7_39 g_7_39 g_7_40 4.993426e-04
Rgh_7_40 g_7_40 g_8_40 4.993426e-04
Rgv_7_40 g_7_40 g_7_41 4.993426e-04
Rgh_7_41 g_7_41 g_8_41 4.993426e-04
Rgv_7_41 g_7_41 g_7_42 4.993426e-04
Rgh_7_42 g_7_42 g_8_42 4.993426e-04
Rgv_7_42 g_7_42 g_7_43 4.993426e-04
Rgh_7_43 g_7_43 g_8_43 4.993426e-04
Rgv_7_43 g_7_43 g_7_44 4.993426e-04
Rgh_7_44 g_7_44 g_8_44 4.993426e-04
Rgv_7_44 g_7_44 g_7_45 4.993426e-04
Rgh_7_45 g_7_45 g_8_45 4.993426e-04
Rgv_7_45 g_7_45 g_7_46 4.993426e-04
Rgh_7_46 g_7_46 g_8_46 4.993426e-04
Rgv_7_46 g_7_46 g_7_47 4.993426e-04
Rgh_7_47 g_7_47 g_8_47 4.993426e-04
Rgv_7_47 g_7_47 g_7_48 4.993426e-04
Rgh_7_48 g_7_48 g_8_48 4.993426e-04
Rgv_7_48 g_7_48 g_7_49 4.993426e-04
Rgh_7_49 g_7_49 g_8_49 4.993426e-04
Rgv_7_49 g_7_49 g_7_50 4.993426e-04
Rgh_7_50 g_7_50 g_8_50 4.993426e-04
Rgv_7_50 g_7_50 g_7_51 4.993426e-04
Rgh_7_51 g_7_51 g_8_51 4.993426e-04
Rgv_7_51 g_7_51 g_7_52 4.993426e-04
Rgh_7_52 g_7_52 g_8_52 4.993426e-04
Rgv_7_52 g_7_52 g_7_53 4.993426e-04
Rgh_7_53 g_7_53 g_8_53 4.993426e-04
Rgv_7_53 g_7_53 g_7_54 4.993426e-04
Rgh_7_54 g_7_54 g_8_54 4.993426e-04
Rgv_7_54 g_7_54 g_7_55 4.993426e-04
Rgh_7_55 g_7_55 g_8_55 4.993426e-04
Rgv_7_55 g_7_55 g_7_56 4.993426e-04
Rgh_7_56 g_7_56 g_8_56 4.993426e-04
Rgv_7_56 g_7_56 g_7_57 4.993426e-04
Rgh_7_57 g_7_57 g_8_57 4.993426e-04
Rgv_7_57 g_7_57 g_7_58 4.993426e-04
Rgh_7_58 g_7_58 g_8_58 4.993426e-04
Rgv_7_58 g_7_58 g_7_59 4.993426e-04
Rgh_7_59 g_7_59 g_8_59 4.993426e-04
Rgv_7_59 g_7_59 g_7_60 4.993426e-04
Rgh_7_60 g_7_60 g_8_60 4.993426e-04
Rgv_7_60 g_7_60 g_7_61 4.993426e-04
Rgh_7_61 g_7_61 g_8_61 4.993426e-04
Rgv_7_61 g_7_61 g_7_62 4.993426e-04
Rgh_7_62 g_7_62 g_8_62 4.993426e-04
Rgv_7_62 g_7_62 g_7_63 4.993426e-04
Rgh_7_63 g_7_63 g_8_63 4.993426e-04
Rgv_7_63 g_7_63 g_7_64 4.993426e-04
Rgh_7_64 g_7_64 g_8_64 4.993426e-04
Rgv_7_64 g_7_64 g_7_65 4.993426e-04
Rgh_7_65 g_7_65 g_8_65 4.993426e-04
Rgv_7_65 g_7_65 g_7_66 4.993426e-04
Rgh_7_66 g_7_66 g_8_66 4.993426e-04
Rgv_7_66 g_7_66 g_7_67 4.993426e-04
Rgh_7_67 g_7_67 g_8_67 4.993426e-04
Rgv_7_67 g_7_67 g_7_68 4.993426e-04
Rgh_7_68 g_7_68 g_8_68 4.993426e-04
Rgv_7_68 g_7_68 g_7_69 4.993426e-04
Rgh_7_69 g_7_69 g_8_69 4.993426e-04
Rgv_7_69 g_7_69 g_7_70 4.993426e-04
Rgh_7_70 g_7_70 g_8_70 4.993426e-04
Rgv_7_70 g_7_70 g_7_71 4.993426e-04
Rgh_7_71 g_7_71 g_8_71 4.993426e-04
Rgh_8_0 g_8_0 g_9_0 4.993426e-04
Rgv_8_0 g_8_0 g_8_1 4.993426e-04
Rgh_8_1 g_8_1 g_9_1 4.993426e-04
Rgv_8_1 g_8_1 g_8_2 4.993426e-04
Rgh_8_2 g_8_2 g_9_2 4.993426e-04
Rgv_8_2 g_8_2 g_8_3 4.993426e-04
Rgh_8_3 g_8_3 g_9_3 4.993426e-04
Rgv_8_3 g_8_3 g_8_4 4.993426e-04
Rgh_8_4 g_8_4 g_9_4 4.993426e-04
Rgv_8_4 g_8_4 g_8_5 4.993426e-04
Rgh_8_5 g_8_5 g_9_5 4.993426e-04
Rgv_8_5 g_8_5 g_8_6 4.993426e-04
Rgh_8_6 g_8_6 g_9_6 4.993426e-04
Rgv_8_6 g_8_6 g_8_7 4.993426e-04
Rgh_8_7 g_8_7 g_9_7 4.993426e-04
Rgv_8_7 g_8_7 g_8_8 4.993426e-04
Rgh_8_8 g_8_8 g_9_8 4.993426e-04
Rgv_8_8 g_8_8 g_8_9 4.993426e-04
Rgh_8_9 g_8_9 g_9_9 4.993426e-04
Rgv_8_9 g_8_9 g_8_10 4.993426e-04
Rgh_8_10 g_8_10 g_9_10 4.993426e-04
Rgv_8_10 g_8_10 g_8_11 4.993426e-04
Rgh_8_11 g_8_11 g_9_11 4.993426e-04
Rgv_8_11 g_8_11 g_8_12 4.993426e-04
Rgh_8_12 g_8_12 g_9_12 4.993426e-04
Rgv_8_12 g_8_12 g_8_13 4.993426e-04
Rgh_8_13 g_8_13 g_9_13 4.993426e-04
Rgv_8_13 g_8_13 g_8_14 4.993426e-04
Rgh_8_14 g_8_14 g_9_14 4.993426e-04
Rgv_8_14 g_8_14 g_8_15 4.993426e-04
Rgh_8_15 g_8_15 g_9_15 4.993426e-04
Rgv_8_15 g_8_15 g_8_16 4.993426e-04
Rgh_8_16 g_8_16 g_9_16 4.993426e-04
Rgv_8_16 g_8_16 g_8_17 4.993426e-04
Rgh_8_17 g_8_17 g_9_17 4.993426e-04
Rgv_8_17 g_8_17 g_8_18 4.993426e-04
Rgh_8_18 g_8_18 g_9_18 4.993426e-04
Rgv_8_18 g_8_18 g_8_19 4.993426e-04
Rgh_8_19 g_8_19 g_9_19 4.993426e-04
Rgv_8_19 g_8_19 g_8_20 4.993426e-04
Rgh_8_20 g_8_20 g_9_20 4.993426e-04
Rgv_8_20 g_8_20 g_8_21 4.993426e-04
Rgh_8_21 g_8_21 g_9_21 4.993426e-04
Rgv_8_21 g_8_21 g_8_22 4.993426e-04
Rgh_8_22 g_8_22 g_9_22 4.993426e-04
Rgv_8_22 g_8_22 g_8_23 4.993426e-04
Rgh_8_23 g_8_23 g_9_23 4.993426e-04
Rgv_8_23 g_8_23 g_8_24 4.993426e-04
Rgh_8_24 g_8_24 g_9_24 4.993426e-04
Rgv_8_24 g_8_24 g_8_25 4.993426e-04
Rgh_8_25 g_8_25 g_9_25 4.993426e-04
Rgv_8_25 g_8_25 g_8_26 4.993426e-04
Rgh_8_26 g_8_26 g_9_26 4.993426e-04
Rgv_8_26 g_8_26 g_8_27 4.993426e-04
Rgh_8_27 g_8_27 g_9_27 4.993426e-04
Rgv_8_27 g_8_27 g_8_28 4.993426e-04
Rgh_8_28 g_8_28 g_9_28 4.993426e-04
Rgv_8_28 g_8_28 g_8_29 4.993426e-04
Rgh_8_29 g_8_29 g_9_29 4.993426e-04
Rgv_8_29 g_8_29 g_8_30 4.993426e-04
Rgh_8_30 g_8_30 g_9_30 4.993426e-04
Rgv_8_30 g_8_30 g_8_31 4.993426e-04
Rgh_8_31 g_8_31 g_9_31 4.993426e-04
Rgv_8_31 g_8_31 g_8_32 4.993426e-04
Rgh_8_32 g_8_32 g_9_32 4.993426e-04
Rgv_8_32 g_8_32 g_8_33 4.993426e-04
Rgh_8_33 g_8_33 g_9_33 4.993426e-04
Rgv_8_33 g_8_33 g_8_34 4.993426e-04
Rgh_8_34 g_8_34 g_9_34 4.993426e-04
Rgv_8_34 g_8_34 g_8_35 4.993426e-04
Rgh_8_35 g_8_35 g_9_35 4.993426e-04
Rgv_8_35 g_8_35 g_8_36 4.993426e-04
Rgh_8_36 g_8_36 g_9_36 4.993426e-04
Rgv_8_36 g_8_36 g_8_37 4.993426e-04
Rgh_8_37 g_8_37 g_9_37 4.993426e-04
Rgv_8_37 g_8_37 g_8_38 4.993426e-04
Rgh_8_38 g_8_38 g_9_38 4.993426e-04
Rgv_8_38 g_8_38 g_8_39 4.993426e-04
Rgh_8_39 g_8_39 g_9_39 4.993426e-04
Rgv_8_39 g_8_39 g_8_40 4.993426e-04
Rgh_8_40 g_8_40 g_9_40 4.993426e-04
Rgv_8_40 g_8_40 g_8_41 4.993426e-04
Rgh_8_41 g_8_41 g_9_41 4.993426e-04
Rgv_8_41 g_8_41 g_8_42 4.993426e-04
Rgh_8_42 g_8_42 g_9_42 4.993426e-04
Rgv_8_42 g_8_42 g_8_43 4.993426e-04
Rgh_8_43 g_8_43 g_9_43 4.993426e-04
Rgv_8_43 g_8_43 g_8_44 4.993426e-04
Rgh_8_44 g_8_44 g_9_44 4.993426e-04
Rgv_8_44 g_8_44 g_8_45 4.993426e-04
Rgh_8_45 g_8_45 g_9_45 4.993426e-04
Rgv_8_45 g_8_45 g_8_46 4.993426e-04
Rgh_8_46 g_8_46 g_9_46 4.993426e-04
Rgv_8_46 g_8_46 g_8_47 4.993426e-04
Rgh_8_47 g_8_47 g_9_47 4.993426e-04
Rgv_8_47 g_8_47 g_8_48 4.993426e-04
Rgh_8_48 g_8_48 g_9_48 4.993426e-04
Rgv_8_48 g_8_48 g_8_49 4.993426e-04
Rgh_8_49 g_8_49 g_9_49 4.993426e-04
Rgv_8_49 g_8_49 g_8_50 4.993426e-04
Rgh_8_50 g_8_50 g_9_50 4.993426e-04
Rgv_8_50 g_8_50 g_8_51 4.993426e-04
Rgh_8_51 g_8_51 g_9_51 4.993426e-04
Rgv_8_51 g_8_51 g_8_52 4.993426e-04
Rgh_8_52 g_8_52 g_9_52 4.993426e-04
Rgv_8_52 g_8_52 g_8_53 4.993426e-04
Rgh_8_53 g_8_53 g_9_53 4.993426e-04
Rgv_8_53 g_8_53 g_8_54 4.993426e-04
Rgh_8_54 g_8_54 g_9_54 4.993426e-04
Rgv_8_54 g_8_54 g_8_55 4.993426e-04
Rgh_8_55 g_8_55 g_9_55 4.993426e-04
Rgv_8_55 g_8_55 g_8_56 4.993426e-04
Rgh_8_56 g_8_56 g_9_56 4.993426e-04
Rgv_8_56 g_8_56 g_8_57 4.993426e-04
Rgh_8_57 g_8_57 g_9_57 4.993426e-04
Rgv_8_57 g_8_57 g_8_58 4.993426e-04
Rgh_8_58 g_8_58 g_9_58 4.993426e-04
Rgv_8_58 g_8_58 g_8_59 4.993426e-04
Rgh_8_59 g_8_59 g_9_59 4.993426e-04
Rgv_8_59 g_8_59 g_8_60 4.993426e-04
Rgh_8_60 g_8_60 g_9_60 4.993426e-04
Rgv_8_60 g_8_60 g_8_61 4.993426e-04
Rgh_8_61 g_8_61 g_9_61 4.993426e-04
Rgv_8_61 g_8_61 g_8_62 4.993426e-04
Rgh_8_62 g_8_62 g_9_62 4.993426e-04
Rgv_8_62 g_8_62 g_8_63 4.993426e-04
Rgh_8_63 g_8_63 g_9_63 4.993426e-04
Rgv_8_63 g_8_63 g_8_64 4.993426e-04
Rgh_8_64 g_8_64 g_9_64 4.993426e-04
Rgv_8_64 g_8_64 g_8_65 4.993426e-04
Rgh_8_65 g_8_65 g_9_65 4.993426e-04
Rgv_8_65 g_8_65 g_8_66 4.993426e-04
Rgh_8_66 g_8_66 g_9_66 4.993426e-04
Rgv_8_66 g_8_66 g_8_67 4.993426e-04
Rgh_8_67 g_8_67 g_9_67 4.993426e-04
Rgv_8_67 g_8_67 g_8_68 4.993426e-04
Rgh_8_68 g_8_68 g_9_68 4.993426e-04
Rgv_8_68 g_8_68 g_8_69 4.993426e-04
Rgh_8_69 g_8_69 g_9_69 4.993426e-04
Rgv_8_69 g_8_69 g_8_70 4.993426e-04
Rgh_8_70 g_8_70 g_9_70 4.993426e-04
Rgv_8_70 g_8_70 g_8_71 4.993426e-04
Rgh_8_71 g_8_71 g_9_71 4.993426e-04
Rgh_9_0 g_9_0 g_10_0 4.993426e-04
Rgv_9_0 g_9_0 g_9_1 4.993426e-04
Rgh_9_1 g_9_1 g_10_1 4.993426e-04
Rgv_9_1 g_9_1 g_9_2 4.993426e-04
Rgh_9_2 g_9_2 g_10_2 4.993426e-04
Rgv_9_2 g_9_2 g_9_3 4.993426e-04
Rgh_9_3 g_9_3 g_10_3 4.993426e-04
Rgv_9_3 g_9_3 g_9_4 4.993426e-04
Rgh_9_4 g_9_4 g_10_4 4.993426e-04
Rgv_9_4 g_9_4 g_9_5 4.993426e-04
Rgh_9_5 g_9_5 g_10_5 4.993426e-04
Rgv_9_5 g_9_5 g_9_6 4.993426e-04
Rgh_9_6 g_9_6 g_10_6 4.993426e-04
Rgv_9_6 g_9_6 g_9_7 4.993426e-04
Rgh_9_7 g_9_7 g_10_7 4.993426e-04
Rgv_9_7 g_9_7 g_9_8 4.993426e-04
Rgh_9_8 g_9_8 g_10_8 4.993426e-04
Rgv_9_8 g_9_8 g_9_9 4.993426e-04
Rgh_9_9 g_9_9 g_10_9 4.993426e-04
Rgv_9_9 g_9_9 g_9_10 4.993426e-04
Rgh_9_10 g_9_10 g_10_10 4.993426e-04
Rgv_9_10 g_9_10 g_9_11 4.993426e-04
Rgh_9_11 g_9_11 g_10_11 4.993426e-04
Rgv_9_11 g_9_11 g_9_12 4.993426e-04
Rgh_9_12 g_9_12 g_10_12 4.993426e-04
Rgv_9_12 g_9_12 g_9_13 4.993426e-04
Rgh_9_13 g_9_13 g_10_13 4.993426e-04
Rgv_9_13 g_9_13 g_9_14 4.993426e-04
Rgh_9_14 g_9_14 g_10_14 4.993426e-04
Rgv_9_14 g_9_14 g_9_15 4.993426e-04
Rgh_9_15 g_9_15 g_10_15 4.993426e-04
Rgv_9_15 g_9_15 g_9_16 4.993426e-04
Rgh_9_16 g_9_16 g_10_16 4.993426e-04
Rgv_9_16 g_9_16 g_9_17 4.993426e-04
Rgh_9_17 g_9_17 g_10_17 4.993426e-04
Rgv_9_17 g_9_17 g_9_18 4.993426e-04
Rgh_9_18 g_9_18 g_10_18 4.993426e-04
Rgv_9_18 g_9_18 g_9_19 4.993426e-04
Rgh_9_19 g_9_19 g_10_19 4.993426e-04
Rgv_9_19 g_9_19 g_9_20 4.993426e-04
Rgh_9_20 g_9_20 g_10_20 4.993426e-04
Rgv_9_20 g_9_20 g_9_21 4.993426e-04
Rgh_9_21 g_9_21 g_10_21 4.993426e-04
Rgv_9_21 g_9_21 g_9_22 4.993426e-04
Rgh_9_22 g_9_22 g_10_22 4.993426e-04
Rgv_9_22 g_9_22 g_9_23 4.993426e-04
Rgh_9_23 g_9_23 g_10_23 4.993426e-04
Rgv_9_23 g_9_23 g_9_24 4.993426e-04
Rgh_9_24 g_9_24 g_10_24 4.993426e-04
Rgv_9_24 g_9_24 g_9_25 4.993426e-04
Rgh_9_25 g_9_25 g_10_25 4.993426e-04
Rgv_9_25 g_9_25 g_9_26 4.993426e-04
Rgh_9_26 g_9_26 g_10_26 4.993426e-04
Rgv_9_26 g_9_26 g_9_27 4.993426e-04
Rgh_9_27 g_9_27 g_10_27 4.993426e-04
Rgv_9_27 g_9_27 g_9_28 4.993426e-04
Rgh_9_28 g_9_28 g_10_28 4.993426e-04
Rgv_9_28 g_9_28 g_9_29 4.993426e-04
Rgh_9_29 g_9_29 g_10_29 4.993426e-04
Rgv_9_29 g_9_29 g_9_30 4.993426e-04
Rgh_9_30 g_9_30 g_10_30 4.993426e-04
Rgv_9_30 g_9_30 g_9_31 4.993426e-04
Rgh_9_31 g_9_31 g_10_31 4.993426e-04
Rgv_9_31 g_9_31 g_9_32 4.993426e-04
Rgh_9_32 g_9_32 g_10_32 4.993426e-04
Rgv_9_32 g_9_32 g_9_33 4.993426e-04
Rgh_9_33 g_9_33 g_10_33 4.993426e-04
Rgv_9_33 g_9_33 g_9_34 4.993426e-04
Rgh_9_34 g_9_34 g_10_34 4.993426e-04
Rgv_9_34 g_9_34 g_9_35 4.993426e-04
Rgh_9_35 g_9_35 g_10_35 4.993426e-04
Rgv_9_35 g_9_35 g_9_36 4.993426e-04
Rgh_9_36 g_9_36 g_10_36 4.993426e-04
Rgv_9_36 g_9_36 g_9_37 4.993426e-04
Rgh_9_37 g_9_37 g_10_37 4.993426e-04
Rgv_9_37 g_9_37 g_9_38 4.993426e-04
Rgh_9_38 g_9_38 g_10_38 4.993426e-04
Rgv_9_38 g_9_38 g_9_39 4.993426e-04
Rgh_9_39 g_9_39 g_10_39 4.993426e-04
Rgv_9_39 g_9_39 g_9_40 4.993426e-04
Rgh_9_40 g_9_40 g_10_40 4.993426e-04
Rgv_9_40 g_9_40 g_9_41 4.993426e-04
Rgh_9_41 g_9_41 g_10_41 4.993426e-04
Rgv_9_41 g_9_41 g_9_42 4.993426e-04
Rgh_9_42 g_9_42 g_10_42 4.993426e-04
Rgv_9_42 g_9_42 g_9_43 4.993426e-04
Rgh_9_43 g_9_43 g_10_43 4.993426e-04
Rgv_9_43 g_9_43 g_9_44 4.993426e-04
Rgh_9_44 g_9_44 g_10_44 4.993426e-04
Rgv_9_44 g_9_44 g_9_45 4.993426e-04
Rgh_9_45 g_9_45 g_10_45 4.993426e-04
Rgv_9_45 g_9_45 g_9_46 4.993426e-04
Rgh_9_46 g_9_46 g_10_46 4.993426e-04
Rgv_9_46 g_9_46 g_9_47 4.993426e-04
Rgh_9_47 g_9_47 g_10_47 4.993426e-04
Rgv_9_47 g_9_47 g_9_48 4.993426e-04
Rgh_9_48 g_9_48 g_10_48 4.993426e-04
Rgv_9_48 g_9_48 g_9_49 4.993426e-04
Rgh_9_49 g_9_49 g_10_49 4.993426e-04
Rgv_9_49 g_9_49 g_9_50 4.993426e-04
Rgh_9_50 g_9_50 g_10_50 4.993426e-04
Rgv_9_50 g_9_50 g_9_51 4.993426e-04
Rgh_9_51 g_9_51 g_10_51 4.993426e-04
Rgv_9_51 g_9_51 g_9_52 4.993426e-04
Rgh_9_52 g_9_52 g_10_52 4.993426e-04
Rgv_9_52 g_9_52 g_9_53 4.993426e-04
Rgh_9_53 g_9_53 g_10_53 4.993426e-04
Rgv_9_53 g_9_53 g_9_54 4.993426e-04
Rgh_9_54 g_9_54 g_10_54 4.993426e-04
Rgv_9_54 g_9_54 g_9_55 4.993426e-04
Rgh_9_55 g_9_55 g_10_55 4.993426e-04
Rgv_9_55 g_9_55 g_9_56 4.993426e-04
Rgh_9_56 g_9_56 g_10_56 4.993426e-04
Rgv_9_56 g_9_56 g_9_57 4.993426e-04
Rgh_9_57 g_9_57 g_10_57 4.993426e-04
Rgv_9_57 g_9_57 g_9_58 4.993426e-04
Rgh_9_58 g_9_58 g_10_58 4.993426e-04
Rgv_9_58 g_9_58 g_9_59 4.993426e-04
Rgh_9_59 g_9_59 g_10_59 4.993426e-04
Rgv_9_59 g_9_59 g_9_60 4.993426e-04
Rgh_9_60 g_9_60 g_10_60 4.993426e-04
Rgv_9_60 g_9_60 g_9_61 4.993426e-04
Rgh_9_61 g_9_61 g_10_61 4.993426e-04
Rgv_9_61 g_9_61 g_9_62 4.993426e-04
Rgh_9_62 g_9_62 g_10_62 4.993426e-04
Rgv_9_62 g_9_62 g_9_63 4.993426e-04
Rgh_9_63 g_9_63 g_10_63 4.993426e-04
Rgv_9_63 g_9_63 g_9_64 4.993426e-04
Rgh_9_64 g_9_64 g_10_64 4.993426e-04
Rgv_9_64 g_9_64 g_9_65 4.993426e-04
Rgh_9_65 g_9_65 g_10_65 4.993426e-04
Rgv_9_65 g_9_65 g_9_66 4.993426e-04
Rgh_9_66 g_9_66 g_10_66 4.993426e-04
Rgv_9_66 g_9_66 g_9_67 4.993426e-04
Rgh_9_67 g_9_67 g_10_67 4.993426e-04
Rgv_9_67 g_9_67 g_9_68 4.993426e-04
Rgh_9_68 g_9_68 g_10_68 4.993426e-04
Rgv_9_68 g_9_68 g_9_69 4.993426e-04
Rgh_9_69 g_9_69 g_10_69 4.993426e-04
Rgv_9_69 g_9_69 g_9_70 4.993426e-04
Rgh_9_70 g_9_70 g_10_70 4.993426e-04
Rgv_9_70 g_9_70 g_9_71 4.993426e-04
Rgh_9_71 g_9_71 g_10_71 4.993426e-04
Rgh_10_0 g_10_0 g_11_0 4.993426e-04
Rgv_10_0 g_10_0 g_10_1 4.993426e-04
Rgh_10_1 g_10_1 g_11_1 4.993426e-04
Rgv_10_1 g_10_1 g_10_2 4.993426e-04
Rgh_10_2 g_10_2 g_11_2 4.993426e-04
Rgv_10_2 g_10_2 g_10_3 4.993426e-04
Rgh_10_3 g_10_3 g_11_3 4.993426e-04
Rgv_10_3 g_10_3 g_10_4 4.993426e-04
Rgh_10_4 g_10_4 g_11_4 4.993426e-04
Rgv_10_4 g_10_4 g_10_5 4.993426e-04
Rgh_10_5 g_10_5 g_11_5 4.993426e-04
Rgv_10_5 g_10_5 g_10_6 4.993426e-04
Rgh_10_6 g_10_6 g_11_6 4.993426e-04
Rgv_10_6 g_10_6 g_10_7 4.993426e-04
Rgh_10_7 g_10_7 g_11_7 4.993426e-04
Rgv_10_7 g_10_7 g_10_8 4.993426e-04
Rgh_10_8 g_10_8 g_11_8 4.993426e-04
Rgv_10_8 g_10_8 g_10_9 4.993426e-04
Rgh_10_9 g_10_9 g_11_9 4.993426e-04
Rgv_10_9 g_10_9 g_10_10 4.993426e-04
Rgh_10_10 g_10_10 g_11_10 4.993426e-04
Rgv_10_10 g_10_10 g_10_11 4.993426e-04
Rgh_10_11 g_10_11 g_11_11 4.993426e-04
Rgv_10_11 g_10_11 g_10_12 4.993426e-04
Rgh_10_12 g_10_12 g_11_12 4.993426e-04
Rgv_10_12 g_10_12 g_10_13 4.993426e-04
Rgh_10_13 g_10_13 g_11_13 4.993426e-04
Rgv_10_13 g_10_13 g_10_14 4.993426e-04
Rgh_10_14 g_10_14 g_11_14 4.993426e-04
Rgv_10_14 g_10_14 g_10_15 4.993426e-04
Rgh_10_15 g_10_15 g_11_15 4.993426e-04
Rgv_10_15 g_10_15 g_10_16 4.993426e-04
Rgh_10_16 g_10_16 g_11_16 4.993426e-04
Rgv_10_16 g_10_16 g_10_17 4.993426e-04
Rgh_10_17 g_10_17 g_11_17 4.993426e-04
Rgv_10_17 g_10_17 g_10_18 4.993426e-04
Rgh_10_18 g_10_18 g_11_18 4.993426e-04
Rgv_10_18 g_10_18 g_10_19 4.993426e-04
Rgh_10_19 g_10_19 g_11_19 4.993426e-04
Rgv_10_19 g_10_19 g_10_20 4.993426e-04
Rgh_10_20 g_10_20 g_11_20 4.993426e-04
Rgv_10_20 g_10_20 g_10_21 4.993426e-04
Rgh_10_21 g_10_21 g_11_21 4.993426e-04
Rgv_10_21 g_10_21 g_10_22 4.993426e-04
Rgh_10_22 g_10_22 g_11_22 4.993426e-04
Rgv_10_22 g_10_22 g_10_23 4.993426e-04
Rgh_10_23 g_10_23 g_11_23 4.993426e-04
Rgv_10_23 g_10_23 g_10_24 4.993426e-04
Rgh_10_24 g_10_24 g_11_24 4.993426e-04
Rgv_10_24 g_10_24 g_10_25 4.993426e-04
Rgh_10_25 g_10_25 g_11_25 4.993426e-04
Rgv_10_25 g_10_25 g_10_26 4.993426e-04
Rgh_10_26 g_10_26 g_11_26 4.993426e-04
Rgv_10_26 g_10_26 g_10_27 4.993426e-04
Rgh_10_27 g_10_27 g_11_27 4.993426e-04
Rgv_10_27 g_10_27 g_10_28 4.993426e-04
Rgh_10_28 g_10_28 g_11_28 4.993426e-04
Rgv_10_28 g_10_28 g_10_29 4.993426e-04
Rgh_10_29 g_10_29 g_11_29 4.993426e-04
Rgv_10_29 g_10_29 g_10_30 4.993426e-04
Rgh_10_30 g_10_30 g_11_30 4.993426e-04
Rgv_10_30 g_10_30 g_10_31 4.993426e-04
Rgh_10_31 g_10_31 g_11_31 4.993426e-04
Rgv_10_31 g_10_31 g_10_32 4.993426e-04
Rgh_10_32 g_10_32 g_11_32 4.993426e-04
Rgv_10_32 g_10_32 g_10_33 4.993426e-04
Rgh_10_33 g_10_33 g_11_33 4.993426e-04
Rgv_10_33 g_10_33 g_10_34 4.993426e-04
Rgh_10_34 g_10_34 g_11_34 4.993426e-04
Rgv_10_34 g_10_34 g_10_35 4.993426e-04
Rgh_10_35 g_10_35 g_11_35 4.993426e-04
Rgv_10_35 g_10_35 g_10_36 4.993426e-04
Rgh_10_36 g_10_36 g_11_36 4.993426e-04
Rgv_10_36 g_10_36 g_10_37 4.993426e-04
Rgh_10_37 g_10_37 g_11_37 4.993426e-04
Rgv_10_37 g_10_37 g_10_38 4.993426e-04
Rgh_10_38 g_10_38 g_11_38 4.993426e-04
Rgv_10_38 g_10_38 g_10_39 4.993426e-04
Rgh_10_39 g_10_39 g_11_39 4.993426e-04
Rgv_10_39 g_10_39 g_10_40 4.993426e-04
Rgh_10_40 g_10_40 g_11_40 4.993426e-04
Rgv_10_40 g_10_40 g_10_41 4.993426e-04
Rgh_10_41 g_10_41 g_11_41 4.993426e-04
Rgv_10_41 g_10_41 g_10_42 4.993426e-04
Rgh_10_42 g_10_42 g_11_42 4.993426e-04
Rgv_10_42 g_10_42 g_10_43 4.993426e-04
Rgh_10_43 g_10_43 g_11_43 4.993426e-04
Rgv_10_43 g_10_43 g_10_44 4.993426e-04
Rgh_10_44 g_10_44 g_11_44 4.993426e-04
Rgv_10_44 g_10_44 g_10_45 4.993426e-04
Rgh_10_45 g_10_45 g_11_45 4.993426e-04
Rgv_10_45 g_10_45 g_10_46 4.993426e-04
Rgh_10_46 g_10_46 g_11_46 4.993426e-04
Rgv_10_46 g_10_46 g_10_47 4.993426e-04
Rgh_10_47 g_10_47 g_11_47 4.993426e-04
Rgv_10_47 g_10_47 g_10_48 4.993426e-04
Rgh_10_48 g_10_48 g_11_48 4.993426e-04
Rgv_10_48 g_10_48 g_10_49 4.993426e-04
Rgh_10_49 g_10_49 g_11_49 4.993426e-04
Rgv_10_49 g_10_49 g_10_50 4.993426e-04
Rgh_10_50 g_10_50 g_11_50 4.993426e-04
Rgv_10_50 g_10_50 g_10_51 4.993426e-04
Rgh_10_51 g_10_51 g_11_51 4.993426e-04
Rgv_10_51 g_10_51 g_10_52 4.993426e-04
Rgh_10_52 g_10_52 g_11_52 4.993426e-04
Rgv_10_52 g_10_52 g_10_53 4.993426e-04
Rgh_10_53 g_10_53 g_11_53 4.993426e-04
Rgv_10_53 g_10_53 g_10_54 4.993426e-04
Rgh_10_54 g_10_54 g_11_54 4.993426e-04
Rgv_10_54 g_10_54 g_10_55 4.993426e-04
Rgh_10_55 g_10_55 g_11_55 4.993426e-04
Rgv_10_55 g_10_55 g_10_56 4.993426e-04
Rgh_10_56 g_10_56 g_11_56 4.993426e-04
Rgv_10_56 g_10_56 g_10_57 4.993426e-04
Rgh_10_57 g_10_57 g_11_57 4.993426e-04
Rgv_10_57 g_10_57 g_10_58 4.993426e-04
Rgh_10_58 g_10_58 g_11_58 4.993426e-04
Rgv_10_58 g_10_58 g_10_59 4.993426e-04
Rgh_10_59 g_10_59 g_11_59 4.993426e-04
Rgv_10_59 g_10_59 g_10_60 4.993426e-04
Rgh_10_60 g_10_60 g_11_60 4.993426e-04
Rgv_10_60 g_10_60 g_10_61 4.993426e-04
Rgh_10_61 g_10_61 g_11_61 4.993426e-04
Rgv_10_61 g_10_61 g_10_62 4.993426e-04
Rgh_10_62 g_10_62 g_11_62 4.993426e-04
Rgv_10_62 g_10_62 g_10_63 4.993426e-04
Rgh_10_63 g_10_63 g_11_63 4.993426e-04
Rgv_10_63 g_10_63 g_10_64 4.993426e-04
Rgh_10_64 g_10_64 g_11_64 4.993426e-04
Rgv_10_64 g_10_64 g_10_65 4.993426e-04
Rgh_10_65 g_10_65 g_11_65 4.993426e-04
Rgv_10_65 g_10_65 g_10_66 4.993426e-04
Rgh_10_66 g_10_66 g_11_66 4.993426e-04
Rgv_10_66 g_10_66 g_10_67 4.993426e-04
Rgh_10_67 g_10_67 g_11_67 4.993426e-04
Rgv_10_67 g_10_67 g_10_68 4.993426e-04
Rgh_10_68 g_10_68 g_11_68 4.993426e-04
Rgv_10_68 g_10_68 g_10_69 4.993426e-04
Rgh_10_69 g_10_69 g_11_69 4.993426e-04
Rgv_10_69 g_10_69 g_10_70 4.993426e-04
Rgh_10_70 g_10_70 g_11_70 4.993426e-04
Rgv_10_70 g_10_70 g_10_71 4.993426e-04
Rgh_10_71 g_10_71 g_11_71 4.993426e-04
Rgh_11_0 g_11_0 g_12_0 4.993426e-04
Rgv_11_0 g_11_0 g_11_1 4.993426e-04
Rgh_11_1 g_11_1 g_12_1 4.993426e-04
Rgv_11_1 g_11_1 g_11_2 4.993426e-04
Rgh_11_2 g_11_2 g_12_2 4.993426e-04
Rgv_11_2 g_11_2 g_11_3 4.993426e-04
Rgh_11_3 g_11_3 g_12_3 4.993426e-04
Rgv_11_3 g_11_3 g_11_4 4.993426e-04
Rgh_11_4 g_11_4 g_12_4 4.993426e-04
Rgv_11_4 g_11_4 g_11_5 4.993426e-04
Rgh_11_5 g_11_5 g_12_5 4.993426e-04
Rgv_11_5 g_11_5 g_11_6 4.993426e-04
Rgh_11_6 g_11_6 g_12_6 4.993426e-04
Rgv_11_6 g_11_6 g_11_7 4.993426e-04
Rgh_11_7 g_11_7 g_12_7 4.993426e-04
Rgv_11_7 g_11_7 g_11_8 4.993426e-04
Rgh_11_8 g_11_8 g_12_8 4.993426e-04
Rgv_11_8 g_11_8 g_11_9 4.993426e-04
Rgh_11_9 g_11_9 g_12_9 4.993426e-04
Rgv_11_9 g_11_9 g_11_10 4.993426e-04
Rgh_11_10 g_11_10 g_12_10 4.993426e-04
Rgv_11_10 g_11_10 g_11_11 4.993426e-04
Rgh_11_11 g_11_11 g_12_11 4.993426e-04
Rgv_11_11 g_11_11 g_11_12 4.993426e-04
Rgh_11_12 g_11_12 g_12_12 4.993426e-04
Rgv_11_12 g_11_12 g_11_13 4.993426e-04
Rgh_11_13 g_11_13 g_12_13 4.993426e-04
Rgv_11_13 g_11_13 g_11_14 4.993426e-04
Rgh_11_14 g_11_14 g_12_14 4.993426e-04
Rgv_11_14 g_11_14 g_11_15 4.993426e-04
Rgh_11_15 g_11_15 g_12_15 4.993426e-04
Rgv_11_15 g_11_15 g_11_16 4.993426e-04
Rgh_11_16 g_11_16 g_12_16 4.993426e-04
Rgv_11_16 g_11_16 g_11_17 4.993426e-04
Rgh_11_17 g_11_17 g_12_17 4.993426e-04
Rgv_11_17 g_11_17 g_11_18 4.993426e-04
Rgh_11_18 g_11_18 g_12_18 4.993426e-04
Rgv_11_18 g_11_18 g_11_19 4.993426e-04
Rgh_11_19 g_11_19 g_12_19 4.993426e-04
Rgv_11_19 g_11_19 g_11_20 4.993426e-04
Rgh_11_20 g_11_20 g_12_20 4.993426e-04
Rgv_11_20 g_11_20 g_11_21 4.993426e-04
Rgh_11_21 g_11_21 g_12_21 4.993426e-04
Rgv_11_21 g_11_21 g_11_22 4.993426e-04
Rgh_11_22 g_11_22 g_12_22 4.993426e-04
Rgv_11_22 g_11_22 g_11_23 4.993426e-04
Rgh_11_23 g_11_23 g_12_23 4.993426e-04
Rgv_11_23 g_11_23 g_11_24 4.993426e-04
Rgh_11_24 g_11_24 g_12_24 4.993426e-04
Rgv_11_24 g_11_24 g_11_25 4.993426e-04
Rgh_11_25 g_11_25 g_12_25 4.993426e-04
Rgv_11_25 g_11_25 g_11_26 4.993426e-04
Rgh_11_26 g_11_26 g_12_26 4.993426e-04
Rgv_11_26 g_11_26 g_11_27 4.993426e-04
Rgh_11_27 g_11_27 g_12_27 4.993426e-04
Rgv_11_27 g_11_27 g_11_28 4.993426e-04
Rgh_11_28 g_11_28 g_12_28 4.993426e-04
Rgv_11_28 g_11_28 g_11_29 4.993426e-04
Rgh_11_29 g_11_29 g_12_29 4.993426e-04
Rgv_11_29 g_11_29 g_11_30 4.993426e-04
Rgh_11_30 g_11_30 g_12_30 4.993426e-04
Rgv_11_30 g_11_30 g_11_31 4.993426e-04
Rgh_11_31 g_11_31 g_12_31 4.993426e-04
Rgv_11_31 g_11_31 g_11_32 4.993426e-04
Rgh_11_32 g_11_32 g_12_32 4.993426e-04
Rgv_11_32 g_11_32 g_11_33 4.993426e-04
Rgh_11_33 g_11_33 g_12_33 4.993426e-04
Rgv_11_33 g_11_33 g_11_34 4.993426e-04
Rgh_11_34 g_11_34 g_12_34 4.993426e-04
Rgv_11_34 g_11_34 g_11_35 4.993426e-04
Rgh_11_35 g_11_35 g_12_35 4.993426e-04
Rgv_11_35 g_11_35 g_11_36 4.993426e-04
Rgh_11_36 g_11_36 g_12_36 4.993426e-04
Rgv_11_36 g_11_36 g_11_37 4.993426e-04
Rgh_11_37 g_11_37 g_12_37 4.993426e-04
Rgv_11_37 g_11_37 g_11_38 4.993426e-04
Rgh_11_38 g_11_38 g_12_38 4.993426e-04
Rgv_11_38 g_11_38 g_11_39 4.993426e-04
Rgh_11_39 g_11_39 g_12_39 4.993426e-04
Rgv_11_39 g_11_39 g_11_40 4.993426e-04
Rgh_11_40 g_11_40 g_12_40 4.993426e-04
Rgv_11_40 g_11_40 g_11_41 4.993426e-04
Rgh_11_41 g_11_41 g_12_41 4.993426e-04
Rgv_11_41 g_11_41 g_11_42 4.993426e-04
Rgh_11_42 g_11_42 g_12_42 4.993426e-04
Rgv_11_42 g_11_42 g_11_43 4.993426e-04
Rgh_11_43 g_11_43 g_12_43 4.993426e-04
Rgv_11_43 g_11_43 g_11_44 4.993426e-04
Rgh_11_44 g_11_44 g_12_44 4.993426e-04
Rgv_11_44 g_11_44 g_11_45 4.993426e-04
Rgh_11_45 g_11_45 g_12_45 4.993426e-04
Rgv_11_45 g_11_45 g_11_46 4.993426e-04
Rgh_11_46 g_11_46 g_12_46 4.993426e-04
Rgv_11_46 g_11_46 g_11_47 4.993426e-04
Rgh_11_47 g_11_47 g_12_47 4.993426e-04
Rgv_11_47 g_11_47 g_11_48 4.993426e-04
Rgh_11_48 g_11_48 g_12_48 4.993426e-04
Rgv_11_48 g_11_48 g_11_49 4.993426e-04
Rgh_11_49 g_11_49 g_12_49 4.993426e-04
Rgv_11_49 g_11_49 g_11_50 4.993426e-04
Rgh_11_50 g_11_50 g_12_50 4.993426e-04
Rgv_11_50 g_11_50 g_11_51 4.993426e-04
Rgh_11_51 g_11_51 g_12_51 4.993426e-04
Rgv_11_51 g_11_51 g_11_52 4.993426e-04
Rgh_11_52 g_11_52 g_12_52 4.993426e-04
Rgv_11_52 g_11_52 g_11_53 4.993426e-04
Rgh_11_53 g_11_53 g_12_53 4.993426e-04
Rgv_11_53 g_11_53 g_11_54 4.993426e-04
Rgh_11_54 g_11_54 g_12_54 4.993426e-04
Rgv_11_54 g_11_54 g_11_55 4.993426e-04
Rgh_11_55 g_11_55 g_12_55 4.993426e-04
Rgv_11_55 g_11_55 g_11_56 4.993426e-04
Rgh_11_56 g_11_56 g_12_56 4.993426e-04
Rgv_11_56 g_11_56 g_11_57 4.993426e-04
Rgh_11_57 g_11_57 g_12_57 4.993426e-04
Rgv_11_57 g_11_57 g_11_58 4.993426e-04
Rgh_11_58 g_11_58 g_12_58 4.993426e-04
Rgv_11_58 g_11_58 g_11_59 4.993426e-04
Rgh_11_59 g_11_59 g_12_59 4.993426e-04
Rgv_11_59 g_11_59 g_11_60 4.993426e-04
Rgh_11_60 g_11_60 g_12_60 4.993426e-04
Rgv_11_60 g_11_60 g_11_61 4.993426e-04
Rgh_11_61 g_11_61 g_12_61 4.993426e-04
Rgv_11_61 g_11_61 g_11_62 4.993426e-04
Rgh_11_62 g_11_62 g_12_62 4.993426e-04
Rgv_11_62 g_11_62 g_11_63 4.993426e-04
Rgh_11_63 g_11_63 g_12_63 4.993426e-04
Rgv_11_63 g_11_63 g_11_64 4.993426e-04
Rgh_11_64 g_11_64 g_12_64 4.993426e-04
Rgv_11_64 g_11_64 g_11_65 4.993426e-04
Rgh_11_65 g_11_65 g_12_65 4.993426e-04
Rgv_11_65 g_11_65 g_11_66 4.993426e-04
Rgh_11_66 g_11_66 g_12_66 4.993426e-04
Rgv_11_66 g_11_66 g_11_67 4.993426e-04
Rgh_11_67 g_11_67 g_12_67 4.993426e-04
Rgv_11_67 g_11_67 g_11_68 4.993426e-04
Rgh_11_68 g_11_68 g_12_68 4.993426e-04
Rgv_11_68 g_11_68 g_11_69 4.993426e-04
Rgh_11_69 g_11_69 g_12_69 4.993426e-04
Rgv_11_69 g_11_69 g_11_70 4.993426e-04
Rgh_11_70 g_11_70 g_12_70 4.993426e-04
Rgv_11_70 g_11_70 g_11_71 4.993426e-04
Rgh_11_71 g_11_71 g_12_71 4.993426e-04
Rgh_12_0 g_12_0 g_13_0 4.993426e-04
Rgv_12_0 g_12_0 g_12_1 4.993426e-04
Rgh_12_1 g_12_1 g_13_1 4.993426e-04
Rgv_12_1 g_12_1 g_12_2 4.993426e-04
Rgh_12_2 g_12_2 g_13_2 4.993426e-04
Rgv_12_2 g_12_2 g_12_3 4.993426e-04
Rgh_12_3 g_12_3 g_13_3 4.993426e-04
Rgv_12_3 g_12_3 g_12_4 4.993426e-04
Rgh_12_4 g_12_4 g_13_4 4.993426e-04
Rgv_12_4 g_12_4 g_12_5 4.993426e-04
Rgh_12_5 g_12_5 g_13_5 4.993426e-04
Rgv_12_5 g_12_5 g_12_6 4.993426e-04
Rgh_12_6 g_12_6 g_13_6 4.993426e-04
Rgv_12_6 g_12_6 g_12_7 4.993426e-04
Rgh_12_7 g_12_7 g_13_7 4.993426e-04
Rgv_12_7 g_12_7 g_12_8 4.993426e-04
Rgh_12_8 g_12_8 g_13_8 4.993426e-04
Rgv_12_8 g_12_8 g_12_9 4.993426e-04
Rgh_12_9 g_12_9 g_13_9 4.993426e-04
Rgv_12_9 g_12_9 g_12_10 4.993426e-04
Rgh_12_10 g_12_10 g_13_10 4.993426e-04
Rgv_12_10 g_12_10 g_12_11 4.993426e-04
Rgh_12_11 g_12_11 g_13_11 4.993426e-04
Rgv_12_11 g_12_11 g_12_12 4.993426e-04
Rgh_12_12 g_12_12 g_13_12 4.993426e-04
Rgv_12_12 g_12_12 g_12_13 4.993426e-04
Rgh_12_13 g_12_13 g_13_13 4.993426e-04
Rgv_12_13 g_12_13 g_12_14 4.993426e-04
Rgh_12_14 g_12_14 g_13_14 4.993426e-04
Rgv_12_14 g_12_14 g_12_15 4.993426e-04
Rgh_12_15 g_12_15 g_13_15 4.993426e-04
Rgv_12_15 g_12_15 g_12_16 4.993426e-04
Rgh_12_16 g_12_16 g_13_16 4.993426e-04
Rgv_12_16 g_12_16 g_12_17 4.993426e-04
Rgh_12_17 g_12_17 g_13_17 4.993426e-04
Rgv_12_17 g_12_17 g_12_18 4.993426e-04
Rgh_12_18 g_12_18 g_13_18 4.993426e-04
Rgv_12_18 g_12_18 g_12_19 4.993426e-04
Rgh_12_19 g_12_19 g_13_19 4.993426e-04
Rgv_12_19 g_12_19 g_12_20 4.993426e-04
Rgh_12_20 g_12_20 g_13_20 4.993426e-04
Rgv_12_20 g_12_20 g_12_21 4.993426e-04
Rgh_12_21 g_12_21 g_13_21 4.993426e-04
Rgv_12_21 g_12_21 g_12_22 4.993426e-04
Rgh_12_22 g_12_22 g_13_22 4.993426e-04
Rgv_12_22 g_12_22 g_12_23 4.993426e-04
Rgh_12_23 g_12_23 g_13_23 4.993426e-04
Rgv_12_23 g_12_23 g_12_24 4.993426e-04
Rgh_12_24 g_12_24 g_13_24 4.993426e-04
Rgv_12_24 g_12_24 g_12_25 4.993426e-04
Rgh_12_25 g_12_25 g_13_25 4.993426e-04
Rgv_12_25 g_12_25 g_12_26 4.993426e-04
Rgh_12_26 g_12_26 g_13_26 4.993426e-04
Rgv_12_26 g_12_26 g_12_27 4.993426e-04
Rgh_12_27 g_12_27 g_13_27 4.993426e-04
Rgv_12_27 g_12_27 g_12_28 4.993426e-04
Rgh_12_28 g_12_28 g_13_28 4.993426e-04
Rgv_12_28 g_12_28 g_12_29 4.993426e-04
Rgh_12_29 g_12_29 g_13_29 4.993426e-04
Rgv_12_29 g_12_29 g_12_30 4.993426e-04
Rgh_12_30 g_12_30 g_13_30 4.993426e-04
Rgv_12_30 g_12_30 g_12_31 4.993426e-04
Rgh_12_31 g_12_31 g_13_31 4.993426e-04
Rgv_12_31 g_12_31 g_12_32 4.993426e-04
Rgh_12_32 g_12_32 g_13_32 4.993426e-04
Rgv_12_32 g_12_32 g_12_33 4.993426e-04
Rgh_12_33 g_12_33 g_13_33 4.993426e-04
Rgv_12_33 g_12_33 g_12_34 4.993426e-04
Rgh_12_34 g_12_34 g_13_34 4.993426e-04
Rgv_12_34 g_12_34 g_12_35 4.993426e-04
Rgh_12_35 g_12_35 g_13_35 4.993426e-04
Rgv_12_35 g_12_35 g_12_36 4.993426e-04
Rgh_12_36 g_12_36 g_13_36 4.993426e-04
Rgv_12_36 g_12_36 g_12_37 4.993426e-04
Rgh_12_37 g_12_37 g_13_37 4.993426e-04
Rgv_12_37 g_12_37 g_12_38 4.993426e-04
Rgh_12_38 g_12_38 g_13_38 4.993426e-04
Rgv_12_38 g_12_38 g_12_39 4.993426e-04
Rgh_12_39 g_12_39 g_13_39 4.993426e-04
Rgv_12_39 g_12_39 g_12_40 4.993426e-04
Rgh_12_40 g_12_40 g_13_40 4.993426e-04
Rgv_12_40 g_12_40 g_12_41 4.993426e-04
Rgh_12_41 g_12_41 g_13_41 4.993426e-04
Rgv_12_41 g_12_41 g_12_42 4.993426e-04
Rgh_12_42 g_12_42 g_13_42 4.993426e-04
Rgv_12_42 g_12_42 g_12_43 4.993426e-04
Rgh_12_43 g_12_43 g_13_43 4.993426e-04
Rgv_12_43 g_12_43 g_12_44 4.993426e-04
Rgh_12_44 g_12_44 g_13_44 4.993426e-04
Rgv_12_44 g_12_44 g_12_45 4.993426e-04
Rgh_12_45 g_12_45 g_13_45 4.993426e-04
Rgv_12_45 g_12_45 g_12_46 4.993426e-04
Rgh_12_46 g_12_46 g_13_46 4.993426e-04
Rgv_12_46 g_12_46 g_12_47 4.993426e-04
Rgh_12_47 g_12_47 g_13_47 4.993426e-04
Rgv_12_47 g_12_47 g_12_48 4.993426e-04
Rgh_12_48 g_12_48 g_13_48 4.993426e-04
Rgv_12_48 g_12_48 g_12_49 4.993426e-04
Rgh_12_49 g_12_49 g_13_49 4.993426e-04
Rgv_12_49 g_12_49 g_12_50 4.993426e-04
Rgh_12_50 g_12_50 g_13_50 4.993426e-04
Rgv_12_50 g_12_50 g_12_51 4.993426e-04
Rgh_12_51 g_12_51 g_13_51 4.993426e-04
Rgv_12_51 g_12_51 g_12_52 4.993426e-04
Rgh_12_52 g_12_52 g_13_52 4.993426e-04
Rgv_12_52 g_12_52 g_12_53 4.993426e-04
Rgh_12_53 g_12_53 g_13_53 4.993426e-04
Rgv_12_53 g_12_53 g_12_54 4.993426e-04
Rgh_12_54 g_12_54 g_13_54 4.993426e-04
Rgv_12_54 g_12_54 g_12_55 4.993426e-04
Rgh_12_55 g_12_55 g_13_55 4.993426e-04
Rgv_12_55 g_12_55 g_12_56 4.993426e-04
Rgh_12_56 g_12_56 g_13_56 4.993426e-04
Rgv_12_56 g_12_56 g_12_57 4.993426e-04
Rgh_12_57 g_12_57 g_13_57 4.993426e-04
Rgv_12_57 g_12_57 g_12_58 4.993426e-04
Rgh_12_58 g_12_58 g_13_58 4.993426e-04
Rgv_12_58 g_12_58 g_12_59 4.993426e-04
Rgh_12_59 g_12_59 g_13_59 4.993426e-04
Rgv_12_59 g_12_59 g_12_60 4.993426e-04
Rgh_12_60 g_12_60 g_13_60 4.993426e-04
Rgv_12_60 g_12_60 g_12_61 4.993426e-04
Rgh_12_61 g_12_61 g_13_61 4.993426e-04
Rgv_12_61 g_12_61 g_12_62 4.993426e-04
Rgh_12_62 g_12_62 g_13_62 4.993426e-04
Rgv_12_62 g_12_62 g_12_63 4.993426e-04
Rgh_12_63 g_12_63 g_13_63 4.993426e-04
Rgv_12_63 g_12_63 g_12_64 4.993426e-04
Rgh_12_64 g_12_64 g_13_64 4.993426e-04
Rgv_12_64 g_12_64 g_12_65 4.993426e-04
Rgh_12_65 g_12_65 g_13_65 4.993426e-04
Rgv_12_65 g_12_65 g_12_66 4.993426e-04
Rgh_12_66 g_12_66 g_13_66 4.993426e-04
Rgv_12_66 g_12_66 g_12_67 4.993426e-04
Rgh_12_67 g_12_67 g_13_67 4.993426e-04
Rgv_12_67 g_12_67 g_12_68 4.993426e-04
Rgh_12_68 g_12_68 g_13_68 4.993426e-04
Rgv_12_68 g_12_68 g_12_69 4.993426e-04
Rgh_12_69 g_12_69 g_13_69 4.993426e-04
Rgv_12_69 g_12_69 g_12_70 4.993426e-04
Rgh_12_70 g_12_70 g_13_70 4.993426e-04
Rgv_12_70 g_12_70 g_12_71 4.993426e-04
Rgh_12_71 g_12_71 g_13_71 4.993426e-04
Rgh_13_0 g_13_0 g_14_0 4.993426e-04
Rgv_13_0 g_13_0 g_13_1 4.993426e-04
Rgh_13_1 g_13_1 g_14_1 4.993426e-04
Rgv_13_1 g_13_1 g_13_2 4.993426e-04
Rgh_13_2 g_13_2 g_14_2 4.993426e-04
Rgv_13_2 g_13_2 g_13_3 4.993426e-04
Rgh_13_3 g_13_3 g_14_3 4.993426e-04
Rgv_13_3 g_13_3 g_13_4 4.993426e-04
Rgh_13_4 g_13_4 g_14_4 4.993426e-04
Rgv_13_4 g_13_4 g_13_5 4.993426e-04
Rgh_13_5 g_13_5 g_14_5 4.993426e-04
Rgv_13_5 g_13_5 g_13_6 4.993426e-04
Rgh_13_6 g_13_6 g_14_6 4.993426e-04
Rgv_13_6 g_13_6 g_13_7 4.993426e-04
Rgh_13_7 g_13_7 g_14_7 4.993426e-04
Rgv_13_7 g_13_7 g_13_8 4.993426e-04
Rgh_13_8 g_13_8 g_14_8 4.993426e-04
Rgv_13_8 g_13_8 g_13_9 4.993426e-04
Rgh_13_9 g_13_9 g_14_9 4.993426e-04
Rgv_13_9 g_13_9 g_13_10 4.993426e-04
Rgh_13_10 g_13_10 g_14_10 4.993426e-04
Rgv_13_10 g_13_10 g_13_11 4.993426e-04
Rgh_13_11 g_13_11 g_14_11 4.993426e-04
Rgv_13_11 g_13_11 g_13_12 4.993426e-04
Rgh_13_12 g_13_12 g_14_12 4.993426e-04
Rgv_13_12 g_13_12 g_13_13 4.993426e-04
Rgh_13_13 g_13_13 g_14_13 4.993426e-04
Rgv_13_13 g_13_13 g_13_14 4.993426e-04
Rgh_13_14 g_13_14 g_14_14 4.993426e-04
Rgv_13_14 g_13_14 g_13_15 4.993426e-04
Rgh_13_15 g_13_15 g_14_15 4.993426e-04
Rgv_13_15 g_13_15 g_13_16 4.993426e-04
Rgh_13_16 g_13_16 g_14_16 4.993426e-04
Rgv_13_16 g_13_16 g_13_17 4.993426e-04
Rgh_13_17 g_13_17 g_14_17 4.993426e-04
Rgv_13_17 g_13_17 g_13_18 4.993426e-04
Rgh_13_18 g_13_18 g_14_18 4.993426e-04
Rgv_13_18 g_13_18 g_13_19 4.993426e-04
Rgh_13_19 g_13_19 g_14_19 4.993426e-04
Rgv_13_19 g_13_19 g_13_20 4.993426e-04
Rgh_13_20 g_13_20 g_14_20 4.993426e-04
Rgv_13_20 g_13_20 g_13_21 4.993426e-04
Rgh_13_21 g_13_21 g_14_21 4.993426e-04
Rgv_13_21 g_13_21 g_13_22 4.993426e-04
Rgh_13_22 g_13_22 g_14_22 4.993426e-04
Rgv_13_22 g_13_22 g_13_23 4.993426e-04
Rgh_13_23 g_13_23 g_14_23 4.993426e-04
Rgv_13_23 g_13_23 g_13_24 4.993426e-04
Rgh_13_24 g_13_24 g_14_24 4.993426e-04
Rgv_13_24 g_13_24 g_13_25 4.993426e-04
Rgh_13_25 g_13_25 g_14_25 4.993426e-04
Rgv_13_25 g_13_25 g_13_26 4.993426e-04
Rgh_13_26 g_13_26 g_14_26 4.993426e-04
Rgv_13_26 g_13_26 g_13_27 4.993426e-04
Rgh_13_27 g_13_27 g_14_27 4.993426e-04
Rgv_13_27 g_13_27 g_13_28 4.993426e-04
Rgh_13_28 g_13_28 g_14_28 4.993426e-04
Rgv_13_28 g_13_28 g_13_29 4.993426e-04
Rgh_13_29 g_13_29 g_14_29 4.993426e-04
Rgv_13_29 g_13_29 g_13_30 4.993426e-04
Rgh_13_30 g_13_30 g_14_30 4.993426e-04
Rgv_13_30 g_13_30 g_13_31 4.993426e-04
Rgh_13_31 g_13_31 g_14_31 4.993426e-04
Rgv_13_31 g_13_31 g_13_32 4.993426e-04
Rgh_13_32 g_13_32 g_14_32 4.993426e-04
Rgv_13_32 g_13_32 g_13_33 4.993426e-04
Rgh_13_33 g_13_33 g_14_33 4.993426e-04
Rgv_13_33 g_13_33 g_13_34 4.993426e-04
Rgh_13_34 g_13_34 g_14_34 4.993426e-04
Rgv_13_34 g_13_34 g_13_35 4.993426e-04
Rgh_13_35 g_13_35 g_14_35 4.993426e-04
Rgv_13_35 g_13_35 g_13_36 4.993426e-04
Rgh_13_36 g_13_36 g_14_36 4.993426e-04
Rgv_13_36 g_13_36 g_13_37 4.993426e-04
Rgh_13_37 g_13_37 g_14_37 4.993426e-04
Rgv_13_37 g_13_37 g_13_38 4.993426e-04
Rgh_13_38 g_13_38 g_14_38 4.993426e-04
Rgv_13_38 g_13_38 g_13_39 4.993426e-04
Rgh_13_39 g_13_39 g_14_39 4.993426e-04
Rgv_13_39 g_13_39 g_13_40 4.993426e-04
Rgh_13_40 g_13_40 g_14_40 4.993426e-04
Rgv_13_40 g_13_40 g_13_41 4.993426e-04
Rgh_13_41 g_13_41 g_14_41 4.993426e-04
Rgv_13_41 g_13_41 g_13_42 4.993426e-04
Rgh_13_42 g_13_42 g_14_42 4.993426e-04
Rgv_13_42 g_13_42 g_13_43 4.993426e-04
Rgh_13_43 g_13_43 g_14_43 4.993426e-04
Rgv_13_43 g_13_43 g_13_44 4.993426e-04
Rgh_13_44 g_13_44 g_14_44 4.993426e-04
Rgv_13_44 g_13_44 g_13_45 4.993426e-04
Rgh_13_45 g_13_45 g_14_45 4.993426e-04
Rgv_13_45 g_13_45 g_13_46 4.993426e-04
Rgh_13_46 g_13_46 g_14_46 4.993426e-04
Rgv_13_46 g_13_46 g_13_47 4.993426e-04
Rgh_13_47 g_13_47 g_14_47 4.993426e-04
Rgv_13_47 g_13_47 g_13_48 4.993426e-04
Rgh_13_48 g_13_48 g_14_48 4.993426e-04
Rgv_13_48 g_13_48 g_13_49 4.993426e-04
Rgh_13_49 g_13_49 g_14_49 4.993426e-04
Rgv_13_49 g_13_49 g_13_50 4.993426e-04
Rgh_13_50 g_13_50 g_14_50 4.993426e-04
Rgv_13_50 g_13_50 g_13_51 4.993426e-04
Rgh_13_51 g_13_51 g_14_51 4.993426e-04
Rgv_13_51 g_13_51 g_13_52 4.993426e-04
Rgh_13_52 g_13_52 g_14_52 4.993426e-04
Rgv_13_52 g_13_52 g_13_53 4.993426e-04
Rgh_13_53 g_13_53 g_14_53 4.993426e-04
Rgv_13_53 g_13_53 g_13_54 4.993426e-04
Rgh_13_54 g_13_54 g_14_54 4.993426e-04
Rgv_13_54 g_13_54 g_13_55 4.993426e-04
Rgh_13_55 g_13_55 g_14_55 4.993426e-04
Rgv_13_55 g_13_55 g_13_56 4.993426e-04
Rgh_13_56 g_13_56 g_14_56 4.993426e-04
Rgv_13_56 g_13_56 g_13_57 4.993426e-04
Rgh_13_57 g_13_57 g_14_57 4.993426e-04
Rgv_13_57 g_13_57 g_13_58 4.993426e-04
Rgh_13_58 g_13_58 g_14_58 4.993426e-04
Rgv_13_58 g_13_58 g_13_59 4.993426e-04
Rgh_13_59 g_13_59 g_14_59 4.993426e-04
Rgv_13_59 g_13_59 g_13_60 4.993426e-04
Rgh_13_60 g_13_60 g_14_60 4.993426e-04
Rgv_13_60 g_13_60 g_13_61 4.993426e-04
Rgh_13_61 g_13_61 g_14_61 4.993426e-04
Rgv_13_61 g_13_61 g_13_62 4.993426e-04
Rgh_13_62 g_13_62 g_14_62 4.993426e-04
Rgv_13_62 g_13_62 g_13_63 4.993426e-04
Rgh_13_63 g_13_63 g_14_63 4.993426e-04
Rgv_13_63 g_13_63 g_13_64 4.993426e-04
Rgh_13_64 g_13_64 g_14_64 4.993426e-04
Rgv_13_64 g_13_64 g_13_65 4.993426e-04
Rgh_13_65 g_13_65 g_14_65 4.993426e-04
Rgv_13_65 g_13_65 g_13_66 4.993426e-04
Rgh_13_66 g_13_66 g_14_66 4.993426e-04
Rgv_13_66 g_13_66 g_13_67 4.993426e-04
Rgh_13_67 g_13_67 g_14_67 4.993426e-04
Rgv_13_67 g_13_67 g_13_68 4.993426e-04
Rgh_13_68 g_13_68 g_14_68 4.993426e-04
Rgv_13_68 g_13_68 g_13_69 4.993426e-04
Rgh_13_69 g_13_69 g_14_69 4.993426e-04
Rgv_13_69 g_13_69 g_13_70 4.993426e-04
Rgh_13_70 g_13_70 g_14_70 4.993426e-04
Rgv_13_70 g_13_70 g_13_71 4.993426e-04
Rgh_13_71 g_13_71 g_14_71 4.993426e-04
Rgh_14_0 g_14_0 g_15_0 4.993426e-04
Rgv_14_0 g_14_0 g_14_1 4.993426e-04
Rgh_14_1 g_14_1 g_15_1 4.993426e-04
Rgv_14_1 g_14_1 g_14_2 4.993426e-04
Rgh_14_2 g_14_2 g_15_2 4.993426e-04
Rgv_14_2 g_14_2 g_14_3 4.993426e-04
Rgh_14_3 g_14_3 g_15_3 4.993426e-04
Rgv_14_3 g_14_3 g_14_4 4.993426e-04
Rgh_14_4 g_14_4 g_15_4 4.993426e-04
Rgv_14_4 g_14_4 g_14_5 4.993426e-04
Rgh_14_5 g_14_5 g_15_5 4.993426e-04
Rgv_14_5 g_14_5 g_14_6 4.993426e-04
Rgh_14_6 g_14_6 g_15_6 4.993426e-04
Rgv_14_6 g_14_6 g_14_7 4.993426e-04
Rgh_14_7 g_14_7 g_15_7 4.993426e-04
Rgv_14_7 g_14_7 g_14_8 4.993426e-04
Rgh_14_8 g_14_8 g_15_8 4.993426e-04
Rgv_14_8 g_14_8 g_14_9 4.993426e-04
Rgh_14_9 g_14_9 g_15_9 4.993426e-04
Rgv_14_9 g_14_9 g_14_10 4.993426e-04
Rgh_14_10 g_14_10 g_15_10 4.993426e-04
Rgv_14_10 g_14_10 g_14_11 4.993426e-04
Rgh_14_11 g_14_11 g_15_11 4.993426e-04
Rgv_14_11 g_14_11 g_14_12 4.993426e-04
Rgh_14_12 g_14_12 g_15_12 4.993426e-04
Rgv_14_12 g_14_12 g_14_13 4.993426e-04
Rgh_14_13 g_14_13 g_15_13 4.993426e-04
Rgv_14_13 g_14_13 g_14_14 4.993426e-04
Rgh_14_14 g_14_14 g_15_14 4.993426e-04
Rgv_14_14 g_14_14 g_14_15 4.993426e-04
Rgh_14_15 g_14_15 g_15_15 4.993426e-04
Rgv_14_15 g_14_15 g_14_16 4.993426e-04
Rgh_14_16 g_14_16 g_15_16 4.993426e-04
Rgv_14_16 g_14_16 g_14_17 4.993426e-04
Rgh_14_17 g_14_17 g_15_17 4.993426e-04
Rgv_14_17 g_14_17 g_14_18 4.993426e-04
Rgh_14_18 g_14_18 g_15_18 4.993426e-04
Rgv_14_18 g_14_18 g_14_19 4.993426e-04
Rgh_14_19 g_14_19 g_15_19 4.993426e-04
Rgv_14_19 g_14_19 g_14_20 4.993426e-04
Rgh_14_20 g_14_20 g_15_20 4.993426e-04
Rgv_14_20 g_14_20 g_14_21 4.993426e-04
Rgh_14_21 g_14_21 g_15_21 4.993426e-04
Rgv_14_21 g_14_21 g_14_22 4.993426e-04
Rgh_14_22 g_14_22 g_15_22 4.993426e-04
Rgv_14_22 g_14_22 g_14_23 4.993426e-04
Rgh_14_23 g_14_23 g_15_23 4.993426e-04
Rgv_14_23 g_14_23 g_14_24 4.993426e-04
Rgh_14_24 g_14_24 g_15_24 4.993426e-04
Rgv_14_24 g_14_24 g_14_25 4.993426e-04
Rgh_14_25 g_14_25 g_15_25 4.993426e-04
Rgv_14_25 g_14_25 g_14_26 4.993426e-04
Rgh_14_26 g_14_26 g_15_26 4.993426e-04
Rgv_14_26 g_14_26 g_14_27 4.993426e-04
Rgh_14_27 g_14_27 g_15_27 4.993426e-04
Rgv_14_27 g_14_27 g_14_28 4.993426e-04
Rgh_14_28 g_14_28 g_15_28 4.993426e-04
Rgv_14_28 g_14_28 g_14_29 4.993426e-04
Rgh_14_29 g_14_29 g_15_29 4.993426e-04
Rgv_14_29 g_14_29 g_14_30 4.993426e-04
Rgh_14_30 g_14_30 g_15_30 4.993426e-04
Rgv_14_30 g_14_30 g_14_31 4.993426e-04
Rgh_14_31 g_14_31 g_15_31 4.993426e-04
Rgv_14_31 g_14_31 g_14_32 4.993426e-04
Rgh_14_32 g_14_32 g_15_32 4.993426e-04
Rgv_14_32 g_14_32 g_14_33 4.993426e-04
Rgh_14_33 g_14_33 g_15_33 4.993426e-04
Rgv_14_33 g_14_33 g_14_34 4.993426e-04
Rgh_14_34 g_14_34 g_15_34 4.993426e-04
Rgv_14_34 g_14_34 g_14_35 4.993426e-04
Rgh_14_35 g_14_35 g_15_35 4.993426e-04
Rgv_14_35 g_14_35 g_14_36 4.993426e-04
Rgh_14_36 g_14_36 g_15_36 4.993426e-04
Rgv_14_36 g_14_36 g_14_37 4.993426e-04
Rgh_14_37 g_14_37 g_15_37 4.993426e-04
Rgv_14_37 g_14_37 g_14_38 4.993426e-04
Rgh_14_38 g_14_38 g_15_38 4.993426e-04
Rgv_14_38 g_14_38 g_14_39 4.993426e-04
Rgh_14_39 g_14_39 g_15_39 4.993426e-04
Rgv_14_39 g_14_39 g_14_40 4.993426e-04
Rgh_14_40 g_14_40 g_15_40 4.993426e-04
Rgv_14_40 g_14_40 g_14_41 4.993426e-04
Rgh_14_41 g_14_41 g_15_41 4.993426e-04
Rgv_14_41 g_14_41 g_14_42 4.993426e-04
Rgh_14_42 g_14_42 g_15_42 4.993426e-04
Rgv_14_42 g_14_42 g_14_43 4.993426e-04
Rgh_14_43 g_14_43 g_15_43 4.993426e-04
Rgv_14_43 g_14_43 g_14_44 4.993426e-04
Rgh_14_44 g_14_44 g_15_44 4.993426e-04
Rgv_14_44 g_14_44 g_14_45 4.993426e-04
Rgh_14_45 g_14_45 g_15_45 4.993426e-04
Rgv_14_45 g_14_45 g_14_46 4.993426e-04
Rgh_14_46 g_14_46 g_15_46 4.993426e-04
Rgv_14_46 g_14_46 g_14_47 4.993426e-04
Rgh_14_47 g_14_47 g_15_47 4.993426e-04
Rgv_14_47 g_14_47 g_14_48 4.993426e-04
Rgh_14_48 g_14_48 g_15_48 4.993426e-04
Rgv_14_48 g_14_48 g_14_49 4.993426e-04
Rgh_14_49 g_14_49 g_15_49 4.993426e-04
Rgv_14_49 g_14_49 g_14_50 4.993426e-04
Rgh_14_50 g_14_50 g_15_50 4.993426e-04
Rgv_14_50 g_14_50 g_14_51 4.993426e-04
Rgh_14_51 g_14_51 g_15_51 4.993426e-04
Rgv_14_51 g_14_51 g_14_52 4.993426e-04
Rgh_14_52 g_14_52 g_15_52 4.993426e-04
Rgv_14_52 g_14_52 g_14_53 4.993426e-04
Rgh_14_53 g_14_53 g_15_53 4.993426e-04
Rgv_14_53 g_14_53 g_14_54 4.993426e-04
Rgh_14_54 g_14_54 g_15_54 4.993426e-04
Rgv_14_54 g_14_54 g_14_55 4.993426e-04
Rgh_14_55 g_14_55 g_15_55 4.993426e-04
Rgv_14_55 g_14_55 g_14_56 4.993426e-04
Rgh_14_56 g_14_56 g_15_56 4.993426e-04
Rgv_14_56 g_14_56 g_14_57 4.993426e-04
Rgh_14_57 g_14_57 g_15_57 4.993426e-04
Rgv_14_57 g_14_57 g_14_58 4.993426e-04
Rgh_14_58 g_14_58 g_15_58 4.993426e-04
Rgv_14_58 g_14_58 g_14_59 4.993426e-04
Rgh_14_59 g_14_59 g_15_59 4.993426e-04
Rgv_14_59 g_14_59 g_14_60 4.993426e-04
Rgh_14_60 g_14_60 g_15_60 4.993426e-04
Rgv_14_60 g_14_60 g_14_61 4.993426e-04
Rgh_14_61 g_14_61 g_15_61 4.993426e-04
Rgv_14_61 g_14_61 g_14_62 4.993426e-04
Rgh_14_62 g_14_62 g_15_62 4.993426e-04
Rgv_14_62 g_14_62 g_14_63 4.993426e-04
Rgh_14_63 g_14_63 g_15_63 4.993426e-04
Rgv_14_63 g_14_63 g_14_64 4.993426e-04
Rgh_14_64 g_14_64 g_15_64 4.993426e-04
Rgv_14_64 g_14_64 g_14_65 4.993426e-04
Rgh_14_65 g_14_65 g_15_65 4.993426e-04
Rgv_14_65 g_14_65 g_14_66 4.993426e-04
Rgh_14_66 g_14_66 g_15_66 4.993426e-04
Rgv_14_66 g_14_66 g_14_67 4.993426e-04
Rgh_14_67 g_14_67 g_15_67 4.993426e-04
Rgv_14_67 g_14_67 g_14_68 4.993426e-04
Rgh_14_68 g_14_68 g_15_68 4.993426e-04
Rgv_14_68 g_14_68 g_14_69 4.993426e-04
Rgh_14_69 g_14_69 g_15_69 4.993426e-04
Rgv_14_69 g_14_69 g_14_70 4.993426e-04
Rgh_14_70 g_14_70 g_15_70 4.993426e-04
Rgv_14_70 g_14_70 g_14_71 4.993426e-04
Rgh_14_71 g_14_71 g_15_71 4.993426e-04
Rgh_15_0 g_15_0 g_16_0 4.993426e-04
Rgv_15_0 g_15_0 g_15_1 4.993426e-04
Rgh_15_1 g_15_1 g_16_1 4.993426e-04
Rgv_15_1 g_15_1 g_15_2 4.993426e-04
Rgh_15_2 g_15_2 g_16_2 4.993426e-04
Rgv_15_2 g_15_2 g_15_3 4.993426e-04
Rgh_15_3 g_15_3 g_16_3 4.993426e-04
Rgv_15_3 g_15_3 g_15_4 4.993426e-04
Rgh_15_4 g_15_4 g_16_4 4.993426e-04
Rgv_15_4 g_15_4 g_15_5 4.993426e-04
Rgh_15_5 g_15_5 g_16_5 4.993426e-04
Rgv_15_5 g_15_5 g_15_6 4.993426e-04
Rgh_15_6 g_15_6 g_16_6 4.993426e-04
Rgv_15_6 g_15_6 g_15_7 4.993426e-04
Rgh_15_7 g_15_7 g_16_7 4.993426e-04
Rgv_15_7 g_15_7 g_15_8 4.993426e-04
Rgh_15_8 g_15_8 g_16_8 4.993426e-04
Rgv_15_8 g_15_8 g_15_9 4.993426e-04
Rgh_15_9 g_15_9 g_16_9 4.993426e-04
Rgv_15_9 g_15_9 g_15_10 4.993426e-04
Rgh_15_10 g_15_10 g_16_10 4.993426e-04
Rgv_15_10 g_15_10 g_15_11 4.993426e-04
Rgh_15_11 g_15_11 g_16_11 4.993426e-04
Rgv_15_11 g_15_11 g_15_12 4.993426e-04
Rgh_15_12 g_15_12 g_16_12 4.993426e-04
Rgv_15_12 g_15_12 g_15_13 4.993426e-04
Rgh_15_13 g_15_13 g_16_13 4.993426e-04
Rgv_15_13 g_15_13 g_15_14 4.993426e-04
Rgh_15_14 g_15_14 g_16_14 4.993426e-04
Rgv_15_14 g_15_14 g_15_15 4.993426e-04
Rgh_15_15 g_15_15 g_16_15 4.993426e-04
Rgv_15_15 g_15_15 g_15_16 4.993426e-04
Rgh_15_16 g_15_16 g_16_16 4.993426e-04
Rgv_15_16 g_15_16 g_15_17 4.993426e-04
Rgh_15_17 g_15_17 g_16_17 4.993426e-04
Rgv_15_17 g_15_17 g_15_18 4.993426e-04
Rgh_15_18 g_15_18 g_16_18 4.993426e-04
Rgv_15_18 g_15_18 g_15_19 4.993426e-04
Rgh_15_19 g_15_19 g_16_19 4.993426e-04
Rgv_15_19 g_15_19 g_15_20 4.993426e-04
Rgh_15_20 g_15_20 g_16_20 4.993426e-04
Rgv_15_20 g_15_20 g_15_21 4.993426e-04
Rgh_15_21 g_15_21 g_16_21 4.993426e-04
Rgv_15_21 g_15_21 g_15_22 4.993426e-04
Rgh_15_22 g_15_22 g_16_22 4.993426e-04
Rgv_15_22 g_15_22 g_15_23 4.993426e-04
Rgh_15_23 g_15_23 g_16_23 4.993426e-04
Rgv_15_23 g_15_23 g_15_24 4.993426e-04
Rgh_15_24 g_15_24 g_16_24 4.993426e-04
Rgv_15_24 g_15_24 g_15_25 4.993426e-04
Rgh_15_25 g_15_25 g_16_25 4.993426e-04
Rgv_15_25 g_15_25 g_15_26 4.993426e-04
Rgh_15_26 g_15_26 g_16_26 4.993426e-04
Rgv_15_26 g_15_26 g_15_27 4.993426e-04
Rgh_15_27 g_15_27 g_16_27 4.993426e-04
Rgv_15_27 g_15_27 g_15_28 4.993426e-04
Rgh_15_28 g_15_28 g_16_28 4.993426e-04
Rgv_15_28 g_15_28 g_15_29 4.993426e-04
Rgh_15_29 g_15_29 g_16_29 4.993426e-04
Rgv_15_29 g_15_29 g_15_30 4.993426e-04
Rgh_15_30 g_15_30 g_16_30 4.993426e-04
Rgv_15_30 g_15_30 g_15_31 4.993426e-04
Rgh_15_31 g_15_31 g_16_31 4.993426e-04
Rgv_15_31 g_15_31 g_15_32 4.993426e-04
Rgh_15_32 g_15_32 g_16_32 4.993426e-04
Rgv_15_32 g_15_32 g_15_33 4.993426e-04
Rgh_15_33 g_15_33 g_16_33 4.993426e-04
Rgv_15_33 g_15_33 g_15_34 4.993426e-04
Rgh_15_34 g_15_34 g_16_34 4.993426e-04
Rgv_15_34 g_15_34 g_15_35 4.993426e-04
Rgh_15_35 g_15_35 g_16_35 4.993426e-04
Rgv_15_35 g_15_35 g_15_36 4.993426e-04
Rgh_15_36 g_15_36 g_16_36 4.993426e-04
Rgv_15_36 g_15_36 g_15_37 4.993426e-04
Rgh_15_37 g_15_37 g_16_37 4.993426e-04
Rgv_15_37 g_15_37 g_15_38 4.993426e-04
Rgh_15_38 g_15_38 g_16_38 4.993426e-04
Rgv_15_38 g_15_38 g_15_39 4.993426e-04
Rgh_15_39 g_15_39 g_16_39 4.993426e-04
Rgv_15_39 g_15_39 g_15_40 4.993426e-04
Rgh_15_40 g_15_40 g_16_40 4.993426e-04
Rgv_15_40 g_15_40 g_15_41 4.993426e-04
Rgh_15_41 g_15_41 g_16_41 4.993426e-04
Rgv_15_41 g_15_41 g_15_42 4.993426e-04
Rgh_15_42 g_15_42 g_16_42 4.993426e-04
Rgv_15_42 g_15_42 g_15_43 4.993426e-04
Rgh_15_43 g_15_43 g_16_43 4.993426e-04
Rgv_15_43 g_15_43 g_15_44 4.993426e-04
Rgh_15_44 g_15_44 g_16_44 4.993426e-04
Rgv_15_44 g_15_44 g_15_45 4.993426e-04
Rgh_15_45 g_15_45 g_16_45 4.993426e-04
Rgv_15_45 g_15_45 g_15_46 4.993426e-04
Rgh_15_46 g_15_46 g_16_46 4.993426e-04
Rgv_15_46 g_15_46 g_15_47 4.993426e-04
Rgh_15_47 g_15_47 g_16_47 4.993426e-04
Rgv_15_47 g_15_47 g_15_48 4.993426e-04
Rgh_15_48 g_15_48 g_16_48 4.993426e-04
Rgv_15_48 g_15_48 g_15_49 4.993426e-04
Rgh_15_49 g_15_49 g_16_49 4.993426e-04
Rgv_15_49 g_15_49 g_15_50 4.993426e-04
Rgh_15_50 g_15_50 g_16_50 4.993426e-04
Rgv_15_50 g_15_50 g_15_51 4.993426e-04
Rgh_15_51 g_15_51 g_16_51 4.993426e-04
Rgv_15_51 g_15_51 g_15_52 4.993426e-04
Rgh_15_52 g_15_52 g_16_52 4.993426e-04
Rgv_15_52 g_15_52 g_15_53 4.993426e-04
Rgh_15_53 g_15_53 g_16_53 4.993426e-04
Rgv_15_53 g_15_53 g_15_54 4.993426e-04
Rgh_15_54 g_15_54 g_16_54 4.993426e-04
Rgv_15_54 g_15_54 g_15_55 4.993426e-04
Rgh_15_55 g_15_55 g_16_55 4.993426e-04
Rgv_15_55 g_15_55 g_15_56 4.993426e-04
Rgh_15_56 g_15_56 g_16_56 4.993426e-04
Rgv_15_56 g_15_56 g_15_57 4.993426e-04
Rgh_15_57 g_15_57 g_16_57 4.993426e-04
Rgv_15_57 g_15_57 g_15_58 4.993426e-04
Rgh_15_58 g_15_58 g_16_58 4.993426e-04
Rgv_15_58 g_15_58 g_15_59 4.993426e-04
Rgh_15_59 g_15_59 g_16_59 4.993426e-04
Rgv_15_59 g_15_59 g_15_60 4.993426e-04
Rgh_15_60 g_15_60 g_16_60 4.993426e-04
Rgv_15_60 g_15_60 g_15_61 4.993426e-04
Rgh_15_61 g_15_61 g_16_61 4.993426e-04
Rgv_15_61 g_15_61 g_15_62 4.993426e-04
Rgh_15_62 g_15_62 g_16_62 4.993426e-04
Rgv_15_62 g_15_62 g_15_63 4.993426e-04
Rgh_15_63 g_15_63 g_16_63 4.993426e-04
Rgv_15_63 g_15_63 g_15_64 4.993426e-04
Rgh_15_64 g_15_64 g_16_64 4.993426e-04
Rgv_15_64 g_15_64 g_15_65 4.993426e-04
Rgh_15_65 g_15_65 g_16_65 4.993426e-04
Rgv_15_65 g_15_65 g_15_66 4.993426e-04
Rgh_15_66 g_15_66 g_16_66 4.993426e-04
Rgv_15_66 g_15_66 g_15_67 4.993426e-04
Rgh_15_67 g_15_67 g_16_67 4.993426e-04
Rgv_15_67 g_15_67 g_15_68 4.993426e-04
Rgh_15_68 g_15_68 g_16_68 4.993426e-04
Rgv_15_68 g_15_68 g_15_69 4.993426e-04
Rgh_15_69 g_15_69 g_16_69 4.993426e-04
Rgv_15_69 g_15_69 g_15_70 4.993426e-04
Rgh_15_70 g_15_70 g_16_70 4.993426e-04
Rgv_15_70 g_15_70 g_15_71 4.993426e-04
Rgh_15_71 g_15_71 g_16_71 4.993426e-04
Rgh_16_0 g_16_0 g_17_0 4.993426e-04
Rgv_16_0 g_16_0 g_16_1 4.993426e-04
Rgh_16_1 g_16_1 g_17_1 4.993426e-04
Rgv_16_1 g_16_1 g_16_2 4.993426e-04
Rgh_16_2 g_16_2 g_17_2 4.993426e-04
Rgv_16_2 g_16_2 g_16_3 4.993426e-04
Rgh_16_3 g_16_3 g_17_3 4.993426e-04
Rgv_16_3 g_16_3 g_16_4 4.993426e-04
Rgh_16_4 g_16_4 g_17_4 4.993426e-04
Rgv_16_4 g_16_4 g_16_5 4.993426e-04
Rgh_16_5 g_16_5 g_17_5 4.993426e-04
Rgv_16_5 g_16_5 g_16_6 4.993426e-04
Rgh_16_6 g_16_6 g_17_6 4.993426e-04
Rgv_16_6 g_16_6 g_16_7 4.993426e-04
Rgh_16_7 g_16_7 g_17_7 4.993426e-04
Rgv_16_7 g_16_7 g_16_8 4.993426e-04
Rgh_16_8 g_16_8 g_17_8 4.993426e-04
Rgv_16_8 g_16_8 g_16_9 4.993426e-04
Rgh_16_9 g_16_9 g_17_9 4.993426e-04
Rgv_16_9 g_16_9 g_16_10 4.993426e-04
Rgh_16_10 g_16_10 g_17_10 4.993426e-04
Rgv_16_10 g_16_10 g_16_11 4.993426e-04
Rgh_16_11 g_16_11 g_17_11 4.993426e-04
Rgv_16_11 g_16_11 g_16_12 4.993426e-04
Rgh_16_12 g_16_12 g_17_12 4.993426e-04
Rgv_16_12 g_16_12 g_16_13 4.993426e-04
Rgh_16_13 g_16_13 g_17_13 4.993426e-04
Rgv_16_13 g_16_13 g_16_14 4.993426e-04
Rgh_16_14 g_16_14 g_17_14 4.993426e-04
Rgv_16_14 g_16_14 g_16_15 4.993426e-04
Rgh_16_15 g_16_15 g_17_15 4.993426e-04
Rgv_16_15 g_16_15 g_16_16 4.993426e-04
Rgh_16_16 g_16_16 g_17_16 4.993426e-04
Rgv_16_16 g_16_16 g_16_17 4.993426e-04
Rgh_16_17 g_16_17 g_17_17 4.993426e-04
Rgv_16_17 g_16_17 g_16_18 4.993426e-04
Rgh_16_18 g_16_18 g_17_18 4.993426e-04
Rgv_16_18 g_16_18 g_16_19 4.993426e-04
Rgh_16_19 g_16_19 g_17_19 4.993426e-04
Rgv_16_19 g_16_19 g_16_20 4.993426e-04
Rgh_16_20 g_16_20 g_17_20 4.993426e-04
Rgv_16_20 g_16_20 g_16_21 4.993426e-04
Rgh_16_21 g_16_21 g_17_21 4.993426e-04
Rgv_16_21 g_16_21 g_16_22 4.993426e-04
Rgh_16_22 g_16_22 g_17_22 4.993426e-04
Rgv_16_22 g_16_22 g_16_23 4.993426e-04
Rgh_16_23 g_16_23 g_17_23 4.993426e-04
Rgv_16_23 g_16_23 g_16_24 4.993426e-04
Rgh_16_24 g_16_24 g_17_24 4.993426e-04
Rgv_16_24 g_16_24 g_16_25 4.993426e-04
Rgh_16_25 g_16_25 g_17_25 4.993426e-04
Rgv_16_25 g_16_25 g_16_26 4.993426e-04
Rgh_16_26 g_16_26 g_17_26 4.993426e-04
Rgv_16_26 g_16_26 g_16_27 4.993426e-04
Rgh_16_27 g_16_27 g_17_27 4.993426e-04
Rgv_16_27 g_16_27 g_16_28 4.993426e-04
Rgh_16_28 g_16_28 g_17_28 4.993426e-04
Rgv_16_28 g_16_28 g_16_29 4.993426e-04
Rgh_16_29 g_16_29 g_17_29 4.993426e-04
Rgv_16_29 g_16_29 g_16_30 4.993426e-04
Rgh_16_30 g_16_30 g_17_30 4.993426e-04
Rgv_16_30 g_16_30 g_16_31 4.993426e-04
Rgh_16_31 g_16_31 g_17_31 4.993426e-04
Rgv_16_31 g_16_31 g_16_32 4.993426e-04
Rgh_16_32 g_16_32 g_17_32 4.993426e-04
Rgv_16_32 g_16_32 g_16_33 4.993426e-04
Rgh_16_33 g_16_33 g_17_33 4.993426e-04
Rgv_16_33 g_16_33 g_16_34 4.993426e-04
Rgh_16_34 g_16_34 g_17_34 4.993426e-04
Rgv_16_34 g_16_34 g_16_35 4.993426e-04
Rgh_16_35 g_16_35 g_17_35 4.993426e-04
Rgv_16_35 g_16_35 g_16_36 4.993426e-04
Rgh_16_36 g_16_36 g_17_36 4.993426e-04
Rgv_16_36 g_16_36 g_16_37 4.993426e-04
Rgh_16_37 g_16_37 g_17_37 4.993426e-04
Rgv_16_37 g_16_37 g_16_38 4.993426e-04
Rgh_16_38 g_16_38 g_17_38 4.993426e-04
Rgv_16_38 g_16_38 g_16_39 4.993426e-04
Rgh_16_39 g_16_39 g_17_39 4.993426e-04
Rgv_16_39 g_16_39 g_16_40 4.993426e-04
Rgh_16_40 g_16_40 g_17_40 4.993426e-04
Rgv_16_40 g_16_40 g_16_41 4.993426e-04
Rgh_16_41 g_16_41 g_17_41 4.993426e-04
Rgv_16_41 g_16_41 g_16_42 4.993426e-04
Rgh_16_42 g_16_42 g_17_42 4.993426e-04
Rgv_16_42 g_16_42 g_16_43 4.993426e-04
Rgh_16_43 g_16_43 g_17_43 4.993426e-04
Rgv_16_43 g_16_43 g_16_44 4.993426e-04
Rgh_16_44 g_16_44 g_17_44 4.993426e-04
Rgv_16_44 g_16_44 g_16_45 4.993426e-04
Rgh_16_45 g_16_45 g_17_45 4.993426e-04
Rgv_16_45 g_16_45 g_16_46 4.993426e-04
Rgh_16_46 g_16_46 g_17_46 4.993426e-04
Rgv_16_46 g_16_46 g_16_47 4.993426e-04
Rgh_16_47 g_16_47 g_17_47 4.993426e-04
Rgv_16_47 g_16_47 g_16_48 4.993426e-04
Rgh_16_48 g_16_48 g_17_48 4.993426e-04
Rgv_16_48 g_16_48 g_16_49 4.993426e-04
Rgh_16_49 g_16_49 g_17_49 4.993426e-04
Rgv_16_49 g_16_49 g_16_50 4.993426e-04
Rgh_16_50 g_16_50 g_17_50 4.993426e-04
Rgv_16_50 g_16_50 g_16_51 4.993426e-04
Rgh_16_51 g_16_51 g_17_51 4.993426e-04
Rgv_16_51 g_16_51 g_16_52 4.993426e-04
Rgh_16_52 g_16_52 g_17_52 4.993426e-04
Rgv_16_52 g_16_52 g_16_53 4.993426e-04
Rgh_16_53 g_16_53 g_17_53 4.993426e-04
Rgv_16_53 g_16_53 g_16_54 4.993426e-04
Rgh_16_54 g_16_54 g_17_54 4.993426e-04
Rgv_16_54 g_16_54 g_16_55 4.993426e-04
Rgh_16_55 g_16_55 g_17_55 4.993426e-04
Rgv_16_55 g_16_55 g_16_56 4.993426e-04
Rgh_16_56 g_16_56 g_17_56 4.993426e-04
Rgv_16_56 g_16_56 g_16_57 4.993426e-04
Rgh_16_57 g_16_57 g_17_57 4.993426e-04
Rgv_16_57 g_16_57 g_16_58 4.993426e-04
Rgh_16_58 g_16_58 g_17_58 4.993426e-04
Rgv_16_58 g_16_58 g_16_59 4.993426e-04
Rgh_16_59 g_16_59 g_17_59 4.993426e-04
Rgv_16_59 g_16_59 g_16_60 4.993426e-04
Rgh_16_60 g_16_60 g_17_60 4.993426e-04
Rgv_16_60 g_16_60 g_16_61 4.993426e-04
Rgh_16_61 g_16_61 g_17_61 4.993426e-04
Rgv_16_61 g_16_61 g_16_62 4.993426e-04
Rgh_16_62 g_16_62 g_17_62 4.993426e-04
Rgv_16_62 g_16_62 g_16_63 4.993426e-04
Rgh_16_63 g_16_63 g_17_63 4.993426e-04
Rgv_16_63 g_16_63 g_16_64 4.993426e-04
Rgh_16_64 g_16_64 g_17_64 4.993426e-04
Rgv_16_64 g_16_64 g_16_65 4.993426e-04
Rgh_16_65 g_16_65 g_17_65 4.993426e-04
Rgv_16_65 g_16_65 g_16_66 4.993426e-04
Rgh_16_66 g_16_66 g_17_66 4.993426e-04
Rgv_16_66 g_16_66 g_16_67 4.993426e-04
Rgh_16_67 g_16_67 g_17_67 4.993426e-04
Rgv_16_67 g_16_67 g_16_68 4.993426e-04
Rgh_16_68 g_16_68 g_17_68 4.993426e-04
Rgv_16_68 g_16_68 g_16_69 4.993426e-04
Rgh_16_69 g_16_69 g_17_69 4.993426e-04
Rgv_16_69 g_16_69 g_16_70 4.993426e-04
Rgh_16_70 g_16_70 g_17_70 4.993426e-04
Rgv_16_70 g_16_70 g_16_71 4.993426e-04
Rgh_16_71 g_16_71 g_17_71 4.993426e-04
Rgh_17_0 g_17_0 g_18_0 4.993426e-04
Rgv_17_0 g_17_0 g_17_1 4.993426e-04
Rgh_17_1 g_17_1 g_18_1 4.993426e-04
Rgv_17_1 g_17_1 g_17_2 4.993426e-04
Rgh_17_2 g_17_2 g_18_2 4.993426e-04
Rgv_17_2 g_17_2 g_17_3 4.993426e-04
Rgh_17_3 g_17_3 g_18_3 4.993426e-04
Rgv_17_3 g_17_3 g_17_4 4.993426e-04
Rgh_17_4 g_17_4 g_18_4 4.993426e-04
Rgv_17_4 g_17_4 g_17_5 4.993426e-04
Rgh_17_5 g_17_5 g_18_5 4.993426e-04
Rgv_17_5 g_17_5 g_17_6 4.993426e-04
Rgh_17_6 g_17_6 g_18_6 4.993426e-04
Rgv_17_6 g_17_6 g_17_7 4.993426e-04
Rgh_17_7 g_17_7 g_18_7 4.993426e-04
Rgv_17_7 g_17_7 g_17_8 4.993426e-04
Rgh_17_8 g_17_8 g_18_8 4.993426e-04
Rgv_17_8 g_17_8 g_17_9 4.993426e-04
Rgh_17_9 g_17_9 g_18_9 4.993426e-04
Rgv_17_9 g_17_9 g_17_10 4.993426e-04
Rgh_17_10 g_17_10 g_18_10 4.993426e-04
Rgv_17_10 g_17_10 g_17_11 4.993426e-04
Rgh_17_11 g_17_11 g_18_11 4.993426e-04
Rgv_17_11 g_17_11 g_17_12 4.993426e-04
Rgh_17_12 g_17_12 g_18_12 4.993426e-04
Rgv_17_12 g_17_12 g_17_13 4.993426e-04
Rgh_17_13 g_17_13 g_18_13 4.993426e-04
Rgv_17_13 g_17_13 g_17_14 4.993426e-04
Rgh_17_14 g_17_14 g_18_14 4.993426e-04
Rgv_17_14 g_17_14 g_17_15 4.993426e-04
Rgh_17_15 g_17_15 g_18_15 4.993426e-04
Rgv_17_15 g_17_15 g_17_16 4.993426e-04
Rgh_17_16 g_17_16 g_18_16 4.993426e-04
Rgv_17_16 g_17_16 g_17_17 4.993426e-04
Rgh_17_17 g_17_17 g_18_17 4.993426e-04
Rgv_17_17 g_17_17 g_17_18 4.993426e-04
Rgh_17_18 g_17_18 g_18_18 4.993426e-04
Rgv_17_18 g_17_18 g_17_19 4.993426e-04
Rgh_17_19 g_17_19 g_18_19 4.993426e-04
Rgv_17_19 g_17_19 g_17_20 4.993426e-04
Rgh_17_20 g_17_20 g_18_20 4.993426e-04
Rgv_17_20 g_17_20 g_17_21 4.993426e-04
Rgh_17_21 g_17_21 g_18_21 4.993426e-04
Rgv_17_21 g_17_21 g_17_22 4.993426e-04
Rgh_17_22 g_17_22 g_18_22 4.993426e-04
Rgv_17_22 g_17_22 g_17_23 4.993426e-04
Rgh_17_23 g_17_23 g_18_23 4.993426e-04
Rgv_17_23 g_17_23 g_17_24 4.993426e-04
Rgh_17_24 g_17_24 g_18_24 4.993426e-04
Rgv_17_24 g_17_24 g_17_25 4.993426e-04
Rgh_17_25 g_17_25 g_18_25 4.993426e-04
Rgv_17_25 g_17_25 g_17_26 4.993426e-04
Rgh_17_26 g_17_26 g_18_26 4.993426e-04
Rgv_17_26 g_17_26 g_17_27 4.993426e-04
Rgh_17_27 g_17_27 g_18_27 4.993426e-04
Rgv_17_27 g_17_27 g_17_28 4.993426e-04
Rgh_17_28 g_17_28 g_18_28 4.993426e-04
Rgv_17_28 g_17_28 g_17_29 4.993426e-04
Rgh_17_29 g_17_29 g_18_29 4.993426e-04
Rgv_17_29 g_17_29 g_17_30 4.993426e-04
Rgh_17_30 g_17_30 g_18_30 4.993426e-04
Rgv_17_30 g_17_30 g_17_31 4.993426e-04
Rgh_17_31 g_17_31 g_18_31 4.993426e-04
Rgv_17_31 g_17_31 g_17_32 4.993426e-04
Rgh_17_32 g_17_32 g_18_32 4.993426e-04
Rgv_17_32 g_17_32 g_17_33 4.993426e-04
Rgh_17_33 g_17_33 g_18_33 4.993426e-04
Rgv_17_33 g_17_33 g_17_34 4.993426e-04
Rgh_17_34 g_17_34 g_18_34 4.993426e-04
Rgv_17_34 g_17_34 g_17_35 4.993426e-04
Rgh_17_35 g_17_35 g_18_35 4.993426e-04
Rgv_17_35 g_17_35 g_17_36 4.993426e-04
Rgh_17_36 g_17_36 g_18_36 4.993426e-04
Rgv_17_36 g_17_36 g_17_37 4.993426e-04
Rgh_17_37 g_17_37 g_18_37 4.993426e-04
Rgv_17_37 g_17_37 g_17_38 4.993426e-04
Rgh_17_38 g_17_38 g_18_38 4.993426e-04
Rgv_17_38 g_17_38 g_17_39 4.993426e-04
Rgh_17_39 g_17_39 g_18_39 4.993426e-04
Rgv_17_39 g_17_39 g_17_40 4.993426e-04
Rgh_17_40 g_17_40 g_18_40 4.993426e-04
Rgv_17_40 g_17_40 g_17_41 4.993426e-04
Rgh_17_41 g_17_41 g_18_41 4.993426e-04
Rgv_17_41 g_17_41 g_17_42 4.993426e-04
Rgh_17_42 g_17_42 g_18_42 4.993426e-04
Rgv_17_42 g_17_42 g_17_43 4.993426e-04
Rgh_17_43 g_17_43 g_18_43 4.993426e-04
Rgv_17_43 g_17_43 g_17_44 4.993426e-04
Rgh_17_44 g_17_44 g_18_44 4.993426e-04
Rgv_17_44 g_17_44 g_17_45 4.993426e-04
Rgh_17_45 g_17_45 g_18_45 4.993426e-04
Rgv_17_45 g_17_45 g_17_46 4.993426e-04
Rgh_17_46 g_17_46 g_18_46 4.993426e-04
Rgv_17_46 g_17_46 g_17_47 4.993426e-04
Rgh_17_47 g_17_47 g_18_47 4.993426e-04
Rgv_17_47 g_17_47 g_17_48 4.993426e-04
Rgh_17_48 g_17_48 g_18_48 4.993426e-04
Rgv_17_48 g_17_48 g_17_49 4.993426e-04
Rgh_17_49 g_17_49 g_18_49 4.993426e-04
Rgv_17_49 g_17_49 g_17_50 4.993426e-04
Rgh_17_50 g_17_50 g_18_50 4.993426e-04
Rgv_17_50 g_17_50 g_17_51 4.993426e-04
Rgh_17_51 g_17_51 g_18_51 4.993426e-04
Rgv_17_51 g_17_51 g_17_52 4.993426e-04
Rgh_17_52 g_17_52 g_18_52 4.993426e-04
Rgv_17_52 g_17_52 g_17_53 4.993426e-04
Rgh_17_53 g_17_53 g_18_53 4.993426e-04
Rgv_17_53 g_17_53 g_17_54 4.993426e-04
Rgh_17_54 g_17_54 g_18_54 4.993426e-04
Rgv_17_54 g_17_54 g_17_55 4.993426e-04
Rgh_17_55 g_17_55 g_18_55 4.993426e-04
Rgv_17_55 g_17_55 g_17_56 4.993426e-04
Rgh_17_56 g_17_56 g_18_56 4.993426e-04
Rgv_17_56 g_17_56 g_17_57 4.993426e-04
Rgh_17_57 g_17_57 g_18_57 4.993426e-04
Rgv_17_57 g_17_57 g_17_58 4.993426e-04
Rgh_17_58 g_17_58 g_18_58 4.993426e-04
Rgv_17_58 g_17_58 g_17_59 4.993426e-04
Rgh_17_59 g_17_59 g_18_59 4.993426e-04
Rgv_17_59 g_17_59 g_17_60 4.993426e-04
Rgh_17_60 g_17_60 g_18_60 4.993426e-04
Rgv_17_60 g_17_60 g_17_61 4.993426e-04
Rgh_17_61 g_17_61 g_18_61 4.993426e-04
Rgv_17_61 g_17_61 g_17_62 4.993426e-04
Rgh_17_62 g_17_62 g_18_62 4.993426e-04
Rgv_17_62 g_17_62 g_17_63 4.993426e-04
Rgh_17_63 g_17_63 g_18_63 4.993426e-04
Rgv_17_63 g_17_63 g_17_64 4.993426e-04
Rgh_17_64 g_17_64 g_18_64 4.993426e-04
Rgv_17_64 g_17_64 g_17_65 4.993426e-04
Rgh_17_65 g_17_65 g_18_65 4.993426e-04
Rgv_17_65 g_17_65 g_17_66 4.993426e-04
Rgh_17_66 g_17_66 g_18_66 4.993426e-04
Rgv_17_66 g_17_66 g_17_67 4.993426e-04
Rgh_17_67 g_17_67 g_18_67 4.993426e-04
Rgv_17_67 g_17_67 g_17_68 4.993426e-04
Rgh_17_68 g_17_68 g_18_68 4.993426e-04
Rgv_17_68 g_17_68 g_17_69 4.993426e-04
Rgh_17_69 g_17_69 g_18_69 4.993426e-04
Rgv_17_69 g_17_69 g_17_70 4.993426e-04
Rgh_17_70 g_17_70 g_18_70 4.993426e-04
Rgv_17_70 g_17_70 g_17_71 4.993426e-04
Rgh_17_71 g_17_71 g_18_71 4.993426e-04
Rgh_18_0 g_18_0 g_19_0 4.993426e-04
Rgv_18_0 g_18_0 g_18_1 4.993426e-04
Rgh_18_1 g_18_1 g_19_1 4.993426e-04
Rgv_18_1 g_18_1 g_18_2 4.993426e-04
Rgh_18_2 g_18_2 g_19_2 4.993426e-04
Rgv_18_2 g_18_2 g_18_3 4.993426e-04
Rgh_18_3 g_18_3 g_19_3 4.993426e-04
Rgv_18_3 g_18_3 g_18_4 4.993426e-04
Rgh_18_4 g_18_4 g_19_4 4.993426e-04
Rgv_18_4 g_18_4 g_18_5 4.993426e-04
Rgh_18_5 g_18_5 g_19_5 4.993426e-04
Rgv_18_5 g_18_5 g_18_6 4.993426e-04
Rgh_18_6 g_18_6 g_19_6 4.993426e-04
Rgv_18_6 g_18_6 g_18_7 4.993426e-04
Rgh_18_7 g_18_7 g_19_7 4.993426e-04
Rgv_18_7 g_18_7 g_18_8 4.993426e-04
Rgh_18_8 g_18_8 g_19_8 4.993426e-04
Rgv_18_8 g_18_8 g_18_9 4.993426e-04
Rgh_18_9 g_18_9 g_19_9 4.993426e-04
Rgv_18_9 g_18_9 g_18_10 4.993426e-04
Rgh_18_10 g_18_10 g_19_10 4.993426e-04
Rgv_18_10 g_18_10 g_18_11 4.993426e-04
Rgh_18_11 g_18_11 g_19_11 4.993426e-04
Rgv_18_11 g_18_11 g_18_12 4.993426e-04
Rgh_18_12 g_18_12 g_19_12 4.993426e-04
Rgv_18_12 g_18_12 g_18_13 4.993426e-04
Rgh_18_13 g_18_13 g_19_13 4.993426e-04
Rgv_18_13 g_18_13 g_18_14 4.993426e-04
Rgh_18_14 g_18_14 g_19_14 4.993426e-04
Rgv_18_14 g_18_14 g_18_15 4.993426e-04
Rgh_18_15 g_18_15 g_19_15 4.993426e-04
Rgv_18_15 g_18_15 g_18_16 4.993426e-04
Rgh_18_16 g_18_16 g_19_16 4.993426e-04
Rgv_18_16 g_18_16 g_18_17 4.993426e-04
Rgh_18_17 g_18_17 g_19_17 4.993426e-04
Rgv_18_17 g_18_17 g_18_18 4.993426e-04
Rgh_18_18 g_18_18 g_19_18 4.993426e-04
Rgv_18_18 g_18_18 g_18_19 4.993426e-04
Rgh_18_19 g_18_19 g_19_19 4.993426e-04
Rgv_18_19 g_18_19 g_18_20 4.993426e-04
Rgh_18_20 g_18_20 g_19_20 4.993426e-04
Rgv_18_20 g_18_20 g_18_21 4.993426e-04
Rgh_18_21 g_18_21 g_19_21 4.993426e-04
Rgv_18_21 g_18_21 g_18_22 4.993426e-04
Rgh_18_22 g_18_22 g_19_22 4.993426e-04
Rgv_18_22 g_18_22 g_18_23 4.993426e-04
Rgh_18_23 g_18_23 g_19_23 4.993426e-04
Rgv_18_23 g_18_23 g_18_24 4.993426e-04
Rgh_18_24 g_18_24 g_19_24 4.993426e-04
Rgv_18_24 g_18_24 g_18_25 4.993426e-04
Rgh_18_25 g_18_25 g_19_25 4.993426e-04
Rgv_18_25 g_18_25 g_18_26 4.993426e-04
Rgh_18_26 g_18_26 g_19_26 4.993426e-04
Rgv_18_26 g_18_26 g_18_27 4.993426e-04
Rgh_18_27 g_18_27 g_19_27 4.993426e-04
Rgv_18_27 g_18_27 g_18_28 4.993426e-04
Rgh_18_28 g_18_28 g_19_28 4.993426e-04
Rgv_18_28 g_18_28 g_18_29 4.993426e-04
Rgh_18_29 g_18_29 g_19_29 4.993426e-04
Rgv_18_29 g_18_29 g_18_30 4.993426e-04
Rgh_18_30 g_18_30 g_19_30 4.993426e-04
Rgv_18_30 g_18_30 g_18_31 4.993426e-04
Rgh_18_31 g_18_31 g_19_31 4.993426e-04
Rgv_18_31 g_18_31 g_18_32 4.993426e-04
Rgh_18_32 g_18_32 g_19_32 4.993426e-04
Rgv_18_32 g_18_32 g_18_33 4.993426e-04
Rgh_18_33 g_18_33 g_19_33 4.993426e-04
Rgv_18_33 g_18_33 g_18_34 4.993426e-04
Rgh_18_34 g_18_34 g_19_34 4.993426e-04
Rgv_18_34 g_18_34 g_18_35 4.993426e-04
Rgh_18_35 g_18_35 g_19_35 4.993426e-04
Rgv_18_35 g_18_35 g_18_36 4.993426e-04
Rgh_18_36 g_18_36 g_19_36 4.993426e-04
Rgv_18_36 g_18_36 g_18_37 4.993426e-04
Rgh_18_37 g_18_37 g_19_37 4.993426e-04
Rgv_18_37 g_18_37 g_18_38 4.993426e-04
Rgh_18_38 g_18_38 g_19_38 4.993426e-04
Rgv_18_38 g_18_38 g_18_39 4.993426e-04
Rgh_18_39 g_18_39 g_19_39 4.993426e-04
Rgv_18_39 g_18_39 g_18_40 4.993426e-04
Rgh_18_40 g_18_40 g_19_40 4.993426e-04
Rgv_18_40 g_18_40 g_18_41 4.993426e-04
Rgh_18_41 g_18_41 g_19_41 4.993426e-04
Rgv_18_41 g_18_41 g_18_42 4.993426e-04
Rgh_18_42 g_18_42 g_19_42 4.993426e-04
Rgv_18_42 g_18_42 g_18_43 4.993426e-04
Rgh_18_43 g_18_43 g_19_43 4.993426e-04
Rgv_18_43 g_18_43 g_18_44 4.993426e-04
Rgh_18_44 g_18_44 g_19_44 4.993426e-04
Rgv_18_44 g_18_44 g_18_45 4.993426e-04
Rgh_18_45 g_18_45 g_19_45 4.993426e-04
Rgv_18_45 g_18_45 g_18_46 4.993426e-04
Rgh_18_46 g_18_46 g_19_46 4.993426e-04
Rgv_18_46 g_18_46 g_18_47 4.993426e-04
Rgh_18_47 g_18_47 g_19_47 4.993426e-04
Rgv_18_47 g_18_47 g_18_48 4.993426e-04
Rgh_18_48 g_18_48 g_19_48 4.993426e-04
Rgv_18_48 g_18_48 g_18_49 4.993426e-04
Rgh_18_49 g_18_49 g_19_49 4.993426e-04
Rgv_18_49 g_18_49 g_18_50 4.993426e-04
Rgh_18_50 g_18_50 g_19_50 4.993426e-04
Rgv_18_50 g_18_50 g_18_51 4.993426e-04
Rgh_18_51 g_18_51 g_19_51 4.993426e-04
Rgv_18_51 g_18_51 g_18_52 4.993426e-04
Rgh_18_52 g_18_52 g_19_52 4.993426e-04
Rgv_18_52 g_18_52 g_18_53 4.993426e-04
Rgh_18_53 g_18_53 g_19_53 4.993426e-04
Rgv_18_53 g_18_53 g_18_54 4.993426e-04
Rgh_18_54 g_18_54 g_19_54 4.993426e-04
Rgv_18_54 g_18_54 g_18_55 4.993426e-04
Rgh_18_55 g_18_55 g_19_55 4.993426e-04
Rgv_18_55 g_18_55 g_18_56 4.993426e-04
Rgh_18_56 g_18_56 g_19_56 4.993426e-04
Rgv_18_56 g_18_56 g_18_57 4.993426e-04
Rgh_18_57 g_18_57 g_19_57 4.993426e-04
Rgv_18_57 g_18_57 g_18_58 4.993426e-04
Rgh_18_58 g_18_58 g_19_58 4.993426e-04
Rgv_18_58 g_18_58 g_18_59 4.993426e-04
Rgh_18_59 g_18_59 g_19_59 4.993426e-04
Rgv_18_59 g_18_59 g_18_60 4.993426e-04
Rgh_18_60 g_18_60 g_19_60 4.993426e-04
Rgv_18_60 g_18_60 g_18_61 4.993426e-04
Rgh_18_61 g_18_61 g_19_61 4.993426e-04
Rgv_18_61 g_18_61 g_18_62 4.993426e-04
Rgh_18_62 g_18_62 g_19_62 4.993426e-04
Rgv_18_62 g_18_62 g_18_63 4.993426e-04
Rgh_18_63 g_18_63 g_19_63 4.993426e-04
Rgv_18_63 g_18_63 g_18_64 4.993426e-04
Rgh_18_64 g_18_64 g_19_64 4.993426e-04
Rgv_18_64 g_18_64 g_18_65 4.993426e-04
Rgh_18_65 g_18_65 g_19_65 4.993426e-04
Rgv_18_65 g_18_65 g_18_66 4.993426e-04
Rgh_18_66 g_18_66 g_19_66 4.993426e-04
Rgv_18_66 g_18_66 g_18_67 4.993426e-04
Rgh_18_67 g_18_67 g_19_67 4.993426e-04
Rgv_18_67 g_18_67 g_18_68 4.993426e-04
Rgh_18_68 g_18_68 g_19_68 4.993426e-04
Rgv_18_68 g_18_68 g_18_69 4.993426e-04
Rgh_18_69 g_18_69 g_19_69 4.993426e-04
Rgv_18_69 g_18_69 g_18_70 4.993426e-04
Rgh_18_70 g_18_70 g_19_70 4.993426e-04
Rgv_18_70 g_18_70 g_18_71 4.993426e-04
Rgh_18_71 g_18_71 g_19_71 4.993426e-04
Rgh_19_0 g_19_0 g_20_0 4.993426e-04
Rgv_19_0 g_19_0 g_19_1 4.993426e-04
Rgh_19_1 g_19_1 g_20_1 4.993426e-04
Rgv_19_1 g_19_1 g_19_2 4.993426e-04
Rgh_19_2 g_19_2 g_20_2 4.993426e-04
Rgv_19_2 g_19_2 g_19_3 4.993426e-04
Rgh_19_3 g_19_3 g_20_3 4.993426e-04
Rgv_19_3 g_19_3 g_19_4 4.993426e-04
Rgh_19_4 g_19_4 g_20_4 4.993426e-04
Rgv_19_4 g_19_4 g_19_5 4.993426e-04
Rgh_19_5 g_19_5 g_20_5 4.993426e-04
Rgv_19_5 g_19_5 g_19_6 4.993426e-04
Rgh_19_6 g_19_6 g_20_6 4.993426e-04
Rgv_19_6 g_19_6 g_19_7 4.993426e-04
Rgh_19_7 g_19_7 g_20_7 4.993426e-04
Rgv_19_7 g_19_7 g_19_8 4.993426e-04
Rgh_19_8 g_19_8 g_20_8 4.993426e-04
Rgv_19_8 g_19_8 g_19_9 4.993426e-04
Rgh_19_9 g_19_9 g_20_9 4.993426e-04
Rgv_19_9 g_19_9 g_19_10 4.993426e-04
Rgh_19_10 g_19_10 g_20_10 4.993426e-04
Rgv_19_10 g_19_10 g_19_11 4.993426e-04
Rgh_19_11 g_19_11 g_20_11 4.993426e-04
Rgv_19_11 g_19_11 g_19_12 4.993426e-04
Rgh_19_12 g_19_12 g_20_12 4.993426e-04
Rgv_19_12 g_19_12 g_19_13 4.993426e-04
Rgh_19_13 g_19_13 g_20_13 4.993426e-04
Rgv_19_13 g_19_13 g_19_14 4.993426e-04
Rgh_19_14 g_19_14 g_20_14 4.993426e-04
Rgv_19_14 g_19_14 g_19_15 4.993426e-04
Rgh_19_15 g_19_15 g_20_15 4.993426e-04
Rgv_19_15 g_19_15 g_19_16 4.993426e-04
Rgh_19_16 g_19_16 g_20_16 4.993426e-04
Rgv_19_16 g_19_16 g_19_17 4.993426e-04
Rgh_19_17 g_19_17 g_20_17 4.993426e-04
Rgv_19_17 g_19_17 g_19_18 4.993426e-04
Rgh_19_18 g_19_18 g_20_18 4.993426e-04
Rgv_19_18 g_19_18 g_19_19 4.993426e-04
Rgh_19_19 g_19_19 g_20_19 4.993426e-04
Rgv_19_19 g_19_19 g_19_20 4.993426e-04
Rgh_19_20 g_19_20 g_20_20 4.993426e-04
Rgv_19_20 g_19_20 g_19_21 4.993426e-04
Rgh_19_21 g_19_21 g_20_21 4.993426e-04
Rgv_19_21 g_19_21 g_19_22 4.993426e-04
Rgh_19_22 g_19_22 g_20_22 4.993426e-04
Rgv_19_22 g_19_22 g_19_23 4.993426e-04
Rgh_19_23 g_19_23 g_20_23 4.993426e-04
Rgv_19_23 g_19_23 g_19_24 4.993426e-04
Rgh_19_24 g_19_24 g_20_24 4.993426e-04
Rgv_19_24 g_19_24 g_19_25 4.993426e-04
Rgh_19_25 g_19_25 g_20_25 4.993426e-04
Rgv_19_25 g_19_25 g_19_26 4.993426e-04
Rgh_19_26 g_19_26 g_20_26 4.993426e-04
Rgv_19_26 g_19_26 g_19_27 4.993426e-04
Rgh_19_27 g_19_27 g_20_27 4.993426e-04
Rgv_19_27 g_19_27 g_19_28 4.993426e-04
Rgh_19_28 g_19_28 g_20_28 4.993426e-04
Rgv_19_28 g_19_28 g_19_29 4.993426e-04
Rgh_19_29 g_19_29 g_20_29 4.993426e-04
Rgv_19_29 g_19_29 g_19_30 4.993426e-04
Rgh_19_30 g_19_30 g_20_30 4.993426e-04
Rgv_19_30 g_19_30 g_19_31 4.993426e-04
Rgh_19_31 g_19_31 g_20_31 4.993426e-04
Rgv_19_31 g_19_31 g_19_32 4.993426e-04
Rgh_19_32 g_19_32 g_20_32 4.993426e-04
Rgv_19_32 g_19_32 g_19_33 4.993426e-04
Rgh_19_33 g_19_33 g_20_33 4.993426e-04
Rgv_19_33 g_19_33 g_19_34 4.993426e-04
Rgh_19_34 g_19_34 g_20_34 4.993426e-04
Rgv_19_34 g_19_34 g_19_35 4.993426e-04
Rgh_19_35 g_19_35 g_20_35 4.993426e-04
Rgv_19_35 g_19_35 g_19_36 4.993426e-04
Rgh_19_36 g_19_36 g_20_36 4.993426e-04
Rgv_19_36 g_19_36 g_19_37 4.993426e-04
Rgh_19_37 g_19_37 g_20_37 4.993426e-04
Rgv_19_37 g_19_37 g_19_38 4.993426e-04
Rgh_19_38 g_19_38 g_20_38 4.993426e-04
Rgv_19_38 g_19_38 g_19_39 4.993426e-04
Rgh_19_39 g_19_39 g_20_39 4.993426e-04
Rgv_19_39 g_19_39 g_19_40 4.993426e-04
Rgh_19_40 g_19_40 g_20_40 4.993426e-04
Rgv_19_40 g_19_40 g_19_41 4.993426e-04
Rgh_19_41 g_19_41 g_20_41 4.993426e-04
Rgv_19_41 g_19_41 g_19_42 4.993426e-04
Rgh_19_42 g_19_42 g_20_42 4.993426e-04
Rgv_19_42 g_19_42 g_19_43 4.993426e-04
Rgh_19_43 g_19_43 g_20_43 4.993426e-04
Rgv_19_43 g_19_43 g_19_44 4.993426e-04
Rgh_19_44 g_19_44 g_20_44 4.993426e-04
Rgv_19_44 g_19_44 g_19_45 4.993426e-04
Rgh_19_45 g_19_45 g_20_45 4.993426e-04
Rgv_19_45 g_19_45 g_19_46 4.993426e-04
Rgh_19_46 g_19_46 g_20_46 4.993426e-04
Rgv_19_46 g_19_46 g_19_47 4.993426e-04
Rgh_19_47 g_19_47 g_20_47 4.993426e-04
Rgv_19_47 g_19_47 g_19_48 4.993426e-04
Rgh_19_48 g_19_48 g_20_48 4.993426e-04
Rgv_19_48 g_19_48 g_19_49 4.993426e-04
Rgh_19_49 g_19_49 g_20_49 4.993426e-04
Rgv_19_49 g_19_49 g_19_50 4.993426e-04
Rgh_19_50 g_19_50 g_20_50 4.993426e-04
Rgv_19_50 g_19_50 g_19_51 4.993426e-04
Rgh_19_51 g_19_51 g_20_51 4.993426e-04
Rgv_19_51 g_19_51 g_19_52 4.993426e-04
Rgh_19_52 g_19_52 g_20_52 4.993426e-04
Rgv_19_52 g_19_52 g_19_53 4.993426e-04
Rgh_19_53 g_19_53 g_20_53 4.993426e-04
Rgv_19_53 g_19_53 g_19_54 4.993426e-04
Rgh_19_54 g_19_54 g_20_54 4.993426e-04
Rgv_19_54 g_19_54 g_19_55 4.993426e-04
Rgh_19_55 g_19_55 g_20_55 4.993426e-04
Rgv_19_55 g_19_55 g_19_56 4.993426e-04
Rgh_19_56 g_19_56 g_20_56 4.993426e-04
Rgv_19_56 g_19_56 g_19_57 4.993426e-04
Rgh_19_57 g_19_57 g_20_57 4.993426e-04
Rgv_19_57 g_19_57 g_19_58 4.993426e-04
Rgh_19_58 g_19_58 g_20_58 4.993426e-04
Rgv_19_58 g_19_58 g_19_59 4.993426e-04
Rgh_19_59 g_19_59 g_20_59 4.993426e-04
Rgv_19_59 g_19_59 g_19_60 4.993426e-04
Rgh_19_60 g_19_60 g_20_60 4.993426e-04
Rgv_19_60 g_19_60 g_19_61 4.993426e-04
Rgh_19_61 g_19_61 g_20_61 4.993426e-04
Rgv_19_61 g_19_61 g_19_62 4.993426e-04
Rgh_19_62 g_19_62 g_20_62 4.993426e-04
Rgv_19_62 g_19_62 g_19_63 4.993426e-04
Rgh_19_63 g_19_63 g_20_63 4.993426e-04
Rgv_19_63 g_19_63 g_19_64 4.993426e-04
Rgh_19_64 g_19_64 g_20_64 4.993426e-04
Rgv_19_64 g_19_64 g_19_65 4.993426e-04
Rgh_19_65 g_19_65 g_20_65 4.993426e-04
Rgv_19_65 g_19_65 g_19_66 4.993426e-04
Rgh_19_66 g_19_66 g_20_66 4.993426e-04
Rgv_19_66 g_19_66 g_19_67 4.993426e-04
Rgh_19_67 g_19_67 g_20_67 4.993426e-04
Rgv_19_67 g_19_67 g_19_68 4.993426e-04
Rgh_19_68 g_19_68 g_20_68 4.993426e-04
Rgv_19_68 g_19_68 g_19_69 4.993426e-04
Rgh_19_69 g_19_69 g_20_69 4.993426e-04
Rgv_19_69 g_19_69 g_19_70 4.993426e-04
Rgh_19_70 g_19_70 g_20_70 4.993426e-04
Rgv_19_70 g_19_70 g_19_71 4.993426e-04
Rgh_19_71 g_19_71 g_20_71 4.993426e-04
Rgh_20_0 g_20_0 g_21_0 4.993426e-04
Rgv_20_0 g_20_0 g_20_1 4.993426e-04
Rgh_20_1 g_20_1 g_21_1 4.993426e-04
Rgv_20_1 g_20_1 g_20_2 4.993426e-04
Rgh_20_2 g_20_2 g_21_2 4.993426e-04
Rgv_20_2 g_20_2 g_20_3 4.993426e-04
Rgh_20_3 g_20_3 g_21_3 4.993426e-04
Rgv_20_3 g_20_3 g_20_4 4.993426e-04
Rgh_20_4 g_20_4 g_21_4 4.993426e-04
Rgv_20_4 g_20_4 g_20_5 4.993426e-04
Rgh_20_5 g_20_5 g_21_5 4.993426e-04
Rgv_20_5 g_20_5 g_20_6 4.993426e-04
Rgh_20_6 g_20_6 g_21_6 4.993426e-04
Rgv_20_6 g_20_6 g_20_7 4.993426e-04
Rgh_20_7 g_20_7 g_21_7 4.993426e-04
Rgv_20_7 g_20_7 g_20_8 4.993426e-04
Rgh_20_8 g_20_8 g_21_8 4.993426e-04
Rgv_20_8 g_20_8 g_20_9 4.993426e-04
Rgh_20_9 g_20_9 g_21_9 4.993426e-04
Rgv_20_9 g_20_9 g_20_10 4.993426e-04
Rgh_20_10 g_20_10 g_21_10 4.993426e-04
Rgv_20_10 g_20_10 g_20_11 4.993426e-04
Rgh_20_11 g_20_11 g_21_11 4.993426e-04
Rgv_20_11 g_20_11 g_20_12 4.993426e-04
Rgh_20_12 g_20_12 g_21_12 4.993426e-04
Rgv_20_12 g_20_12 g_20_13 4.993426e-04
Rgh_20_13 g_20_13 g_21_13 4.993426e-04
Rgv_20_13 g_20_13 g_20_14 4.993426e-04
Rgh_20_14 g_20_14 g_21_14 4.993426e-04
Rgv_20_14 g_20_14 g_20_15 4.993426e-04
Rgh_20_15 g_20_15 g_21_15 4.993426e-04
Rgv_20_15 g_20_15 g_20_16 4.993426e-04
Rgh_20_16 g_20_16 g_21_16 4.993426e-04
Rgv_20_16 g_20_16 g_20_17 4.993426e-04
Rgh_20_17 g_20_17 g_21_17 4.993426e-04
Rgv_20_17 g_20_17 g_20_18 4.993426e-04
Rgh_20_18 g_20_18 g_21_18 4.993426e-04
Rgv_20_18 g_20_18 g_20_19 4.993426e-04
Rgh_20_19 g_20_19 g_21_19 4.993426e-04
Rgv_20_19 g_20_19 g_20_20 4.993426e-04
Rgh_20_20 g_20_20 g_21_20 4.993426e-04
Rgv_20_20 g_20_20 g_20_21 4.993426e-04
Rgh_20_21 g_20_21 g_21_21 4.993426e-04
Rgv_20_21 g_20_21 g_20_22 4.993426e-04
Rgh_20_22 g_20_22 g_21_22 4.993426e-04
Rgv_20_22 g_20_22 g_20_23 4.993426e-04
Rgh_20_23 g_20_23 g_21_23 4.993426e-04
Rgv_20_23 g_20_23 g_20_24 4.993426e-04
Rgh_20_24 g_20_24 g_21_24 4.993426e-04
Rgv_20_24 g_20_24 g_20_25 4.993426e-04
Rgh_20_25 g_20_25 g_21_25 4.993426e-04
Rgv_20_25 g_20_25 g_20_26 4.993426e-04
Rgh_20_26 g_20_26 g_21_26 4.993426e-04
Rgv_20_26 g_20_26 g_20_27 4.993426e-04
Rgh_20_27 g_20_27 g_21_27 4.993426e-04
Rgv_20_27 g_20_27 g_20_28 4.993426e-04
Rgh_20_28 g_20_28 g_21_28 4.993426e-04
Rgv_20_28 g_20_28 g_20_29 4.993426e-04
Rgh_20_29 g_20_29 g_21_29 4.993426e-04
Rgv_20_29 g_20_29 g_20_30 4.993426e-04
Rgh_20_30 g_20_30 g_21_30 4.993426e-04
Rgv_20_30 g_20_30 g_20_31 4.993426e-04
Rgh_20_31 g_20_31 g_21_31 4.993426e-04
Rgv_20_31 g_20_31 g_20_32 4.993426e-04
Rgh_20_32 g_20_32 g_21_32 4.993426e-04
Rgv_20_32 g_20_32 g_20_33 4.993426e-04
Rgh_20_33 g_20_33 g_21_33 4.993426e-04
Rgv_20_33 g_20_33 g_20_34 4.993426e-04
Rgh_20_34 g_20_34 g_21_34 4.993426e-04
Rgv_20_34 g_20_34 g_20_35 4.993426e-04
Rgh_20_35 g_20_35 g_21_35 4.993426e-04
Rgv_20_35 g_20_35 g_20_36 4.993426e-04
Rgh_20_36 g_20_36 g_21_36 4.993426e-04
Rgv_20_36 g_20_36 g_20_37 4.993426e-04
Rgh_20_37 g_20_37 g_21_37 4.993426e-04
Rgv_20_37 g_20_37 g_20_38 4.993426e-04
Rgh_20_38 g_20_38 g_21_38 4.993426e-04
Rgv_20_38 g_20_38 g_20_39 4.993426e-04
Rgh_20_39 g_20_39 g_21_39 4.993426e-04
Rgv_20_39 g_20_39 g_20_40 4.993426e-04
Rgh_20_40 g_20_40 g_21_40 4.993426e-04
Rgv_20_40 g_20_40 g_20_41 4.993426e-04
Rgh_20_41 g_20_41 g_21_41 4.993426e-04
Rgv_20_41 g_20_41 g_20_42 4.993426e-04
Rgh_20_42 g_20_42 g_21_42 4.993426e-04
Rgv_20_42 g_20_42 g_20_43 4.993426e-04
Rgh_20_43 g_20_43 g_21_43 4.993426e-04
Rgv_20_43 g_20_43 g_20_44 4.993426e-04
Rgh_20_44 g_20_44 g_21_44 4.993426e-04
Rgv_20_44 g_20_44 g_20_45 4.993426e-04
Rgh_20_45 g_20_45 g_21_45 4.993426e-04
Rgv_20_45 g_20_45 g_20_46 4.993426e-04
Rgh_20_46 g_20_46 g_21_46 4.993426e-04
Rgv_20_46 g_20_46 g_20_47 4.993426e-04
Rgh_20_47 g_20_47 g_21_47 4.993426e-04
Rgv_20_47 g_20_47 g_20_48 4.993426e-04
Rgh_20_48 g_20_48 g_21_48 4.993426e-04
Rgv_20_48 g_20_48 g_20_49 4.993426e-04
Rgh_20_49 g_20_49 g_21_49 4.993426e-04
Rgv_20_49 g_20_49 g_20_50 4.993426e-04
Rgh_20_50 g_20_50 g_21_50 4.993426e-04
Rgv_20_50 g_20_50 g_20_51 4.993426e-04
Rgh_20_51 g_20_51 g_21_51 4.993426e-04
Rgv_20_51 g_20_51 g_20_52 4.993426e-04
Rgh_20_52 g_20_52 g_21_52 4.993426e-04
Rgv_20_52 g_20_52 g_20_53 4.993426e-04
Rgh_20_53 g_20_53 g_21_53 4.993426e-04
Rgv_20_53 g_20_53 g_20_54 4.993426e-04
Rgh_20_54 g_20_54 g_21_54 4.993426e-04
Rgv_20_54 g_20_54 g_20_55 4.993426e-04
Rgh_20_55 g_20_55 g_21_55 4.993426e-04
Rgv_20_55 g_20_55 g_20_56 4.993426e-04
Rgh_20_56 g_20_56 g_21_56 4.993426e-04
Rgv_20_56 g_20_56 g_20_57 4.993426e-04
Rgh_20_57 g_20_57 g_21_57 4.993426e-04
Rgv_20_57 g_20_57 g_20_58 4.993426e-04
Rgh_20_58 g_20_58 g_21_58 4.993426e-04
Rgv_20_58 g_20_58 g_20_59 4.993426e-04
Rgh_20_59 g_20_59 g_21_59 4.993426e-04
Rgv_20_59 g_20_59 g_20_60 4.993426e-04
Rgh_20_60 g_20_60 g_21_60 4.993426e-04
Rgv_20_60 g_20_60 g_20_61 4.993426e-04
Rgh_20_61 g_20_61 g_21_61 4.993426e-04
Rgv_20_61 g_20_61 g_20_62 4.993426e-04
Rgh_20_62 g_20_62 g_21_62 4.993426e-04
Rgv_20_62 g_20_62 g_20_63 4.993426e-04
Rgh_20_63 g_20_63 g_21_63 4.993426e-04
Rgv_20_63 g_20_63 g_20_64 4.993426e-04
Rgh_20_64 g_20_64 g_21_64 4.993426e-04
Rgv_20_64 g_20_64 g_20_65 4.993426e-04
Rgh_20_65 g_20_65 g_21_65 4.993426e-04
Rgv_20_65 g_20_65 g_20_66 4.993426e-04
Rgh_20_66 g_20_66 g_21_66 4.993426e-04
Rgv_20_66 g_20_66 g_20_67 4.993426e-04
Rgh_20_67 g_20_67 g_21_67 4.993426e-04
Rgv_20_67 g_20_67 g_20_68 4.993426e-04
Rgh_20_68 g_20_68 g_21_68 4.993426e-04
Rgv_20_68 g_20_68 g_20_69 4.993426e-04
Rgh_20_69 g_20_69 g_21_69 4.993426e-04
Rgv_20_69 g_20_69 g_20_70 4.993426e-04
Rgh_20_70 g_20_70 g_21_70 4.993426e-04
Rgv_20_70 g_20_70 g_20_71 4.993426e-04
Rgh_20_71 g_20_71 g_21_71 4.993426e-04
Rgh_21_0 g_21_0 g_22_0 4.993426e-04
Rgv_21_0 g_21_0 g_21_1 4.993426e-04
Rgh_21_1 g_21_1 g_22_1 4.993426e-04
Rgv_21_1 g_21_1 g_21_2 4.993426e-04
Rgh_21_2 g_21_2 g_22_2 4.993426e-04
Rgv_21_2 g_21_2 g_21_3 4.993426e-04
Rgh_21_3 g_21_3 g_22_3 4.993426e-04
Rgv_21_3 g_21_3 g_21_4 4.993426e-04
Rgh_21_4 g_21_4 g_22_4 4.993426e-04
Rgv_21_4 g_21_4 g_21_5 4.993426e-04
Rgh_21_5 g_21_5 g_22_5 4.993426e-04
Rgv_21_5 g_21_5 g_21_6 4.993426e-04
Rgh_21_6 g_21_6 g_22_6 4.993426e-04
Rgv_21_6 g_21_6 g_21_7 4.993426e-04
Rgh_21_7 g_21_7 g_22_7 4.993426e-04
Rgv_21_7 g_21_7 g_21_8 4.993426e-04
Rgh_21_8 g_21_8 g_22_8 4.993426e-04
Rgv_21_8 g_21_8 g_21_9 4.993426e-04
Rgh_21_9 g_21_9 g_22_9 4.993426e-04
Rgv_21_9 g_21_9 g_21_10 4.993426e-04
Rgh_21_10 g_21_10 g_22_10 4.993426e-04
Rgv_21_10 g_21_10 g_21_11 4.993426e-04
Rgh_21_11 g_21_11 g_22_11 4.993426e-04
Rgv_21_11 g_21_11 g_21_12 4.993426e-04
Rgh_21_12 g_21_12 g_22_12 4.993426e-04
Rgv_21_12 g_21_12 g_21_13 4.993426e-04
Rgh_21_13 g_21_13 g_22_13 4.993426e-04
Rgv_21_13 g_21_13 g_21_14 4.993426e-04
Rgh_21_14 g_21_14 g_22_14 4.993426e-04
Rgv_21_14 g_21_14 g_21_15 4.993426e-04
Rgh_21_15 g_21_15 g_22_15 4.993426e-04
Rgv_21_15 g_21_15 g_21_16 4.993426e-04
Rgh_21_16 g_21_16 g_22_16 4.993426e-04
Rgv_21_16 g_21_16 g_21_17 4.993426e-04
Rgh_21_17 g_21_17 g_22_17 4.993426e-04
Rgv_21_17 g_21_17 g_21_18 4.993426e-04
Rgh_21_18 g_21_18 g_22_18 4.993426e-04
Rgv_21_18 g_21_18 g_21_19 4.993426e-04
Rgh_21_19 g_21_19 g_22_19 4.993426e-04
Rgv_21_19 g_21_19 g_21_20 4.993426e-04
Rgh_21_20 g_21_20 g_22_20 4.993426e-04
Rgv_21_20 g_21_20 g_21_21 4.993426e-04
Rgh_21_21 g_21_21 g_22_21 4.993426e-04
Rgv_21_21 g_21_21 g_21_22 4.993426e-04
Rgh_21_22 g_21_22 g_22_22 4.993426e-04
Rgv_21_22 g_21_22 g_21_23 4.993426e-04
Rgh_21_23 g_21_23 g_22_23 4.993426e-04
Rgv_21_23 g_21_23 g_21_24 4.993426e-04
Rgh_21_24 g_21_24 g_22_24 4.993426e-04
Rgv_21_24 g_21_24 g_21_25 4.993426e-04
Rgh_21_25 g_21_25 g_22_25 4.993426e-04
Rgv_21_25 g_21_25 g_21_26 4.993426e-04
Rgh_21_26 g_21_26 g_22_26 4.993426e-04
Rgv_21_26 g_21_26 g_21_27 4.993426e-04
Rgh_21_27 g_21_27 g_22_27 4.993426e-04
Rgv_21_27 g_21_27 g_21_28 4.993426e-04
Rgh_21_28 g_21_28 g_22_28 4.993426e-04
Rgv_21_28 g_21_28 g_21_29 4.993426e-04
Rgh_21_29 g_21_29 g_22_29 4.993426e-04
Rgv_21_29 g_21_29 g_21_30 4.993426e-04
Rgh_21_30 g_21_30 g_22_30 4.993426e-04
Rgv_21_30 g_21_30 g_21_31 4.993426e-04
Rgh_21_31 g_21_31 g_22_31 4.993426e-04
Rgv_21_31 g_21_31 g_21_32 4.993426e-04
Rgh_21_32 g_21_32 g_22_32 4.993426e-04
Rgv_21_32 g_21_32 g_21_33 4.993426e-04
Rgh_21_33 g_21_33 g_22_33 4.993426e-04
Rgv_21_33 g_21_33 g_21_34 4.993426e-04
Rgh_21_34 g_21_34 g_22_34 4.993426e-04
Rgv_21_34 g_21_34 g_21_35 4.993426e-04
Rgh_21_35 g_21_35 g_22_35 4.993426e-04
Rgv_21_35 g_21_35 g_21_36 4.993426e-04
Rgh_21_36 g_21_36 g_22_36 4.993426e-04
Rgv_21_36 g_21_36 g_21_37 4.993426e-04
Rgh_21_37 g_21_37 g_22_37 4.993426e-04
Rgv_21_37 g_21_37 g_21_38 4.993426e-04
Rgh_21_38 g_21_38 g_22_38 4.993426e-04
Rgv_21_38 g_21_38 g_21_39 4.993426e-04
Rgh_21_39 g_21_39 g_22_39 4.993426e-04
Rgv_21_39 g_21_39 g_21_40 4.993426e-04
Rgh_21_40 g_21_40 g_22_40 4.993426e-04
Rgv_21_40 g_21_40 g_21_41 4.993426e-04
Rgh_21_41 g_21_41 g_22_41 4.993426e-04
Rgv_21_41 g_21_41 g_21_42 4.993426e-04
Rgh_21_42 g_21_42 g_22_42 4.993426e-04
Rgv_21_42 g_21_42 g_21_43 4.993426e-04
Rgh_21_43 g_21_43 g_22_43 4.993426e-04
Rgv_21_43 g_21_43 g_21_44 4.993426e-04
Rgh_21_44 g_21_44 g_22_44 4.993426e-04
Rgv_21_44 g_21_44 g_21_45 4.993426e-04
Rgh_21_45 g_21_45 g_22_45 4.993426e-04
Rgv_21_45 g_21_45 g_21_46 4.993426e-04
Rgh_21_46 g_21_46 g_22_46 4.993426e-04
Rgv_21_46 g_21_46 g_21_47 4.993426e-04
Rgh_21_47 g_21_47 g_22_47 4.993426e-04
Rgv_21_47 g_21_47 g_21_48 4.993426e-04
Rgh_21_48 g_21_48 g_22_48 4.993426e-04
Rgv_21_48 g_21_48 g_21_49 4.993426e-04
Rgh_21_49 g_21_49 g_22_49 4.993426e-04
Rgv_21_49 g_21_49 g_21_50 4.993426e-04
Rgh_21_50 g_21_50 g_22_50 4.993426e-04
Rgv_21_50 g_21_50 g_21_51 4.993426e-04
Rgh_21_51 g_21_51 g_22_51 4.993426e-04
Rgv_21_51 g_21_51 g_21_52 4.993426e-04
Rgh_21_52 g_21_52 g_22_52 4.993426e-04
Rgv_21_52 g_21_52 g_21_53 4.993426e-04
Rgh_21_53 g_21_53 g_22_53 4.993426e-04
Rgv_21_53 g_21_53 g_21_54 4.993426e-04
Rgh_21_54 g_21_54 g_22_54 4.993426e-04
Rgv_21_54 g_21_54 g_21_55 4.993426e-04
Rgh_21_55 g_21_55 g_22_55 4.993426e-04
Rgv_21_55 g_21_55 g_21_56 4.993426e-04
Rgh_21_56 g_21_56 g_22_56 4.993426e-04
Rgv_21_56 g_21_56 g_21_57 4.993426e-04
Rgh_21_57 g_21_57 g_22_57 4.993426e-04
Rgv_21_57 g_21_57 g_21_58 4.993426e-04
Rgh_21_58 g_21_58 g_22_58 4.993426e-04
Rgv_21_58 g_21_58 g_21_59 4.993426e-04
Rgh_21_59 g_21_59 g_22_59 4.993426e-04
Rgv_21_59 g_21_59 g_21_60 4.993426e-04
Rgh_21_60 g_21_60 g_22_60 4.993426e-04
Rgv_21_60 g_21_60 g_21_61 4.993426e-04
Rgh_21_61 g_21_61 g_22_61 4.993426e-04
Rgv_21_61 g_21_61 g_21_62 4.993426e-04
Rgh_21_62 g_21_62 g_22_62 4.993426e-04
Rgv_21_62 g_21_62 g_21_63 4.993426e-04
Rgh_21_63 g_21_63 g_22_63 4.993426e-04
Rgv_21_63 g_21_63 g_21_64 4.993426e-04
Rgh_21_64 g_21_64 g_22_64 4.993426e-04
Rgv_21_64 g_21_64 g_21_65 4.993426e-04
Rgh_21_65 g_21_65 g_22_65 4.993426e-04
Rgv_21_65 g_21_65 g_21_66 4.993426e-04
Rgh_21_66 g_21_66 g_22_66 4.993426e-04
Rgv_21_66 g_21_66 g_21_67 4.993426e-04
Rgh_21_67 g_21_67 g_22_67 4.993426e-04
Rgv_21_67 g_21_67 g_21_68 4.993426e-04
Rgh_21_68 g_21_68 g_22_68 4.993426e-04
Rgv_21_68 g_21_68 g_21_69 4.993426e-04
Rgh_21_69 g_21_69 g_22_69 4.993426e-04
Rgv_21_69 g_21_69 g_21_70 4.993426e-04
Rgh_21_70 g_21_70 g_22_70 4.993426e-04
Rgv_21_70 g_21_70 g_21_71 4.993426e-04
Rgh_21_71 g_21_71 g_22_71 4.993426e-04
Rgh_22_0 g_22_0 g_23_0 4.993426e-04
Rgv_22_0 g_22_0 g_22_1 4.993426e-04
Rgh_22_1 g_22_1 g_23_1 4.993426e-04
Rgv_22_1 g_22_1 g_22_2 4.993426e-04
Rgh_22_2 g_22_2 g_23_2 4.993426e-04
Rgv_22_2 g_22_2 g_22_3 4.993426e-04
Rgh_22_3 g_22_3 g_23_3 4.993426e-04
Rgv_22_3 g_22_3 g_22_4 4.993426e-04
Rgh_22_4 g_22_4 g_23_4 4.993426e-04
Rgv_22_4 g_22_4 g_22_5 4.993426e-04
Rgh_22_5 g_22_5 g_23_5 4.993426e-04
Rgv_22_5 g_22_5 g_22_6 4.993426e-04
Rgh_22_6 g_22_6 g_23_6 4.993426e-04
Rgv_22_6 g_22_6 g_22_7 4.993426e-04
Rgh_22_7 g_22_7 g_23_7 4.993426e-04
Rgv_22_7 g_22_7 g_22_8 4.993426e-04
Rgh_22_8 g_22_8 g_23_8 4.993426e-04
Rgv_22_8 g_22_8 g_22_9 4.993426e-04
Rgh_22_9 g_22_9 g_23_9 4.993426e-04
Rgv_22_9 g_22_9 g_22_10 4.993426e-04
Rgh_22_10 g_22_10 g_23_10 4.993426e-04
Rgv_22_10 g_22_10 g_22_11 4.993426e-04
Rgh_22_11 g_22_11 g_23_11 4.993426e-04
Rgv_22_11 g_22_11 g_22_12 4.993426e-04
Rgh_22_12 g_22_12 g_23_12 4.993426e-04
Rgv_22_12 g_22_12 g_22_13 4.993426e-04
Rgh_22_13 g_22_13 g_23_13 4.993426e-04
Rgv_22_13 g_22_13 g_22_14 4.993426e-04
Rgh_22_14 g_22_14 g_23_14 4.993426e-04
Rgv_22_14 g_22_14 g_22_15 4.993426e-04
Rgh_22_15 g_22_15 g_23_15 4.993426e-04
Rgv_22_15 g_22_15 g_22_16 4.993426e-04
Rgh_22_16 g_22_16 g_23_16 4.993426e-04
Rgv_22_16 g_22_16 g_22_17 4.993426e-04
Rgh_22_17 g_22_17 g_23_17 4.993426e-04
Rgv_22_17 g_22_17 g_22_18 4.993426e-04
Rgh_22_18 g_22_18 g_23_18 4.993426e-04
Rgv_22_18 g_22_18 g_22_19 4.993426e-04
Rgh_22_19 g_22_19 g_23_19 4.993426e-04
Rgv_22_19 g_22_19 g_22_20 4.993426e-04
Rgh_22_20 g_22_20 g_23_20 4.993426e-04
Rgv_22_20 g_22_20 g_22_21 4.993426e-04
Rgh_22_21 g_22_21 g_23_21 4.993426e-04
Rgv_22_21 g_22_21 g_22_22 4.993426e-04
Rgh_22_22 g_22_22 g_23_22 4.993426e-04
Rgv_22_22 g_22_22 g_22_23 4.993426e-04
Rgh_22_23 g_22_23 g_23_23 4.993426e-04
Rgv_22_23 g_22_23 g_22_24 4.993426e-04
Rgh_22_24 g_22_24 g_23_24 4.993426e-04
Rgv_22_24 g_22_24 g_22_25 4.993426e-04
Rgh_22_25 g_22_25 g_23_25 4.993426e-04
Rgv_22_25 g_22_25 g_22_26 4.993426e-04
Rgh_22_26 g_22_26 g_23_26 4.993426e-04
Rgv_22_26 g_22_26 g_22_27 4.993426e-04
Rgh_22_27 g_22_27 g_23_27 4.993426e-04
Rgv_22_27 g_22_27 g_22_28 4.993426e-04
Rgh_22_28 g_22_28 g_23_28 4.993426e-04
Rgv_22_28 g_22_28 g_22_29 4.993426e-04
Rgh_22_29 g_22_29 g_23_29 4.993426e-04
Rgv_22_29 g_22_29 g_22_30 4.993426e-04
Rgh_22_30 g_22_30 g_23_30 4.993426e-04
Rgv_22_30 g_22_30 g_22_31 4.993426e-04
Rgh_22_31 g_22_31 g_23_31 4.993426e-04
Rgv_22_31 g_22_31 g_22_32 4.993426e-04
Rgh_22_32 g_22_32 g_23_32 4.993426e-04
Rgv_22_32 g_22_32 g_22_33 4.993426e-04
Rgh_22_33 g_22_33 g_23_33 4.993426e-04
Rgv_22_33 g_22_33 g_22_34 4.993426e-04
Rgh_22_34 g_22_34 g_23_34 4.993426e-04
Rgv_22_34 g_22_34 g_22_35 4.993426e-04
Rgh_22_35 g_22_35 g_23_35 4.993426e-04
Rgv_22_35 g_22_35 g_22_36 4.993426e-04
Rgh_22_36 g_22_36 g_23_36 4.993426e-04
Rgv_22_36 g_22_36 g_22_37 4.993426e-04
Rgh_22_37 g_22_37 g_23_37 4.993426e-04
Rgv_22_37 g_22_37 g_22_38 4.993426e-04
Rgh_22_38 g_22_38 g_23_38 4.993426e-04
Rgv_22_38 g_22_38 g_22_39 4.993426e-04
Rgh_22_39 g_22_39 g_23_39 4.993426e-04
Rgv_22_39 g_22_39 g_22_40 4.993426e-04
Rgh_22_40 g_22_40 g_23_40 4.993426e-04
Rgv_22_40 g_22_40 g_22_41 4.993426e-04
Rgh_22_41 g_22_41 g_23_41 4.993426e-04
Rgv_22_41 g_22_41 g_22_42 4.993426e-04
Rgh_22_42 g_22_42 g_23_42 4.993426e-04
Rgv_22_42 g_22_42 g_22_43 4.993426e-04
Rgh_22_43 g_22_43 g_23_43 4.993426e-04
Rgv_22_43 g_22_43 g_22_44 4.993426e-04
Rgh_22_44 g_22_44 g_23_44 4.993426e-04
Rgv_22_44 g_22_44 g_22_45 4.993426e-04
Rgh_22_45 g_22_45 g_23_45 4.993426e-04
Rgv_22_45 g_22_45 g_22_46 4.993426e-04
Rgh_22_46 g_22_46 g_23_46 4.993426e-04
Rgv_22_46 g_22_46 g_22_47 4.993426e-04
Rgh_22_47 g_22_47 g_23_47 4.993426e-04
Rgv_22_47 g_22_47 g_22_48 4.993426e-04
Rgh_22_48 g_22_48 g_23_48 4.993426e-04
Rgv_22_48 g_22_48 g_22_49 4.993426e-04
Rgh_22_49 g_22_49 g_23_49 4.993426e-04
Rgv_22_49 g_22_49 g_22_50 4.993426e-04
Rgh_22_50 g_22_50 g_23_50 4.993426e-04
Rgv_22_50 g_22_50 g_22_51 4.993426e-04
Rgh_22_51 g_22_51 g_23_51 4.993426e-04
Rgv_22_51 g_22_51 g_22_52 4.993426e-04
Rgh_22_52 g_22_52 g_23_52 4.993426e-04
Rgv_22_52 g_22_52 g_22_53 4.993426e-04
Rgh_22_53 g_22_53 g_23_53 4.993426e-04
Rgv_22_53 g_22_53 g_22_54 4.993426e-04
Rgh_22_54 g_22_54 g_23_54 4.993426e-04
Rgv_22_54 g_22_54 g_22_55 4.993426e-04
Rgh_22_55 g_22_55 g_23_55 4.993426e-04
Rgv_22_55 g_22_55 g_22_56 4.993426e-04
Rgh_22_56 g_22_56 g_23_56 4.993426e-04
Rgv_22_56 g_22_56 g_22_57 4.993426e-04
Rgh_22_57 g_22_57 g_23_57 4.993426e-04
Rgv_22_57 g_22_57 g_22_58 4.993426e-04
Rgh_22_58 g_22_58 g_23_58 4.993426e-04
Rgv_22_58 g_22_58 g_22_59 4.993426e-04
Rgh_22_59 g_22_59 g_23_59 4.993426e-04
Rgv_22_59 g_22_59 g_22_60 4.993426e-04
Rgh_22_60 g_22_60 g_23_60 4.993426e-04
Rgv_22_60 g_22_60 g_22_61 4.993426e-04
Rgh_22_61 g_22_61 g_23_61 4.993426e-04
Rgv_22_61 g_22_61 g_22_62 4.993426e-04
Rgh_22_62 g_22_62 g_23_62 4.993426e-04
Rgv_22_62 g_22_62 g_22_63 4.993426e-04
Rgh_22_63 g_22_63 g_23_63 4.993426e-04
Rgv_22_63 g_22_63 g_22_64 4.993426e-04
Rgh_22_64 g_22_64 g_23_64 4.993426e-04
Rgv_22_64 g_22_64 g_22_65 4.993426e-04
Rgh_22_65 g_22_65 g_23_65 4.993426e-04
Rgv_22_65 g_22_65 g_22_66 4.993426e-04
Rgh_22_66 g_22_66 g_23_66 4.993426e-04
Rgv_22_66 g_22_66 g_22_67 4.993426e-04
Rgh_22_67 g_22_67 g_23_67 4.993426e-04
Rgv_22_67 g_22_67 g_22_68 4.993426e-04
Rgh_22_68 g_22_68 g_23_68 4.993426e-04
Rgv_22_68 g_22_68 g_22_69 4.993426e-04
Rgh_22_69 g_22_69 g_23_69 4.993426e-04
Rgv_22_69 g_22_69 g_22_70 4.993426e-04
Rgh_22_70 g_22_70 g_23_70 4.993426e-04
Rgv_22_70 g_22_70 g_22_71 4.993426e-04
Rgh_22_71 g_22_71 g_23_71 4.993426e-04
Rgh_23_0 g_23_0 g_24_0 4.993426e-04
Rgv_23_0 g_23_0 g_23_1 4.993426e-04
Rgh_23_1 g_23_1 g_24_1 4.993426e-04
Rgv_23_1 g_23_1 g_23_2 4.993426e-04
Rgh_23_2 g_23_2 g_24_2 4.993426e-04
Rgv_23_2 g_23_2 g_23_3 4.993426e-04
Rgh_23_3 g_23_3 g_24_3 4.993426e-04
Rgv_23_3 g_23_3 g_23_4 4.993426e-04
Rgh_23_4 g_23_4 g_24_4 4.993426e-04
Rgv_23_4 g_23_4 g_23_5 4.993426e-04
Rgh_23_5 g_23_5 g_24_5 4.993426e-04
Rgv_23_5 g_23_5 g_23_6 4.993426e-04
Rgh_23_6 g_23_6 g_24_6 4.993426e-04
Rgv_23_6 g_23_6 g_23_7 4.993426e-04
Rgh_23_7 g_23_7 g_24_7 4.993426e-04
Rgv_23_7 g_23_7 g_23_8 4.993426e-04
Rgh_23_8 g_23_8 g_24_8 4.993426e-04
Rgv_23_8 g_23_8 g_23_9 4.993426e-04
Rgh_23_9 g_23_9 g_24_9 4.993426e-04
Rgv_23_9 g_23_9 g_23_10 4.993426e-04
Rgh_23_10 g_23_10 g_24_10 4.993426e-04
Rgv_23_10 g_23_10 g_23_11 4.993426e-04
Rgh_23_11 g_23_11 g_24_11 4.993426e-04
Rgv_23_11 g_23_11 g_23_12 4.993426e-04
Rgh_23_12 g_23_12 g_24_12 4.993426e-04
Rgv_23_12 g_23_12 g_23_13 4.993426e-04
Rgh_23_13 g_23_13 g_24_13 4.993426e-04
Rgv_23_13 g_23_13 g_23_14 4.993426e-04
Rgh_23_14 g_23_14 g_24_14 4.993426e-04
Rgv_23_14 g_23_14 g_23_15 4.993426e-04
Rgh_23_15 g_23_15 g_24_15 4.993426e-04
Rgv_23_15 g_23_15 g_23_16 4.993426e-04
Rgh_23_16 g_23_16 g_24_16 4.993426e-04
Rgv_23_16 g_23_16 g_23_17 4.993426e-04
Rgh_23_17 g_23_17 g_24_17 4.993426e-04
Rgv_23_17 g_23_17 g_23_18 4.993426e-04
Rgh_23_18 g_23_18 g_24_18 4.993426e-04
Rgv_23_18 g_23_18 g_23_19 4.993426e-04
Rgh_23_19 g_23_19 g_24_19 4.993426e-04
Rgv_23_19 g_23_19 g_23_20 4.993426e-04
Rgh_23_20 g_23_20 g_24_20 4.993426e-04
Rgv_23_20 g_23_20 g_23_21 4.993426e-04
Rgh_23_21 g_23_21 g_24_21 4.993426e-04
Rgv_23_21 g_23_21 g_23_22 4.993426e-04
Rgh_23_22 g_23_22 g_24_22 4.993426e-04
Rgv_23_22 g_23_22 g_23_23 4.993426e-04
Rgh_23_23 g_23_23 g_24_23 4.993426e-04
Rgv_23_23 g_23_23 g_23_24 4.993426e-04
Rgh_23_24 g_23_24 g_24_24 4.993426e-04
Rgv_23_24 g_23_24 g_23_25 4.993426e-04
Rgh_23_25 g_23_25 g_24_25 4.993426e-04
Rgv_23_25 g_23_25 g_23_26 4.993426e-04
Rgh_23_26 g_23_26 g_24_26 4.993426e-04
Rgv_23_26 g_23_26 g_23_27 4.993426e-04
Rgh_23_27 g_23_27 g_24_27 4.993426e-04
Rgv_23_27 g_23_27 g_23_28 4.993426e-04
Rgh_23_28 g_23_28 g_24_28 4.993426e-04
Rgv_23_28 g_23_28 g_23_29 4.993426e-04
Rgh_23_29 g_23_29 g_24_29 4.993426e-04
Rgv_23_29 g_23_29 g_23_30 4.993426e-04
Rgh_23_30 g_23_30 g_24_30 4.993426e-04
Rgv_23_30 g_23_30 g_23_31 4.993426e-04
Rgh_23_31 g_23_31 g_24_31 4.993426e-04
Rgv_23_31 g_23_31 g_23_32 4.993426e-04
Rgh_23_32 g_23_32 g_24_32 4.993426e-04
Rgv_23_32 g_23_32 g_23_33 4.993426e-04
Rgh_23_33 g_23_33 g_24_33 4.993426e-04
Rgv_23_33 g_23_33 g_23_34 4.993426e-04
Rgh_23_34 g_23_34 g_24_34 4.993426e-04
Rgv_23_34 g_23_34 g_23_35 4.993426e-04
Rgh_23_35 g_23_35 g_24_35 4.993426e-04
Rgv_23_35 g_23_35 g_23_36 4.993426e-04
Rgh_23_36 g_23_36 g_24_36 4.993426e-04
Rgv_23_36 g_23_36 g_23_37 4.993426e-04
Rgh_23_37 g_23_37 g_24_37 4.993426e-04
Rgv_23_37 g_23_37 g_23_38 4.993426e-04
Rgh_23_38 g_23_38 g_24_38 4.993426e-04
Rgv_23_38 g_23_38 g_23_39 4.993426e-04
Rgh_23_39 g_23_39 g_24_39 4.993426e-04
Rgv_23_39 g_23_39 g_23_40 4.993426e-04
Rgh_23_40 g_23_40 g_24_40 4.993426e-04
Rgv_23_40 g_23_40 g_23_41 4.993426e-04
Rgh_23_41 g_23_41 g_24_41 4.993426e-04
Rgv_23_41 g_23_41 g_23_42 4.993426e-04
Rgh_23_42 g_23_42 g_24_42 4.993426e-04
Rgv_23_42 g_23_42 g_23_43 4.993426e-04
Rgh_23_43 g_23_43 g_24_43 4.993426e-04
Rgv_23_43 g_23_43 g_23_44 4.993426e-04
Rgh_23_44 g_23_44 g_24_44 4.993426e-04
Rgv_23_44 g_23_44 g_23_45 4.993426e-04
Rgh_23_45 g_23_45 g_24_45 4.993426e-04
Rgv_23_45 g_23_45 g_23_46 4.993426e-04
Rgh_23_46 g_23_46 g_24_46 4.993426e-04
Rgv_23_46 g_23_46 g_23_47 4.993426e-04
Rgh_23_47 g_23_47 g_24_47 4.993426e-04
Rgv_23_47 g_23_47 g_23_48 4.993426e-04
Rgh_23_48 g_23_48 g_24_48 4.993426e-04
Rgv_23_48 g_23_48 g_23_49 4.993426e-04
Rgh_23_49 g_23_49 g_24_49 4.993426e-04
Rgv_23_49 g_23_49 g_23_50 4.993426e-04
Rgh_23_50 g_23_50 g_24_50 4.993426e-04
Rgv_23_50 g_23_50 g_23_51 4.993426e-04
Rgh_23_51 g_23_51 g_24_51 4.993426e-04
Rgv_23_51 g_23_51 g_23_52 4.993426e-04
Rgh_23_52 g_23_52 g_24_52 4.993426e-04
Rgv_23_52 g_23_52 g_23_53 4.993426e-04
Rgh_23_53 g_23_53 g_24_53 4.993426e-04
Rgv_23_53 g_23_53 g_23_54 4.993426e-04
Rgh_23_54 g_23_54 g_24_54 4.993426e-04
Rgv_23_54 g_23_54 g_23_55 4.993426e-04
Rgh_23_55 g_23_55 g_24_55 4.993426e-04
Rgv_23_55 g_23_55 g_23_56 4.993426e-04
Rgh_23_56 g_23_56 g_24_56 4.993426e-04
Rgv_23_56 g_23_56 g_23_57 4.993426e-04
Rgh_23_57 g_23_57 g_24_57 4.993426e-04
Rgv_23_57 g_23_57 g_23_58 4.993426e-04
Rgh_23_58 g_23_58 g_24_58 4.993426e-04
Rgv_23_58 g_23_58 g_23_59 4.993426e-04
Rgh_23_59 g_23_59 g_24_59 4.993426e-04
Rgv_23_59 g_23_59 g_23_60 4.993426e-04
Rgh_23_60 g_23_60 g_24_60 4.993426e-04
Rgv_23_60 g_23_60 g_23_61 4.993426e-04
Rgh_23_61 g_23_61 g_24_61 4.993426e-04
Rgv_23_61 g_23_61 g_23_62 4.993426e-04
Rgh_23_62 g_23_62 g_24_62 4.993426e-04
Rgv_23_62 g_23_62 g_23_63 4.993426e-04
Rgh_23_63 g_23_63 g_24_63 4.993426e-04
Rgv_23_63 g_23_63 g_23_64 4.993426e-04
Rgh_23_64 g_23_64 g_24_64 4.993426e-04
Rgv_23_64 g_23_64 g_23_65 4.993426e-04
Rgh_23_65 g_23_65 g_24_65 4.993426e-04
Rgv_23_65 g_23_65 g_23_66 4.993426e-04
Rgh_23_66 g_23_66 g_24_66 4.993426e-04
Rgv_23_66 g_23_66 g_23_67 4.993426e-04
Rgh_23_67 g_23_67 g_24_67 4.993426e-04
Rgv_23_67 g_23_67 g_23_68 4.993426e-04
Rgh_23_68 g_23_68 g_24_68 4.993426e-04
Rgv_23_68 g_23_68 g_23_69 4.993426e-04
Rgh_23_69 g_23_69 g_24_69 4.993426e-04
Rgv_23_69 g_23_69 g_23_70 4.993426e-04
Rgh_23_70 g_23_70 g_24_70 4.993426e-04
Rgv_23_70 g_23_70 g_23_71 4.993426e-04
Rgh_23_71 g_23_71 g_24_71 4.993426e-04
Rgh_24_0 g_24_0 g_25_0 4.993426e-04
Rgv_24_0 g_24_0 g_24_1 4.993426e-04
Rgh_24_1 g_24_1 g_25_1 4.993426e-04
Rgv_24_1 g_24_1 g_24_2 4.993426e-04
Rgh_24_2 g_24_2 g_25_2 4.993426e-04
Rgv_24_2 g_24_2 g_24_3 4.993426e-04
Rgh_24_3 g_24_3 g_25_3 4.993426e-04
Rgv_24_3 g_24_3 g_24_4 4.993426e-04
Rgh_24_4 g_24_4 g_25_4 4.993426e-04
Rgv_24_4 g_24_4 g_24_5 4.993426e-04
Rgh_24_5 g_24_5 g_25_5 4.993426e-04
Rgv_24_5 g_24_5 g_24_6 4.993426e-04
Rgh_24_6 g_24_6 g_25_6 4.993426e-04
Rgv_24_6 g_24_6 g_24_7 4.993426e-04
Rgh_24_7 g_24_7 g_25_7 4.993426e-04
Rgv_24_7 g_24_7 g_24_8 4.993426e-04
Rgh_24_8 g_24_8 g_25_8 4.993426e-04
Rgv_24_8 g_24_8 g_24_9 4.993426e-04
Rgh_24_9 g_24_9 g_25_9 4.993426e-04
Rgv_24_9 g_24_9 g_24_10 4.993426e-04
Rgh_24_10 g_24_10 g_25_10 4.993426e-04
Rgv_24_10 g_24_10 g_24_11 4.993426e-04
Rgh_24_11 g_24_11 g_25_11 4.993426e-04
Rgv_24_11 g_24_11 g_24_12 4.993426e-04
Rgh_24_12 g_24_12 g_25_12 4.993426e-04
Rgv_24_12 g_24_12 g_24_13 4.993426e-04
Rgh_24_13 g_24_13 g_25_13 4.993426e-04
Rgv_24_13 g_24_13 g_24_14 4.993426e-04
Rgh_24_14 g_24_14 g_25_14 4.993426e-04
Rgv_24_14 g_24_14 g_24_15 4.993426e-04
Rgh_24_15 g_24_15 g_25_15 4.993426e-04
Rgv_24_15 g_24_15 g_24_16 4.993426e-04
Rgh_24_16 g_24_16 g_25_16 4.993426e-04
Rgv_24_16 g_24_16 g_24_17 4.993426e-04
Rgh_24_17 g_24_17 g_25_17 4.993426e-04
Rgv_24_17 g_24_17 g_24_18 4.993426e-04
Rgh_24_18 g_24_18 g_25_18 4.993426e-04
Rgv_24_18 g_24_18 g_24_19 4.993426e-04
Rgh_24_19 g_24_19 g_25_19 4.993426e-04
Rgv_24_19 g_24_19 g_24_20 4.993426e-04
Rgh_24_20 g_24_20 g_25_20 4.993426e-04
Rgv_24_20 g_24_20 g_24_21 4.993426e-04
Rgh_24_21 g_24_21 g_25_21 4.993426e-04
Rgv_24_21 g_24_21 g_24_22 4.993426e-04
Rgh_24_22 g_24_22 g_25_22 4.993426e-04
Rgv_24_22 g_24_22 g_24_23 4.993426e-04
Rgh_24_23 g_24_23 g_25_23 4.993426e-04
Rgv_24_23 g_24_23 g_24_24 4.993426e-04
Rgh_24_24 g_24_24 g_25_24 4.993426e-04
Rgv_24_24 g_24_24 g_24_25 4.993426e-04
Rgh_24_25 g_24_25 g_25_25 4.993426e-04
Rgv_24_25 g_24_25 g_24_26 4.993426e-04
Rgh_24_26 g_24_26 g_25_26 4.993426e-04
Rgv_24_26 g_24_26 g_24_27 4.993426e-04
Rgh_24_27 g_24_27 g_25_27 4.993426e-04
Rgv_24_27 g_24_27 g_24_28 4.993426e-04
Rgh_24_28 g_24_28 g_25_28 4.993426e-04
Rgv_24_28 g_24_28 g_24_29 4.993426e-04
Rgh_24_29 g_24_29 g_25_29 4.993426e-04
Rgv_24_29 g_24_29 g_24_30 4.993426e-04
Rgh_24_30 g_24_30 g_25_30 4.993426e-04
Rgv_24_30 g_24_30 g_24_31 4.993426e-04
Rgh_24_31 g_24_31 g_25_31 4.993426e-04
Rgv_24_31 g_24_31 g_24_32 4.993426e-04
Rgh_24_32 g_24_32 g_25_32 4.993426e-04
Rgv_24_32 g_24_32 g_24_33 4.993426e-04
Rgh_24_33 g_24_33 g_25_33 4.993426e-04
Rgv_24_33 g_24_33 g_24_34 4.993426e-04
Rgh_24_34 g_24_34 g_25_34 4.993426e-04
Rgv_24_34 g_24_34 g_24_35 4.993426e-04
Rgh_24_35 g_24_35 g_25_35 4.993426e-04
Rgv_24_35 g_24_35 g_24_36 4.993426e-04
Rgh_24_36 g_24_36 g_25_36 4.993426e-04
Rgv_24_36 g_24_36 g_24_37 4.993426e-04
Rgh_24_37 g_24_37 g_25_37 4.993426e-04
Rgv_24_37 g_24_37 g_24_38 4.993426e-04
Rgh_24_38 g_24_38 g_25_38 4.993426e-04
Rgv_24_38 g_24_38 g_24_39 4.993426e-04
Rgh_24_39 g_24_39 g_25_39 4.993426e-04
Rgv_24_39 g_24_39 g_24_40 4.993426e-04
Rgh_24_40 g_24_40 g_25_40 4.993426e-04
Rgv_24_40 g_24_40 g_24_41 4.993426e-04
Rgh_24_41 g_24_41 g_25_41 4.993426e-04
Rgv_24_41 g_24_41 g_24_42 4.993426e-04
Rgh_24_42 g_24_42 g_25_42 4.993426e-04
Rgv_24_42 g_24_42 g_24_43 4.993426e-04
Rgh_24_43 g_24_43 g_25_43 4.993426e-04
Rgv_24_43 g_24_43 g_24_44 4.993426e-04
Rgh_24_44 g_24_44 g_25_44 4.993426e-04
Rgv_24_44 g_24_44 g_24_45 4.993426e-04
Rgh_24_45 g_24_45 g_25_45 4.993426e-04
Rgv_24_45 g_24_45 g_24_46 4.993426e-04
Rgh_24_46 g_24_46 g_25_46 4.993426e-04
Rgv_24_46 g_24_46 g_24_47 4.993426e-04
Rgh_24_47 g_24_47 g_25_47 4.993426e-04
Rgv_24_47 g_24_47 g_24_48 4.993426e-04
Rgh_24_48 g_24_48 g_25_48 4.993426e-04
Rgv_24_48 g_24_48 g_24_49 4.993426e-04
Rgh_24_49 g_24_49 g_25_49 4.993426e-04
Rgv_24_49 g_24_49 g_24_50 4.993426e-04
Rgh_24_50 g_24_50 g_25_50 4.993426e-04
Rgv_24_50 g_24_50 g_24_51 4.993426e-04
Rgh_24_51 g_24_51 g_25_51 4.993426e-04
Rgv_24_51 g_24_51 g_24_52 4.993426e-04
Rgh_24_52 g_24_52 g_25_52 4.993426e-04
Rgv_24_52 g_24_52 g_24_53 4.993426e-04
Rgh_24_53 g_24_53 g_25_53 4.993426e-04
Rgv_24_53 g_24_53 g_24_54 4.993426e-04
Rgh_24_54 g_24_54 g_25_54 4.993426e-04
Rgv_24_54 g_24_54 g_24_55 4.993426e-04
Rgh_24_55 g_24_55 g_25_55 4.993426e-04
Rgv_24_55 g_24_55 g_24_56 4.993426e-04
Rgh_24_56 g_24_56 g_25_56 4.993426e-04
Rgv_24_56 g_24_56 g_24_57 4.993426e-04
Rgh_24_57 g_24_57 g_25_57 4.993426e-04
Rgv_24_57 g_24_57 g_24_58 4.993426e-04
Rgh_24_58 g_24_58 g_25_58 4.993426e-04
Rgv_24_58 g_24_58 g_24_59 4.993426e-04
Rgh_24_59 g_24_59 g_25_59 4.993426e-04
Rgv_24_59 g_24_59 g_24_60 4.993426e-04
Rgh_24_60 g_24_60 g_25_60 4.993426e-04
Rgv_24_60 g_24_60 g_24_61 4.993426e-04
Rgh_24_61 g_24_61 g_25_61 4.993426e-04
Rgv_24_61 g_24_61 g_24_62 4.993426e-04
Rgh_24_62 g_24_62 g_25_62 4.993426e-04
Rgv_24_62 g_24_62 g_24_63 4.993426e-04
Rgh_24_63 g_24_63 g_25_63 4.993426e-04
Rgv_24_63 g_24_63 g_24_64 4.993426e-04
Rgh_24_64 g_24_64 g_25_64 4.993426e-04
Rgv_24_64 g_24_64 g_24_65 4.993426e-04
Rgh_24_65 g_24_65 g_25_65 4.993426e-04
Rgv_24_65 g_24_65 g_24_66 4.993426e-04
Rgh_24_66 g_24_66 g_25_66 4.993426e-04
Rgv_24_66 g_24_66 g_24_67 4.993426e-04
Rgh_24_67 g_24_67 g_25_67 4.993426e-04
Rgv_24_67 g_24_67 g_24_68 4.993426e-04
Rgh_24_68 g_24_68 g_25_68 4.993426e-04
Rgv_24_68 g_24_68 g_24_69 4.993426e-04
Rgh_24_69 g_24_69 g_25_69 4.993426e-04
Rgv_24_69 g_24_69 g_24_70 4.993426e-04
Rgh_24_70 g_24_70 g_25_70 4.993426e-04
Rgv_24_70 g_24_70 g_24_71 4.993426e-04
Rgh_24_71 g_24_71 g_25_71 4.993426e-04
Rgh_25_0 g_25_0 g_26_0 4.993426e-04
Rgv_25_0 g_25_0 g_25_1 4.993426e-04
Rgh_25_1 g_25_1 g_26_1 4.993426e-04
Rgv_25_1 g_25_1 g_25_2 4.993426e-04
Rgh_25_2 g_25_2 g_26_2 4.993426e-04
Rgv_25_2 g_25_2 g_25_3 4.993426e-04
Rgh_25_3 g_25_3 g_26_3 4.993426e-04
Rgv_25_3 g_25_3 g_25_4 4.993426e-04
Rgh_25_4 g_25_4 g_26_4 4.993426e-04
Rgv_25_4 g_25_4 g_25_5 4.993426e-04
Rgh_25_5 g_25_5 g_26_5 4.993426e-04
Rgv_25_5 g_25_5 g_25_6 4.993426e-04
Rgh_25_6 g_25_6 g_26_6 4.993426e-04
Rgv_25_6 g_25_6 g_25_7 4.993426e-04
Rgh_25_7 g_25_7 g_26_7 4.993426e-04
Rgv_25_7 g_25_7 g_25_8 4.993426e-04
Rgh_25_8 g_25_8 g_26_8 4.993426e-04
Rgv_25_8 g_25_8 g_25_9 4.993426e-04
Rgh_25_9 g_25_9 g_26_9 4.993426e-04
Rgv_25_9 g_25_9 g_25_10 4.993426e-04
Rgh_25_10 g_25_10 g_26_10 4.993426e-04
Rgv_25_10 g_25_10 g_25_11 4.993426e-04
Rgh_25_11 g_25_11 g_26_11 4.993426e-04
Rgv_25_11 g_25_11 g_25_12 4.993426e-04
Rgh_25_12 g_25_12 g_26_12 4.993426e-04
Rgv_25_12 g_25_12 g_25_13 4.993426e-04
Rgh_25_13 g_25_13 g_26_13 4.993426e-04
Rgv_25_13 g_25_13 g_25_14 4.993426e-04
Rgh_25_14 g_25_14 g_26_14 4.993426e-04
Rgv_25_14 g_25_14 g_25_15 4.993426e-04
Rgh_25_15 g_25_15 g_26_15 4.993426e-04
Rgv_25_15 g_25_15 g_25_16 4.993426e-04
Rgh_25_16 g_25_16 g_26_16 4.993426e-04
Rgv_25_16 g_25_16 g_25_17 4.993426e-04
Rgh_25_17 g_25_17 g_26_17 4.993426e-04
Rgv_25_17 g_25_17 g_25_18 4.993426e-04
Rgh_25_18 g_25_18 g_26_18 4.993426e-04
Rgv_25_18 g_25_18 g_25_19 4.993426e-04
Rgh_25_19 g_25_19 g_26_19 4.993426e-04
Rgv_25_19 g_25_19 g_25_20 4.993426e-04
Rgh_25_20 g_25_20 g_26_20 4.993426e-04
Rgv_25_20 g_25_20 g_25_21 4.993426e-04
Rgh_25_21 g_25_21 g_26_21 4.993426e-04
Rgv_25_21 g_25_21 g_25_22 4.993426e-04
Rgh_25_22 g_25_22 g_26_22 4.993426e-04
Rgv_25_22 g_25_22 g_25_23 4.993426e-04
Rgh_25_23 g_25_23 g_26_23 4.993426e-04
Rgv_25_23 g_25_23 g_25_24 4.993426e-04
Rgh_25_24 g_25_24 g_26_24 4.993426e-04
Rgv_25_24 g_25_24 g_25_25 4.993426e-04
Rgh_25_25 g_25_25 g_26_25 4.993426e-04
Rgv_25_25 g_25_25 g_25_26 4.993426e-04
Rgh_25_26 g_25_26 g_26_26 4.993426e-04
Rgv_25_26 g_25_26 g_25_27 4.993426e-04
Rgh_25_27 g_25_27 g_26_27 4.993426e-04
Rgv_25_27 g_25_27 g_25_28 4.993426e-04
Rgh_25_28 g_25_28 g_26_28 4.993426e-04
Rgv_25_28 g_25_28 g_25_29 4.993426e-04
Rgh_25_29 g_25_29 g_26_29 4.993426e-04
Rgv_25_29 g_25_29 g_25_30 4.993426e-04
Rgh_25_30 g_25_30 g_26_30 4.993426e-04
Rgv_25_30 g_25_30 g_25_31 4.993426e-04
Rgh_25_31 g_25_31 g_26_31 4.993426e-04
Rgv_25_31 g_25_31 g_25_32 4.993426e-04
Rgh_25_32 g_25_32 g_26_32 4.993426e-04
Rgv_25_32 g_25_32 g_25_33 4.993426e-04
Rgh_25_33 g_25_33 g_26_33 4.993426e-04
Rgv_25_33 g_25_33 g_25_34 4.993426e-04
Rgh_25_34 g_25_34 g_26_34 4.993426e-04
Rgv_25_34 g_25_34 g_25_35 4.993426e-04
Rgh_25_35 g_25_35 g_26_35 4.993426e-04
Rgv_25_35 g_25_35 g_25_36 4.993426e-04
Rgh_25_36 g_25_36 g_26_36 4.993426e-04
Rgv_25_36 g_25_36 g_25_37 4.993426e-04
Rgh_25_37 g_25_37 g_26_37 4.993426e-04
Rgv_25_37 g_25_37 g_25_38 4.993426e-04
Rgh_25_38 g_25_38 g_26_38 4.993426e-04
Rgv_25_38 g_25_38 g_25_39 4.993426e-04
Rgh_25_39 g_25_39 g_26_39 4.993426e-04
Rgv_25_39 g_25_39 g_25_40 4.993426e-04
Rgh_25_40 g_25_40 g_26_40 4.993426e-04
Rgv_25_40 g_25_40 g_25_41 4.993426e-04
Rgh_25_41 g_25_41 g_26_41 4.993426e-04
Rgv_25_41 g_25_41 g_25_42 4.993426e-04
Rgh_25_42 g_25_42 g_26_42 4.993426e-04
Rgv_25_42 g_25_42 g_25_43 4.993426e-04
Rgh_25_43 g_25_43 g_26_43 4.993426e-04
Rgv_25_43 g_25_43 g_25_44 4.993426e-04
Rgh_25_44 g_25_44 g_26_44 4.993426e-04
Rgv_25_44 g_25_44 g_25_45 4.993426e-04
Rgh_25_45 g_25_45 g_26_45 4.993426e-04
Rgv_25_45 g_25_45 g_25_46 4.993426e-04
Rgh_25_46 g_25_46 g_26_46 4.993426e-04
Rgv_25_46 g_25_46 g_25_47 4.993426e-04
Rgh_25_47 g_25_47 g_26_47 4.993426e-04
Rgv_25_47 g_25_47 g_25_48 4.993426e-04
Rgh_25_48 g_25_48 g_26_48 4.993426e-04
Rgv_25_48 g_25_48 g_25_49 4.993426e-04
Rgh_25_49 g_25_49 g_26_49 4.993426e-04
Rgv_25_49 g_25_49 g_25_50 4.993426e-04
Rgh_25_50 g_25_50 g_26_50 4.993426e-04
Rgv_25_50 g_25_50 g_25_51 4.993426e-04
Rgh_25_51 g_25_51 g_26_51 4.993426e-04
Rgv_25_51 g_25_51 g_25_52 4.993426e-04
Rgh_25_52 g_25_52 g_26_52 4.993426e-04
Rgv_25_52 g_25_52 g_25_53 4.993426e-04
Rgh_25_53 g_25_53 g_26_53 4.993426e-04
Rgv_25_53 g_25_53 g_25_54 4.993426e-04
Rgh_25_54 g_25_54 g_26_54 4.993426e-04
Rgv_25_54 g_25_54 g_25_55 4.993426e-04
Rgh_25_55 g_25_55 g_26_55 4.993426e-04
Rgv_25_55 g_25_55 g_25_56 4.993426e-04
Rgh_25_56 g_25_56 g_26_56 4.993426e-04
Rgv_25_56 g_25_56 g_25_57 4.993426e-04
Rgh_25_57 g_25_57 g_26_57 4.993426e-04
Rgv_25_57 g_25_57 g_25_58 4.993426e-04
Rgh_25_58 g_25_58 g_26_58 4.993426e-04
Rgv_25_58 g_25_58 g_25_59 4.993426e-04
Rgh_25_59 g_25_59 g_26_59 4.993426e-04
Rgv_25_59 g_25_59 g_25_60 4.993426e-04
Rgh_25_60 g_25_60 g_26_60 4.993426e-04
Rgv_25_60 g_25_60 g_25_61 4.993426e-04
Rgh_25_61 g_25_61 g_26_61 4.993426e-04
Rgv_25_61 g_25_61 g_25_62 4.993426e-04
Rgh_25_62 g_25_62 g_26_62 4.993426e-04
Rgv_25_62 g_25_62 g_25_63 4.993426e-04
Rgh_25_63 g_25_63 g_26_63 4.993426e-04
Rgv_25_63 g_25_63 g_25_64 4.993426e-04
Rgh_25_64 g_25_64 g_26_64 4.993426e-04
Rgv_25_64 g_25_64 g_25_65 4.993426e-04
Rgh_25_65 g_25_65 g_26_65 4.993426e-04
Rgv_25_65 g_25_65 g_25_66 4.993426e-04
Rgh_25_66 g_25_66 g_26_66 4.993426e-04
Rgv_25_66 g_25_66 g_25_67 4.993426e-04
Rgh_25_67 g_25_67 g_26_67 4.993426e-04
Rgv_25_67 g_25_67 g_25_68 4.993426e-04
Rgh_25_68 g_25_68 g_26_68 4.993426e-04
Rgv_25_68 g_25_68 g_25_69 4.993426e-04
Rgh_25_69 g_25_69 g_26_69 4.993426e-04
Rgv_25_69 g_25_69 g_25_70 4.993426e-04
Rgh_25_70 g_25_70 g_26_70 4.993426e-04
Rgv_25_70 g_25_70 g_25_71 4.993426e-04
Rgh_25_71 g_25_71 g_26_71 4.993426e-04
Rgh_26_0 g_26_0 g_27_0 4.993426e-04
Rgv_26_0 g_26_0 g_26_1 4.993426e-04
Rgh_26_1 g_26_1 g_27_1 4.993426e-04
Rgv_26_1 g_26_1 g_26_2 4.993426e-04
Rgh_26_2 g_26_2 g_27_2 4.993426e-04
Rgv_26_2 g_26_2 g_26_3 4.993426e-04
Rgh_26_3 g_26_3 g_27_3 4.993426e-04
Rgv_26_3 g_26_3 g_26_4 4.993426e-04
Rgh_26_4 g_26_4 g_27_4 4.993426e-04
Rgv_26_4 g_26_4 g_26_5 4.993426e-04
Rgh_26_5 g_26_5 g_27_5 4.993426e-04
Rgv_26_5 g_26_5 g_26_6 4.993426e-04
Rgh_26_6 g_26_6 g_27_6 4.993426e-04
Rgv_26_6 g_26_6 g_26_7 4.993426e-04
Rgh_26_7 g_26_7 g_27_7 4.993426e-04
Rgv_26_7 g_26_7 g_26_8 4.993426e-04
Rgh_26_8 g_26_8 g_27_8 4.993426e-04
Rgv_26_8 g_26_8 g_26_9 4.993426e-04
Rgh_26_9 g_26_9 g_27_9 4.993426e-04
Rgv_26_9 g_26_9 g_26_10 4.993426e-04
Rgh_26_10 g_26_10 g_27_10 4.993426e-04
Rgv_26_10 g_26_10 g_26_11 4.993426e-04
Rgh_26_11 g_26_11 g_27_11 4.993426e-04
Rgv_26_11 g_26_11 g_26_12 4.993426e-04
Rgh_26_12 g_26_12 g_27_12 4.993426e-04
Rgv_26_12 g_26_12 g_26_13 4.993426e-04
Rgh_26_13 g_26_13 g_27_13 4.993426e-04
Rgv_26_13 g_26_13 g_26_14 4.993426e-04
Rgh_26_14 g_26_14 g_27_14 4.993426e-04
Rgv_26_14 g_26_14 g_26_15 4.993426e-04
Rgh_26_15 g_26_15 g_27_15 4.993426e-04
Rgv_26_15 g_26_15 g_26_16 4.993426e-04
Rgh_26_16 g_26_16 g_27_16 4.993426e-04
Rgv_26_16 g_26_16 g_26_17 4.993426e-04
Rgh_26_17 g_26_17 g_27_17 4.993426e-04
Rgv_26_17 g_26_17 g_26_18 4.993426e-04
Rgh_26_18 g_26_18 g_27_18 4.993426e-04
Rgv_26_18 g_26_18 g_26_19 4.993426e-04
Rgh_26_19 g_26_19 g_27_19 4.993426e-04
Rgv_26_19 g_26_19 g_26_20 4.993426e-04
Rgh_26_20 g_26_20 g_27_20 4.993426e-04
Rgv_26_20 g_26_20 g_26_21 4.993426e-04
Rgh_26_21 g_26_21 g_27_21 4.993426e-04
Rgv_26_21 g_26_21 g_26_22 4.993426e-04
Rgh_26_22 g_26_22 g_27_22 4.993426e-04
Rgv_26_22 g_26_22 g_26_23 4.993426e-04
Rgh_26_23 g_26_23 g_27_23 4.993426e-04
Rgv_26_23 g_26_23 g_26_24 4.993426e-04
Rgh_26_24 g_26_24 g_27_24 4.993426e-04
Rgv_26_24 g_26_24 g_26_25 4.993426e-04
Rgh_26_25 g_26_25 g_27_25 4.993426e-04
Rgv_26_25 g_26_25 g_26_26 4.993426e-04
Rgh_26_26 g_26_26 g_27_26 4.993426e-04
Rgv_26_26 g_26_26 g_26_27 4.993426e-04
Rgh_26_27 g_26_27 g_27_27 4.993426e-04
Rgv_26_27 g_26_27 g_26_28 4.993426e-04
Rgh_26_28 g_26_28 g_27_28 4.993426e-04
Rgv_26_28 g_26_28 g_26_29 4.993426e-04
Rgh_26_29 g_26_29 g_27_29 4.993426e-04
Rgv_26_29 g_26_29 g_26_30 4.993426e-04
Rgh_26_30 g_26_30 g_27_30 4.993426e-04
Rgv_26_30 g_26_30 g_26_31 4.993426e-04
Rgh_26_31 g_26_31 g_27_31 4.993426e-04
Rgv_26_31 g_26_31 g_26_32 4.993426e-04
Rgh_26_32 g_26_32 g_27_32 4.993426e-04
Rgv_26_32 g_26_32 g_26_33 4.993426e-04
Rgh_26_33 g_26_33 g_27_33 4.993426e-04
Rgv_26_33 g_26_33 g_26_34 4.993426e-04
Rgh_26_34 g_26_34 g_27_34 4.993426e-04
Rgv_26_34 g_26_34 g_26_35 4.993426e-04
Rgh_26_35 g_26_35 g_27_35 4.993426e-04
Rgv_26_35 g_26_35 g_26_36 4.993426e-04
Rgh_26_36 g_26_36 g_27_36 4.993426e-04
Rgv_26_36 g_26_36 g_26_37 4.993426e-04
Rgh_26_37 g_26_37 g_27_37 4.993426e-04
Rgv_26_37 g_26_37 g_26_38 4.993426e-04
Rgh_26_38 g_26_38 g_27_38 4.993426e-04
Rgv_26_38 g_26_38 g_26_39 4.993426e-04
Rgh_26_39 g_26_39 g_27_39 4.993426e-04
Rgv_26_39 g_26_39 g_26_40 4.993426e-04
Rgh_26_40 g_26_40 g_27_40 4.993426e-04
Rgv_26_40 g_26_40 g_26_41 4.993426e-04
Rgh_26_41 g_26_41 g_27_41 4.993426e-04
Rgv_26_41 g_26_41 g_26_42 4.993426e-04
Rgh_26_42 g_26_42 g_27_42 4.993426e-04
Rgv_26_42 g_26_42 g_26_43 4.993426e-04
Rgh_26_43 g_26_43 g_27_43 4.993426e-04
Rgv_26_43 g_26_43 g_26_44 4.993426e-04
Rgh_26_44 g_26_44 g_27_44 4.993426e-04
Rgv_26_44 g_26_44 g_26_45 4.993426e-04
Rgh_26_45 g_26_45 g_27_45 4.993426e-04
Rgv_26_45 g_26_45 g_26_46 4.993426e-04
Rgh_26_46 g_26_46 g_27_46 4.993426e-04
Rgv_26_46 g_26_46 g_26_47 4.993426e-04
Rgh_26_47 g_26_47 g_27_47 4.993426e-04
Rgv_26_47 g_26_47 g_26_48 4.993426e-04
Rgh_26_48 g_26_48 g_27_48 4.993426e-04
Rgv_26_48 g_26_48 g_26_49 4.993426e-04
Rgh_26_49 g_26_49 g_27_49 4.993426e-04
Rgv_26_49 g_26_49 g_26_50 4.993426e-04
Rgh_26_50 g_26_50 g_27_50 4.993426e-04
Rgv_26_50 g_26_50 g_26_51 4.993426e-04
Rgh_26_51 g_26_51 g_27_51 4.993426e-04
Rgv_26_51 g_26_51 g_26_52 4.993426e-04
Rgh_26_52 g_26_52 g_27_52 4.993426e-04
Rgv_26_52 g_26_52 g_26_53 4.993426e-04
Rgh_26_53 g_26_53 g_27_53 4.993426e-04
Rgv_26_53 g_26_53 g_26_54 4.993426e-04
Rgh_26_54 g_26_54 g_27_54 4.993426e-04
Rgv_26_54 g_26_54 g_26_55 4.993426e-04
Rgh_26_55 g_26_55 g_27_55 4.993426e-04
Rgv_26_55 g_26_55 g_26_56 4.993426e-04
Rgh_26_56 g_26_56 g_27_56 4.993426e-04
Rgv_26_56 g_26_56 g_26_57 4.993426e-04
Rgh_26_57 g_26_57 g_27_57 4.993426e-04
Rgv_26_57 g_26_57 g_26_58 4.993426e-04
Rgh_26_58 g_26_58 g_27_58 4.993426e-04
Rgv_26_58 g_26_58 g_26_59 4.993426e-04
Rgh_26_59 g_26_59 g_27_59 4.993426e-04
Rgv_26_59 g_26_59 g_26_60 4.993426e-04
Rgh_26_60 g_26_60 g_27_60 4.993426e-04
Rgv_26_60 g_26_60 g_26_61 4.993426e-04
Rgh_26_61 g_26_61 g_27_61 4.993426e-04
Rgv_26_61 g_26_61 g_26_62 4.993426e-04
Rgh_26_62 g_26_62 g_27_62 4.993426e-04
Rgv_26_62 g_26_62 g_26_63 4.993426e-04
Rgh_26_63 g_26_63 g_27_63 4.993426e-04
Rgv_26_63 g_26_63 g_26_64 4.993426e-04
Rgh_26_64 g_26_64 g_27_64 4.993426e-04
Rgv_26_64 g_26_64 g_26_65 4.993426e-04
Rgh_26_65 g_26_65 g_27_65 4.993426e-04
Rgv_26_65 g_26_65 g_26_66 4.993426e-04
Rgh_26_66 g_26_66 g_27_66 4.993426e-04
Rgv_26_66 g_26_66 g_26_67 4.993426e-04
Rgh_26_67 g_26_67 g_27_67 4.993426e-04
Rgv_26_67 g_26_67 g_26_68 4.993426e-04
Rgh_26_68 g_26_68 g_27_68 4.993426e-04
Rgv_26_68 g_26_68 g_26_69 4.993426e-04
Rgh_26_69 g_26_69 g_27_69 4.993426e-04
Rgv_26_69 g_26_69 g_26_70 4.993426e-04
Rgh_26_70 g_26_70 g_27_70 4.993426e-04
Rgv_26_70 g_26_70 g_26_71 4.993426e-04
Rgh_26_71 g_26_71 g_27_71 4.993426e-04
Rgh_27_0 g_27_0 g_28_0 4.993426e-04
Rgv_27_0 g_27_0 g_27_1 4.993426e-04
Rgh_27_1 g_27_1 g_28_1 4.993426e-04
Rgv_27_1 g_27_1 g_27_2 4.993426e-04
Rgh_27_2 g_27_2 g_28_2 4.993426e-04
Rgv_27_2 g_27_2 g_27_3 4.993426e-04
Rgh_27_3 g_27_3 g_28_3 4.993426e-04
Rgv_27_3 g_27_3 g_27_4 4.993426e-04
Rgh_27_4 g_27_4 g_28_4 4.993426e-04
Rgv_27_4 g_27_4 g_27_5 4.993426e-04
Rgh_27_5 g_27_5 g_28_5 4.993426e-04
Rgv_27_5 g_27_5 g_27_6 4.993426e-04
Rgh_27_6 g_27_6 g_28_6 4.993426e-04
Rgv_27_6 g_27_6 g_27_7 4.993426e-04
Rgh_27_7 g_27_7 g_28_7 4.993426e-04
Rgv_27_7 g_27_7 g_27_8 4.993426e-04
Rgh_27_8 g_27_8 g_28_8 4.993426e-04
Rgv_27_8 g_27_8 g_27_9 4.993426e-04
Rgh_27_9 g_27_9 g_28_9 4.993426e-04
Rgv_27_9 g_27_9 g_27_10 4.993426e-04
Rgh_27_10 g_27_10 g_28_10 4.993426e-04
Rgv_27_10 g_27_10 g_27_11 4.993426e-04
Rgh_27_11 g_27_11 g_28_11 4.993426e-04
Rgv_27_11 g_27_11 g_27_12 4.993426e-04
Rgh_27_12 g_27_12 g_28_12 4.993426e-04
Rgv_27_12 g_27_12 g_27_13 4.993426e-04
Rgh_27_13 g_27_13 g_28_13 4.993426e-04
Rgv_27_13 g_27_13 g_27_14 4.993426e-04
Rgh_27_14 g_27_14 g_28_14 4.993426e-04
Rgv_27_14 g_27_14 g_27_15 4.993426e-04
Rgh_27_15 g_27_15 g_28_15 4.993426e-04
Rgv_27_15 g_27_15 g_27_16 4.993426e-04
Rgh_27_16 g_27_16 g_28_16 4.993426e-04
Rgv_27_16 g_27_16 g_27_17 4.993426e-04
Rgh_27_17 g_27_17 g_28_17 4.993426e-04
Rgv_27_17 g_27_17 g_27_18 4.993426e-04
Rgh_27_18 g_27_18 g_28_18 4.993426e-04
Rgv_27_18 g_27_18 g_27_19 4.993426e-04
Rgh_27_19 g_27_19 g_28_19 4.993426e-04
Rgv_27_19 g_27_19 g_27_20 4.993426e-04
Rgh_27_20 g_27_20 g_28_20 4.993426e-04
Rgv_27_20 g_27_20 g_27_21 4.993426e-04
Rgh_27_21 g_27_21 g_28_21 4.993426e-04
Rgv_27_21 g_27_21 g_27_22 4.993426e-04
Rgh_27_22 g_27_22 g_28_22 4.993426e-04
Rgv_27_22 g_27_22 g_27_23 4.993426e-04
Rgh_27_23 g_27_23 g_28_23 4.993426e-04
Rgv_27_23 g_27_23 g_27_24 4.993426e-04
Rgh_27_24 g_27_24 g_28_24 4.993426e-04
Rgv_27_24 g_27_24 g_27_25 4.993426e-04
Rgh_27_25 g_27_25 g_28_25 4.993426e-04
Rgv_27_25 g_27_25 g_27_26 4.993426e-04
Rgh_27_26 g_27_26 g_28_26 4.993426e-04
Rgv_27_26 g_27_26 g_27_27 4.993426e-04
Rgh_27_27 g_27_27 g_28_27 4.993426e-04
Rgv_27_27 g_27_27 g_27_28 4.993426e-04
Rgh_27_28 g_27_28 g_28_28 4.993426e-04
Rgv_27_28 g_27_28 g_27_29 4.993426e-04
Rgh_27_29 g_27_29 g_28_29 4.993426e-04
Rgv_27_29 g_27_29 g_27_30 4.993426e-04
Rgh_27_30 g_27_30 g_28_30 4.993426e-04
Rgv_27_30 g_27_30 g_27_31 4.993426e-04
Rgh_27_31 g_27_31 g_28_31 4.993426e-04
Rgv_27_31 g_27_31 g_27_32 4.993426e-04
Rgh_27_32 g_27_32 g_28_32 4.993426e-04
Rgv_27_32 g_27_32 g_27_33 4.993426e-04
Rgh_27_33 g_27_33 g_28_33 4.993426e-04
Rgv_27_33 g_27_33 g_27_34 4.993426e-04
Rgh_27_34 g_27_34 g_28_34 4.993426e-04
Rgv_27_34 g_27_34 g_27_35 4.993426e-04
Rgh_27_35 g_27_35 g_28_35 4.993426e-04
Rgv_27_35 g_27_35 g_27_36 4.993426e-04
Rgh_27_36 g_27_36 g_28_36 4.993426e-04
Rgv_27_36 g_27_36 g_27_37 4.993426e-04
Rgh_27_37 g_27_37 g_28_37 4.993426e-04
Rgv_27_37 g_27_37 g_27_38 4.993426e-04
Rgh_27_38 g_27_38 g_28_38 4.993426e-04
Rgv_27_38 g_27_38 g_27_39 4.993426e-04
Rgh_27_39 g_27_39 g_28_39 4.993426e-04
Rgv_27_39 g_27_39 g_27_40 4.993426e-04
Rgh_27_40 g_27_40 g_28_40 4.993426e-04
Rgv_27_40 g_27_40 g_27_41 4.993426e-04
Rgh_27_41 g_27_41 g_28_41 4.993426e-04
Rgv_27_41 g_27_41 g_27_42 4.993426e-04
Rgh_27_42 g_27_42 g_28_42 4.993426e-04
Rgv_27_42 g_27_42 g_27_43 4.993426e-04
Rgh_27_43 g_27_43 g_28_43 4.993426e-04
Rgv_27_43 g_27_43 g_27_44 4.993426e-04
Rgh_27_44 g_27_44 g_28_44 4.993426e-04
Rgv_27_44 g_27_44 g_27_45 4.993426e-04
Rgh_27_45 g_27_45 g_28_45 4.993426e-04
Rgv_27_45 g_27_45 g_27_46 4.993426e-04
Rgh_27_46 g_27_46 g_28_46 4.993426e-04
Rgv_27_46 g_27_46 g_27_47 4.993426e-04
Rgh_27_47 g_27_47 g_28_47 4.993426e-04
Rgv_27_47 g_27_47 g_27_48 4.993426e-04
Rgh_27_48 g_27_48 g_28_48 4.993426e-04
Rgv_27_48 g_27_48 g_27_49 4.993426e-04
Rgh_27_49 g_27_49 g_28_49 4.993426e-04
Rgv_27_49 g_27_49 g_27_50 4.993426e-04
Rgh_27_50 g_27_50 g_28_50 4.993426e-04
Rgv_27_50 g_27_50 g_27_51 4.993426e-04
Rgh_27_51 g_27_51 g_28_51 4.993426e-04
Rgv_27_51 g_27_51 g_27_52 4.993426e-04
Rgh_27_52 g_27_52 g_28_52 4.993426e-04
Rgv_27_52 g_27_52 g_27_53 4.993426e-04
Rgh_27_53 g_27_53 g_28_53 4.993426e-04
Rgv_27_53 g_27_53 g_27_54 4.993426e-04
Rgh_27_54 g_27_54 g_28_54 4.993426e-04
Rgv_27_54 g_27_54 g_27_55 4.993426e-04
Rgh_27_55 g_27_55 g_28_55 4.993426e-04
Rgv_27_55 g_27_55 g_27_56 4.993426e-04
Rgh_27_56 g_27_56 g_28_56 4.993426e-04
Rgv_27_56 g_27_56 g_27_57 4.993426e-04
Rgh_27_57 g_27_57 g_28_57 4.993426e-04
Rgv_27_57 g_27_57 g_27_58 4.993426e-04
Rgh_27_58 g_27_58 g_28_58 4.993426e-04
Rgv_27_58 g_27_58 g_27_59 4.993426e-04
Rgh_27_59 g_27_59 g_28_59 4.993426e-04
Rgv_27_59 g_27_59 g_27_60 4.993426e-04
Rgh_27_60 g_27_60 g_28_60 4.993426e-04
Rgv_27_60 g_27_60 g_27_61 4.993426e-04
Rgh_27_61 g_27_61 g_28_61 4.993426e-04
Rgv_27_61 g_27_61 g_27_62 4.993426e-04
Rgh_27_62 g_27_62 g_28_62 4.993426e-04
Rgv_27_62 g_27_62 g_27_63 4.993426e-04
Rgh_27_63 g_27_63 g_28_63 4.993426e-04
Rgv_27_63 g_27_63 g_27_64 4.993426e-04
Rgh_27_64 g_27_64 g_28_64 4.993426e-04
Rgv_27_64 g_27_64 g_27_65 4.993426e-04
Rgh_27_65 g_27_65 g_28_65 4.993426e-04
Rgv_27_65 g_27_65 g_27_66 4.993426e-04
Rgh_27_66 g_27_66 g_28_66 4.993426e-04
Rgv_27_66 g_27_66 g_27_67 4.993426e-04
Rgh_27_67 g_27_67 g_28_67 4.993426e-04
Rgv_27_67 g_27_67 g_27_68 4.993426e-04
Rgh_27_68 g_27_68 g_28_68 4.993426e-04
Rgv_27_68 g_27_68 g_27_69 4.993426e-04
Rgh_27_69 g_27_69 g_28_69 4.993426e-04
Rgv_27_69 g_27_69 g_27_70 4.993426e-04
Rgh_27_70 g_27_70 g_28_70 4.993426e-04
Rgv_27_70 g_27_70 g_27_71 4.993426e-04
Rgh_27_71 g_27_71 g_28_71 4.993426e-04
Rgh_28_0 g_28_0 g_29_0 4.993426e-04
Rgv_28_0 g_28_0 g_28_1 4.993426e-04
Rgh_28_1 g_28_1 g_29_1 4.993426e-04
Rgv_28_1 g_28_1 g_28_2 4.993426e-04
Rgh_28_2 g_28_2 g_29_2 4.993426e-04
Rgv_28_2 g_28_2 g_28_3 4.993426e-04
Rgh_28_3 g_28_3 g_29_3 4.993426e-04
Rgv_28_3 g_28_3 g_28_4 4.993426e-04
Rgh_28_4 g_28_4 g_29_4 4.993426e-04
Rgv_28_4 g_28_4 g_28_5 4.993426e-04
Rgh_28_5 g_28_5 g_29_5 4.993426e-04
Rgv_28_5 g_28_5 g_28_6 4.993426e-04
Rgh_28_6 g_28_6 g_29_6 4.993426e-04
Rgv_28_6 g_28_6 g_28_7 4.993426e-04
Rgh_28_7 g_28_7 g_29_7 4.993426e-04
Rgv_28_7 g_28_7 g_28_8 4.993426e-04
Rgh_28_8 g_28_8 g_29_8 4.993426e-04
Rgv_28_8 g_28_8 g_28_9 4.993426e-04
Rgh_28_9 g_28_9 g_29_9 4.993426e-04
Rgv_28_9 g_28_9 g_28_10 4.993426e-04
Rgh_28_10 g_28_10 g_29_10 4.993426e-04
Rgv_28_10 g_28_10 g_28_11 4.993426e-04
Rgh_28_11 g_28_11 g_29_11 4.993426e-04
Rgv_28_11 g_28_11 g_28_12 4.993426e-04
Rgh_28_12 g_28_12 g_29_12 4.993426e-04
Rgv_28_12 g_28_12 g_28_13 4.993426e-04
Rgh_28_13 g_28_13 g_29_13 4.993426e-04
Rgv_28_13 g_28_13 g_28_14 4.993426e-04
Rgh_28_14 g_28_14 g_29_14 4.993426e-04
Rgv_28_14 g_28_14 g_28_15 4.993426e-04
Rgh_28_15 g_28_15 g_29_15 4.993426e-04
Rgv_28_15 g_28_15 g_28_16 4.993426e-04
Rgh_28_16 g_28_16 g_29_16 4.993426e-04
Rgv_28_16 g_28_16 g_28_17 4.993426e-04
Rgh_28_17 g_28_17 g_29_17 4.993426e-04
Rgv_28_17 g_28_17 g_28_18 4.993426e-04
Rgh_28_18 g_28_18 g_29_18 4.993426e-04
Rgv_28_18 g_28_18 g_28_19 4.993426e-04
Rgh_28_19 g_28_19 g_29_19 4.993426e-04
Rgv_28_19 g_28_19 g_28_20 4.993426e-04
Rgh_28_20 g_28_20 g_29_20 4.993426e-04
Rgv_28_20 g_28_20 g_28_21 4.993426e-04
Rgh_28_21 g_28_21 g_29_21 4.993426e-04
Rgv_28_21 g_28_21 g_28_22 4.993426e-04
Rgh_28_22 g_28_22 g_29_22 4.993426e-04
Rgv_28_22 g_28_22 g_28_23 4.993426e-04
Rgh_28_23 g_28_23 g_29_23 4.993426e-04
Rgv_28_23 g_28_23 g_28_24 4.993426e-04
Rgh_28_24 g_28_24 g_29_24 4.993426e-04
Rgv_28_24 g_28_24 g_28_25 4.993426e-04
Rgh_28_25 g_28_25 g_29_25 4.993426e-04
Rgv_28_25 g_28_25 g_28_26 4.993426e-04
Rgh_28_26 g_28_26 g_29_26 4.993426e-04
Rgv_28_26 g_28_26 g_28_27 4.993426e-04
Rgh_28_27 g_28_27 g_29_27 4.993426e-04
Rgv_28_27 g_28_27 g_28_28 4.993426e-04
Rgh_28_28 g_28_28 g_29_28 4.993426e-04
Rgv_28_28 g_28_28 g_28_29 4.993426e-04
Rgh_28_29 g_28_29 g_29_29 4.993426e-04
Rgv_28_29 g_28_29 g_28_30 4.993426e-04
Rgh_28_30 g_28_30 g_29_30 4.993426e-04
Rgv_28_30 g_28_30 g_28_31 4.993426e-04
Rgh_28_31 g_28_31 g_29_31 4.993426e-04
Rgv_28_31 g_28_31 g_28_32 4.993426e-04
Rgh_28_32 g_28_32 g_29_32 4.993426e-04
Rgv_28_32 g_28_32 g_28_33 4.993426e-04
Rgh_28_33 g_28_33 g_29_33 4.993426e-04
Rgv_28_33 g_28_33 g_28_34 4.993426e-04
Rgh_28_34 g_28_34 g_29_34 4.993426e-04
Rgv_28_34 g_28_34 g_28_35 4.993426e-04
Rgh_28_35 g_28_35 g_29_35 4.993426e-04
Rgv_28_35 g_28_35 g_28_36 4.993426e-04
Rgh_28_36 g_28_36 g_29_36 4.993426e-04
Rgv_28_36 g_28_36 g_28_37 4.993426e-04
Rgh_28_37 g_28_37 g_29_37 4.993426e-04
Rgv_28_37 g_28_37 g_28_38 4.993426e-04
Rgh_28_38 g_28_38 g_29_38 4.993426e-04
Rgv_28_38 g_28_38 g_28_39 4.993426e-04
Rgh_28_39 g_28_39 g_29_39 4.993426e-04
Rgv_28_39 g_28_39 g_28_40 4.993426e-04
Rgh_28_40 g_28_40 g_29_40 4.993426e-04
Rgv_28_40 g_28_40 g_28_41 4.993426e-04
Rgh_28_41 g_28_41 g_29_41 4.993426e-04
Rgv_28_41 g_28_41 g_28_42 4.993426e-04
Rgh_28_42 g_28_42 g_29_42 4.993426e-04
Rgv_28_42 g_28_42 g_28_43 4.993426e-04
Rgh_28_43 g_28_43 g_29_43 4.993426e-04
Rgv_28_43 g_28_43 g_28_44 4.993426e-04
Rgh_28_44 g_28_44 g_29_44 4.993426e-04
Rgv_28_44 g_28_44 g_28_45 4.993426e-04
Rgh_28_45 g_28_45 g_29_45 4.993426e-04
Rgv_28_45 g_28_45 g_28_46 4.993426e-04
Rgh_28_46 g_28_46 g_29_46 4.993426e-04
Rgv_28_46 g_28_46 g_28_47 4.993426e-04
Rgh_28_47 g_28_47 g_29_47 4.993426e-04
Rgv_28_47 g_28_47 g_28_48 4.993426e-04
Rgh_28_48 g_28_48 g_29_48 4.993426e-04
Rgv_28_48 g_28_48 g_28_49 4.993426e-04
Rgh_28_49 g_28_49 g_29_49 4.993426e-04
Rgv_28_49 g_28_49 g_28_50 4.993426e-04
Rgh_28_50 g_28_50 g_29_50 4.993426e-04
Rgv_28_50 g_28_50 g_28_51 4.993426e-04
Rgh_28_51 g_28_51 g_29_51 4.993426e-04
Rgv_28_51 g_28_51 g_28_52 4.993426e-04
Rgh_28_52 g_28_52 g_29_52 4.993426e-04
Rgv_28_52 g_28_52 g_28_53 4.993426e-04
Rgh_28_53 g_28_53 g_29_53 4.993426e-04
Rgv_28_53 g_28_53 g_28_54 4.993426e-04
Rgh_28_54 g_28_54 g_29_54 4.993426e-04
Rgv_28_54 g_28_54 g_28_55 4.993426e-04
Rgh_28_55 g_28_55 g_29_55 4.993426e-04
Rgv_28_55 g_28_55 g_28_56 4.993426e-04
Rgh_28_56 g_28_56 g_29_56 4.993426e-04
Rgv_28_56 g_28_56 g_28_57 4.993426e-04
Rgh_28_57 g_28_57 g_29_57 4.993426e-04
Rgv_28_57 g_28_57 g_28_58 4.993426e-04
Rgh_28_58 g_28_58 g_29_58 4.993426e-04
Rgv_28_58 g_28_58 g_28_59 4.993426e-04
Rgh_28_59 g_28_59 g_29_59 4.993426e-04
Rgv_28_59 g_28_59 g_28_60 4.993426e-04
Rgh_28_60 g_28_60 g_29_60 4.993426e-04
Rgv_28_60 g_28_60 g_28_61 4.993426e-04
Rgh_28_61 g_28_61 g_29_61 4.993426e-04
Rgv_28_61 g_28_61 g_28_62 4.993426e-04
Rgh_28_62 g_28_62 g_29_62 4.993426e-04
Rgv_28_62 g_28_62 g_28_63 4.993426e-04
Rgh_28_63 g_28_63 g_29_63 4.993426e-04
Rgv_28_63 g_28_63 g_28_64 4.993426e-04
Rgh_28_64 g_28_64 g_29_64 4.993426e-04
Rgv_28_64 g_28_64 g_28_65 4.993426e-04
Rgh_28_65 g_28_65 g_29_65 4.993426e-04
Rgv_28_65 g_28_65 g_28_66 4.993426e-04
Rgh_28_66 g_28_66 g_29_66 4.993426e-04
Rgv_28_66 g_28_66 g_28_67 4.993426e-04
Rgh_28_67 g_28_67 g_29_67 4.993426e-04
Rgv_28_67 g_28_67 g_28_68 4.993426e-04
Rgh_28_68 g_28_68 g_29_68 4.993426e-04
Rgv_28_68 g_28_68 g_28_69 4.993426e-04
Rgh_28_69 g_28_69 g_29_69 4.993426e-04
Rgv_28_69 g_28_69 g_28_70 4.993426e-04
Rgh_28_70 g_28_70 g_29_70 4.993426e-04
Rgv_28_70 g_28_70 g_28_71 4.993426e-04
Rgh_28_71 g_28_71 g_29_71 4.993426e-04
Rgh_29_0 g_29_0 g_30_0 4.993426e-04
Rgv_29_0 g_29_0 g_29_1 4.993426e-04
Rgh_29_1 g_29_1 g_30_1 4.993426e-04
Rgv_29_1 g_29_1 g_29_2 4.993426e-04
Rgh_29_2 g_29_2 g_30_2 4.993426e-04
Rgv_29_2 g_29_2 g_29_3 4.993426e-04
Rgh_29_3 g_29_3 g_30_3 4.993426e-04
Rgv_29_3 g_29_3 g_29_4 4.993426e-04
Rgh_29_4 g_29_4 g_30_4 4.993426e-04
Rgv_29_4 g_29_4 g_29_5 4.993426e-04
Rgh_29_5 g_29_5 g_30_5 4.993426e-04
Rgv_29_5 g_29_5 g_29_6 4.993426e-04
Rgh_29_6 g_29_6 g_30_6 4.993426e-04
Rgv_29_6 g_29_6 g_29_7 4.993426e-04
Rgh_29_7 g_29_7 g_30_7 4.993426e-04
Rgv_29_7 g_29_7 g_29_8 4.993426e-04
Rgh_29_8 g_29_8 g_30_8 4.993426e-04
Rgv_29_8 g_29_8 g_29_9 4.993426e-04
Rgh_29_9 g_29_9 g_30_9 4.993426e-04
Rgv_29_9 g_29_9 g_29_10 4.993426e-04
Rgh_29_10 g_29_10 g_30_10 4.993426e-04
Rgv_29_10 g_29_10 g_29_11 4.993426e-04
Rgh_29_11 g_29_11 g_30_11 4.993426e-04
Rgv_29_11 g_29_11 g_29_12 4.993426e-04
Rgh_29_12 g_29_12 g_30_12 4.993426e-04
Rgv_29_12 g_29_12 g_29_13 4.993426e-04
Rgh_29_13 g_29_13 g_30_13 4.993426e-04
Rgv_29_13 g_29_13 g_29_14 4.993426e-04
Rgh_29_14 g_29_14 g_30_14 4.993426e-04
Rgv_29_14 g_29_14 g_29_15 4.993426e-04
Rgh_29_15 g_29_15 g_30_15 4.993426e-04
Rgv_29_15 g_29_15 g_29_16 4.993426e-04
Rgh_29_16 g_29_16 g_30_16 4.993426e-04
Rgv_29_16 g_29_16 g_29_17 4.993426e-04
Rgh_29_17 g_29_17 g_30_17 4.993426e-04
Rgv_29_17 g_29_17 g_29_18 4.993426e-04
Rgh_29_18 g_29_18 g_30_18 4.993426e-04
Rgv_29_18 g_29_18 g_29_19 4.993426e-04
Rgh_29_19 g_29_19 g_30_19 4.993426e-04
Rgv_29_19 g_29_19 g_29_20 4.993426e-04
Rgh_29_20 g_29_20 g_30_20 4.993426e-04
Rgv_29_20 g_29_20 g_29_21 4.993426e-04
Rgh_29_21 g_29_21 g_30_21 4.993426e-04
Rgv_29_21 g_29_21 g_29_22 4.993426e-04
Rgh_29_22 g_29_22 g_30_22 4.993426e-04
Rgv_29_22 g_29_22 g_29_23 4.993426e-04
Rgh_29_23 g_29_23 g_30_23 4.993426e-04
Rgv_29_23 g_29_23 g_29_24 4.993426e-04
Rgh_29_24 g_29_24 g_30_24 4.993426e-04
Rgv_29_24 g_29_24 g_29_25 4.993426e-04
Rgh_29_25 g_29_25 g_30_25 4.993426e-04
Rgv_29_25 g_29_25 g_29_26 4.993426e-04
Rgh_29_26 g_29_26 g_30_26 4.993426e-04
Rgv_29_26 g_29_26 g_29_27 4.993426e-04
Rgh_29_27 g_29_27 g_30_27 4.993426e-04
Rgv_29_27 g_29_27 g_29_28 4.993426e-04
Rgh_29_28 g_29_28 g_30_28 4.993426e-04
Rgv_29_28 g_29_28 g_29_29 4.993426e-04
Rgh_29_29 g_29_29 g_30_29 4.993426e-04
Rgv_29_29 g_29_29 g_29_30 4.993426e-04
Rgh_29_30 g_29_30 g_30_30 4.993426e-04
Rgv_29_30 g_29_30 g_29_31 4.993426e-04
Rgh_29_31 g_29_31 g_30_31 4.993426e-04
Rgv_29_31 g_29_31 g_29_32 4.993426e-04
Rgh_29_32 g_29_32 g_30_32 4.993426e-04
Rgv_29_32 g_29_32 g_29_33 4.993426e-04
Rgh_29_33 g_29_33 g_30_33 4.993426e-04
Rgv_29_33 g_29_33 g_29_34 4.993426e-04
Rgh_29_34 g_29_34 g_30_34 4.993426e-04
Rgv_29_34 g_29_34 g_29_35 4.993426e-04
Rgh_29_35 g_29_35 g_30_35 4.993426e-04
Rgv_29_35 g_29_35 g_29_36 4.993426e-04
Rgh_29_36 g_29_36 g_30_36 4.993426e-04
Rgv_29_36 g_29_36 g_29_37 4.993426e-04
Rgh_29_37 g_29_37 g_30_37 4.993426e-04
Rgv_29_37 g_29_37 g_29_38 4.993426e-04
Rgh_29_38 g_29_38 g_30_38 4.993426e-04
Rgv_29_38 g_29_38 g_29_39 4.993426e-04
Rgh_29_39 g_29_39 g_30_39 4.993426e-04
Rgv_29_39 g_29_39 g_29_40 4.993426e-04
Rgh_29_40 g_29_40 g_30_40 4.993426e-04
Rgv_29_40 g_29_40 g_29_41 4.993426e-04
Rgh_29_41 g_29_41 g_30_41 4.993426e-04
Rgv_29_41 g_29_41 g_29_42 4.993426e-04
Rgh_29_42 g_29_42 g_30_42 4.993426e-04
Rgv_29_42 g_29_42 g_29_43 4.993426e-04
Rgh_29_43 g_29_43 g_30_43 4.993426e-04
Rgv_29_43 g_29_43 g_29_44 4.993426e-04
Rgh_29_44 g_29_44 g_30_44 4.993426e-04
Rgv_29_44 g_29_44 g_29_45 4.993426e-04
Rgh_29_45 g_29_45 g_30_45 4.993426e-04
Rgv_29_45 g_29_45 g_29_46 4.993426e-04
Rgh_29_46 g_29_46 g_30_46 4.993426e-04
Rgv_29_46 g_29_46 g_29_47 4.993426e-04
Rgh_29_47 g_29_47 g_30_47 4.993426e-04
Rgv_29_47 g_29_47 g_29_48 4.993426e-04
Rgh_29_48 g_29_48 g_30_48 4.993426e-04
Rgv_29_48 g_29_48 g_29_49 4.993426e-04
Rgh_29_49 g_29_49 g_30_49 4.993426e-04
Rgv_29_49 g_29_49 g_29_50 4.993426e-04
Rgh_29_50 g_29_50 g_30_50 4.993426e-04
Rgv_29_50 g_29_50 g_29_51 4.993426e-04
Rgh_29_51 g_29_51 g_30_51 4.993426e-04
Rgv_29_51 g_29_51 g_29_52 4.993426e-04
Rgh_29_52 g_29_52 g_30_52 4.993426e-04
Rgv_29_52 g_29_52 g_29_53 4.993426e-04
Rgh_29_53 g_29_53 g_30_53 4.993426e-04
Rgv_29_53 g_29_53 g_29_54 4.993426e-04
Rgh_29_54 g_29_54 g_30_54 4.993426e-04
Rgv_29_54 g_29_54 g_29_55 4.993426e-04
Rgh_29_55 g_29_55 g_30_55 4.993426e-04
Rgv_29_55 g_29_55 g_29_56 4.993426e-04
Rgh_29_56 g_29_56 g_30_56 4.993426e-04
Rgv_29_56 g_29_56 g_29_57 4.993426e-04
Rgh_29_57 g_29_57 g_30_57 4.993426e-04
Rgv_29_57 g_29_57 g_29_58 4.993426e-04
Rgh_29_58 g_29_58 g_30_58 4.993426e-04
Rgv_29_58 g_29_58 g_29_59 4.993426e-04
Rgh_29_59 g_29_59 g_30_59 4.993426e-04
Rgv_29_59 g_29_59 g_29_60 4.993426e-04
Rgh_29_60 g_29_60 g_30_60 4.993426e-04
Rgv_29_60 g_29_60 g_29_61 4.993426e-04
Rgh_29_61 g_29_61 g_30_61 4.993426e-04
Rgv_29_61 g_29_61 g_29_62 4.993426e-04
Rgh_29_62 g_29_62 g_30_62 4.993426e-04
Rgv_29_62 g_29_62 g_29_63 4.993426e-04
Rgh_29_63 g_29_63 g_30_63 4.993426e-04
Rgv_29_63 g_29_63 g_29_64 4.993426e-04
Rgh_29_64 g_29_64 g_30_64 4.993426e-04
Rgv_29_64 g_29_64 g_29_65 4.993426e-04
Rgh_29_65 g_29_65 g_30_65 4.993426e-04
Rgv_29_65 g_29_65 g_29_66 4.993426e-04
Rgh_29_66 g_29_66 g_30_66 4.993426e-04
Rgv_29_66 g_29_66 g_29_67 4.993426e-04
Rgh_29_67 g_29_67 g_30_67 4.993426e-04
Rgv_29_67 g_29_67 g_29_68 4.993426e-04
Rgh_29_68 g_29_68 g_30_68 4.993426e-04
Rgv_29_68 g_29_68 g_29_69 4.993426e-04
Rgh_29_69 g_29_69 g_30_69 4.993426e-04
Rgv_29_69 g_29_69 g_29_70 4.993426e-04
Rgh_29_70 g_29_70 g_30_70 4.993426e-04
Rgv_29_70 g_29_70 g_29_71 4.993426e-04
Rgh_29_71 g_29_71 g_30_71 4.993426e-04
Rgh_30_0 g_30_0 g_31_0 4.993426e-04
Rgv_30_0 g_30_0 g_30_1 4.993426e-04
Rgh_30_1 g_30_1 g_31_1 4.993426e-04
Rgv_30_1 g_30_1 g_30_2 4.993426e-04
Rgh_30_2 g_30_2 g_31_2 4.993426e-04
Rgv_30_2 g_30_2 g_30_3 4.993426e-04
Rgh_30_3 g_30_3 g_31_3 4.993426e-04
Rgv_30_3 g_30_3 g_30_4 4.993426e-04
Rgh_30_4 g_30_4 g_31_4 4.993426e-04
Rgv_30_4 g_30_4 g_30_5 4.993426e-04
Rgh_30_5 g_30_5 g_31_5 4.993426e-04
Rgv_30_5 g_30_5 g_30_6 4.993426e-04
Rgh_30_6 g_30_6 g_31_6 4.993426e-04
Rgv_30_6 g_30_6 g_30_7 4.993426e-04
Rgh_30_7 g_30_7 g_31_7 4.993426e-04
Rgv_30_7 g_30_7 g_30_8 4.993426e-04
Rgh_30_8 g_30_8 g_31_8 4.993426e-04
Rgv_30_8 g_30_8 g_30_9 4.993426e-04
Rgh_30_9 g_30_9 g_31_9 4.993426e-04
Rgv_30_9 g_30_9 g_30_10 4.993426e-04
Rgh_30_10 g_30_10 g_31_10 4.993426e-04
Rgv_30_10 g_30_10 g_30_11 4.993426e-04
Rgh_30_11 g_30_11 g_31_11 4.993426e-04
Rgv_30_11 g_30_11 g_30_12 4.993426e-04
Rgh_30_12 g_30_12 g_31_12 4.993426e-04
Rgv_30_12 g_30_12 g_30_13 4.993426e-04
Rgh_30_13 g_30_13 g_31_13 4.993426e-04
Rgv_30_13 g_30_13 g_30_14 4.993426e-04
Rgh_30_14 g_30_14 g_31_14 4.993426e-04
Rgv_30_14 g_30_14 g_30_15 4.993426e-04
Rgh_30_15 g_30_15 g_31_15 4.993426e-04
Rgv_30_15 g_30_15 g_30_16 4.993426e-04
Rgh_30_16 g_30_16 g_31_16 4.993426e-04
Rgv_30_16 g_30_16 g_30_17 4.993426e-04
Rgh_30_17 g_30_17 g_31_17 4.993426e-04
Rgv_30_17 g_30_17 g_30_18 4.993426e-04
Rgh_30_18 g_30_18 g_31_18 4.993426e-04
Rgv_30_18 g_30_18 g_30_19 4.993426e-04
Rgh_30_19 g_30_19 g_31_19 4.993426e-04
Rgv_30_19 g_30_19 g_30_20 4.993426e-04
Rgh_30_20 g_30_20 g_31_20 4.993426e-04
Rgv_30_20 g_30_20 g_30_21 4.993426e-04
Rgh_30_21 g_30_21 g_31_21 4.993426e-04
Rgv_30_21 g_30_21 g_30_22 4.993426e-04
Rgh_30_22 g_30_22 g_31_22 4.993426e-04
Rgv_30_22 g_30_22 g_30_23 4.993426e-04
Rgh_30_23 g_30_23 g_31_23 4.993426e-04
Rgv_30_23 g_30_23 g_30_24 4.993426e-04
Rgh_30_24 g_30_24 g_31_24 4.993426e-04
Rgv_30_24 g_30_24 g_30_25 4.993426e-04
Rgh_30_25 g_30_25 g_31_25 4.993426e-04
Rgv_30_25 g_30_25 g_30_26 4.993426e-04
Rgh_30_26 g_30_26 g_31_26 4.993426e-04
Rgv_30_26 g_30_26 g_30_27 4.993426e-04
Rgh_30_27 g_30_27 g_31_27 4.993426e-04
Rgv_30_27 g_30_27 g_30_28 4.993426e-04
Rgh_30_28 g_30_28 g_31_28 4.993426e-04
Rgv_30_28 g_30_28 g_30_29 4.993426e-04
Rgh_30_29 g_30_29 g_31_29 4.993426e-04
Rgv_30_29 g_30_29 g_30_30 4.993426e-04
Rgh_30_30 g_30_30 g_31_30 4.993426e-04
Rgv_30_30 g_30_30 g_30_31 4.993426e-04
Rgh_30_31 g_30_31 g_31_31 4.993426e-04
Rgv_30_31 g_30_31 g_30_32 4.993426e-04
Rgh_30_32 g_30_32 g_31_32 4.993426e-04
Rgv_30_32 g_30_32 g_30_33 4.993426e-04
Rgh_30_33 g_30_33 g_31_33 4.993426e-04
Rgv_30_33 g_30_33 g_30_34 4.993426e-04
Rgh_30_34 g_30_34 g_31_34 4.993426e-04
Rgv_30_34 g_30_34 g_30_35 4.993426e-04
Rgh_30_35 g_30_35 g_31_35 4.993426e-04
Rgv_30_35 g_30_35 g_30_36 4.993426e-04
Rgh_30_36 g_30_36 g_31_36 4.993426e-04
Rgv_30_36 g_30_36 g_30_37 4.993426e-04
Rgh_30_37 g_30_37 g_31_37 4.993426e-04
Rgv_30_37 g_30_37 g_30_38 4.993426e-04
Rgh_30_38 g_30_38 g_31_38 4.993426e-04
Rgv_30_38 g_30_38 g_30_39 4.993426e-04
Rgh_30_39 g_30_39 g_31_39 4.993426e-04
Rgv_30_39 g_30_39 g_30_40 4.993426e-04
Rgh_30_40 g_30_40 g_31_40 4.993426e-04
Rgv_30_40 g_30_40 g_30_41 4.993426e-04
Rgh_30_41 g_30_41 g_31_41 4.993426e-04
Rgv_30_41 g_30_41 g_30_42 4.993426e-04
Rgh_30_42 g_30_42 g_31_42 4.993426e-04
Rgv_30_42 g_30_42 g_30_43 4.993426e-04
Rgh_30_43 g_30_43 g_31_43 4.993426e-04
Rgv_30_43 g_30_43 g_30_44 4.993426e-04
Rgh_30_44 g_30_44 g_31_44 4.993426e-04
Rgv_30_44 g_30_44 g_30_45 4.993426e-04
Rgh_30_45 g_30_45 g_31_45 4.993426e-04
Rgv_30_45 g_30_45 g_30_46 4.993426e-04
Rgh_30_46 g_30_46 g_31_46 4.993426e-04
Rgv_30_46 g_30_46 g_30_47 4.993426e-04
Rgh_30_47 g_30_47 g_31_47 4.993426e-04
Rgv_30_47 g_30_47 g_30_48 4.993426e-04
Rgh_30_48 g_30_48 g_31_48 4.993426e-04
Rgv_30_48 g_30_48 g_30_49 4.993426e-04
Rgh_30_49 g_30_49 g_31_49 4.993426e-04
Rgv_30_49 g_30_49 g_30_50 4.993426e-04
Rgh_30_50 g_30_50 g_31_50 4.993426e-04
Rgv_30_50 g_30_50 g_30_51 4.993426e-04
Rgh_30_51 g_30_51 g_31_51 4.993426e-04
Rgv_30_51 g_30_51 g_30_52 4.993426e-04
Rgh_30_52 g_30_52 g_31_52 4.993426e-04
Rgv_30_52 g_30_52 g_30_53 4.993426e-04
Rgh_30_53 g_30_53 g_31_53 4.993426e-04
Rgv_30_53 g_30_53 g_30_54 4.993426e-04
Rgh_30_54 g_30_54 g_31_54 4.993426e-04
Rgv_30_54 g_30_54 g_30_55 4.993426e-04
Rgh_30_55 g_30_55 g_31_55 4.993426e-04
Rgv_30_55 g_30_55 g_30_56 4.993426e-04
Rgh_30_56 g_30_56 g_31_56 4.993426e-04
Rgv_30_56 g_30_56 g_30_57 4.993426e-04
Rgh_30_57 g_30_57 g_31_57 4.993426e-04
Rgv_30_57 g_30_57 g_30_58 4.993426e-04
Rgh_30_58 g_30_58 g_31_58 4.993426e-04
Rgv_30_58 g_30_58 g_30_59 4.993426e-04
Rgh_30_59 g_30_59 g_31_59 4.993426e-04
Rgv_30_59 g_30_59 g_30_60 4.993426e-04
Rgh_30_60 g_30_60 g_31_60 4.993426e-04
Rgv_30_60 g_30_60 g_30_61 4.993426e-04
Rgh_30_61 g_30_61 g_31_61 4.993426e-04
Rgv_30_61 g_30_61 g_30_62 4.993426e-04
Rgh_30_62 g_30_62 g_31_62 4.993426e-04
Rgv_30_62 g_30_62 g_30_63 4.993426e-04
Rgh_30_63 g_30_63 g_31_63 4.993426e-04
Rgv_30_63 g_30_63 g_30_64 4.993426e-04
Rgh_30_64 g_30_64 g_31_64 4.993426e-04
Rgv_30_64 g_30_64 g_30_65 4.993426e-04
Rgh_30_65 g_30_65 g_31_65 4.993426e-04
Rgv_30_65 g_30_65 g_30_66 4.993426e-04
Rgh_30_66 g_30_66 g_31_66 4.993426e-04
Rgv_30_66 g_30_66 g_30_67 4.993426e-04
Rgh_30_67 g_30_67 g_31_67 4.993426e-04
Rgv_30_67 g_30_67 g_30_68 4.993426e-04
Rgh_30_68 g_30_68 g_31_68 4.993426e-04
Rgv_30_68 g_30_68 g_30_69 4.993426e-04
Rgh_30_69 g_30_69 g_31_69 4.993426e-04
Rgv_30_69 g_30_69 g_30_70 4.993426e-04
Rgh_30_70 g_30_70 g_31_70 4.993426e-04
Rgv_30_70 g_30_70 g_30_71 4.993426e-04
Rgh_30_71 g_30_71 g_31_71 4.993426e-04
Rgh_31_0 g_31_0 g_32_0 4.993426e-04
Rgv_31_0 g_31_0 g_31_1 4.993426e-04
Rgh_31_1 g_31_1 g_32_1 4.993426e-04
Rgv_31_1 g_31_1 g_31_2 4.993426e-04
Rgh_31_2 g_31_2 g_32_2 4.993426e-04
Rgv_31_2 g_31_2 g_31_3 4.993426e-04
Rgh_31_3 g_31_3 g_32_3 4.993426e-04
Rgv_31_3 g_31_3 g_31_4 4.993426e-04
Rgh_31_4 g_31_4 g_32_4 4.993426e-04
Rgv_31_4 g_31_4 g_31_5 4.993426e-04
Rgh_31_5 g_31_5 g_32_5 4.993426e-04
Rgv_31_5 g_31_5 g_31_6 4.993426e-04
Rgh_31_6 g_31_6 g_32_6 4.993426e-04
Rgv_31_6 g_31_6 g_31_7 4.993426e-04
Rgh_31_7 g_31_7 g_32_7 4.993426e-04
Rgv_31_7 g_31_7 g_31_8 4.993426e-04
Rgh_31_8 g_31_8 g_32_8 4.993426e-04
Rgv_31_8 g_31_8 g_31_9 4.993426e-04
Rgh_31_9 g_31_9 g_32_9 4.993426e-04
Rgv_31_9 g_31_9 g_31_10 4.993426e-04
Rgh_31_10 g_31_10 g_32_10 4.993426e-04
Rgv_31_10 g_31_10 g_31_11 4.993426e-04
Rgh_31_11 g_31_11 g_32_11 4.993426e-04
Rgv_31_11 g_31_11 g_31_12 4.993426e-04
Rgh_31_12 g_31_12 g_32_12 4.993426e-04
Rgv_31_12 g_31_12 g_31_13 4.993426e-04
Rgh_31_13 g_31_13 g_32_13 4.993426e-04
Rgv_31_13 g_31_13 g_31_14 4.993426e-04
Rgh_31_14 g_31_14 g_32_14 4.993426e-04
Rgv_31_14 g_31_14 g_31_15 4.993426e-04
Rgh_31_15 g_31_15 g_32_15 4.993426e-04
Rgv_31_15 g_31_15 g_31_16 4.993426e-04
Rgh_31_16 g_31_16 g_32_16 4.993426e-04
Rgv_31_16 g_31_16 g_31_17 4.993426e-04
Rgh_31_17 g_31_17 g_32_17 4.993426e-04
Rgv_31_17 g_31_17 g_31_18 4.993426e-04
Rgh_31_18 g_31_18 g_32_18 4.993426e-04
Rgv_31_18 g_31_18 g_31_19 4.993426e-04
Rgh_31_19 g_31_19 g_32_19 4.993426e-04
Rgv_31_19 g_31_19 g_31_20 4.993426e-04
Rgh_31_20 g_31_20 g_32_20 4.993426e-04
Rgv_31_20 g_31_20 g_31_21 4.993426e-04
Rgh_31_21 g_31_21 g_32_21 4.993426e-04
Rgv_31_21 g_31_21 g_31_22 4.993426e-04
Rgh_31_22 g_31_22 g_32_22 4.993426e-04
Rgv_31_22 g_31_22 g_31_23 4.993426e-04
Rgh_31_23 g_31_23 g_32_23 4.993426e-04
Rgv_31_23 g_31_23 g_31_24 4.993426e-04
Rgh_31_24 g_31_24 g_32_24 4.993426e-04
Rgv_31_24 g_31_24 g_31_25 4.993426e-04
Rgh_31_25 g_31_25 g_32_25 4.993426e-04
Rgv_31_25 g_31_25 g_31_26 4.993426e-04
Rgh_31_26 g_31_26 g_32_26 4.993426e-04
Rgv_31_26 g_31_26 g_31_27 4.993426e-04
Rgh_31_27 g_31_27 g_32_27 4.993426e-04
Rgv_31_27 g_31_27 g_31_28 4.993426e-04
Rgh_31_28 g_31_28 g_32_28 4.993426e-04
Rgv_31_28 g_31_28 g_31_29 4.993426e-04
Rgh_31_29 g_31_29 g_32_29 4.993426e-04
Rgv_31_29 g_31_29 g_31_30 4.993426e-04
Rgh_31_30 g_31_30 g_32_30 4.993426e-04
Rgv_31_30 g_31_30 g_31_31 4.993426e-04
Rgh_31_31 g_31_31 g_32_31 4.993426e-04
Rgv_31_31 g_31_31 g_31_32 4.993426e-04
Rgh_31_32 g_31_32 g_32_32 4.993426e-04
Rgv_31_32 g_31_32 g_31_33 4.993426e-04
Rgh_31_33 g_31_33 g_32_33 4.993426e-04
Rgv_31_33 g_31_33 g_31_34 4.993426e-04
Rgh_31_34 g_31_34 g_32_34 4.993426e-04
Rgv_31_34 g_31_34 g_31_35 4.993426e-04
Rgh_31_35 g_31_35 g_32_35 4.993426e-04
Rgv_31_35 g_31_35 g_31_36 4.993426e-04
Rgh_31_36 g_31_36 g_32_36 4.993426e-04
Rgv_31_36 g_31_36 g_31_37 4.993426e-04
Rgh_31_37 g_31_37 g_32_37 4.993426e-04
Rgv_31_37 g_31_37 g_31_38 4.993426e-04
Rgh_31_38 g_31_38 g_32_38 4.993426e-04
Rgv_31_38 g_31_38 g_31_39 4.993426e-04
Rgh_31_39 g_31_39 g_32_39 4.993426e-04
Rgv_31_39 g_31_39 g_31_40 4.993426e-04
Rgh_31_40 g_31_40 g_32_40 4.993426e-04
Rgv_31_40 g_31_40 g_31_41 4.993426e-04
Rgh_31_41 g_31_41 g_32_41 4.993426e-04
Rgv_31_41 g_31_41 g_31_42 4.993426e-04
Rgh_31_42 g_31_42 g_32_42 4.993426e-04
Rgv_31_42 g_31_42 g_31_43 4.993426e-04
Rgh_31_43 g_31_43 g_32_43 4.993426e-04
Rgv_31_43 g_31_43 g_31_44 4.993426e-04
Rgh_31_44 g_31_44 g_32_44 4.993426e-04
Rgv_31_44 g_31_44 g_31_45 4.993426e-04
Rgh_31_45 g_31_45 g_32_45 4.993426e-04
Rgv_31_45 g_31_45 g_31_46 4.993426e-04
Rgh_31_46 g_31_46 g_32_46 4.993426e-04
Rgv_31_46 g_31_46 g_31_47 4.993426e-04
Rgh_31_47 g_31_47 g_32_47 4.993426e-04
Rgv_31_47 g_31_47 g_31_48 4.993426e-04
Rgh_31_48 g_31_48 g_32_48 4.993426e-04
Rgv_31_48 g_31_48 g_31_49 4.993426e-04
Rgh_31_49 g_31_49 g_32_49 4.993426e-04
Rgv_31_49 g_31_49 g_31_50 4.993426e-04
Rgh_31_50 g_31_50 g_32_50 4.993426e-04
Rgv_31_50 g_31_50 g_31_51 4.993426e-04
Rgh_31_51 g_31_51 g_32_51 4.993426e-04
Rgv_31_51 g_31_51 g_31_52 4.993426e-04
Rgh_31_52 g_31_52 g_32_52 4.993426e-04
Rgv_31_52 g_31_52 g_31_53 4.993426e-04
Rgh_31_53 g_31_53 g_32_53 4.993426e-04
Rgv_31_53 g_31_53 g_31_54 4.993426e-04
Rgh_31_54 g_31_54 g_32_54 4.993426e-04
Rgv_31_54 g_31_54 g_31_55 4.993426e-04
Rgh_31_55 g_31_55 g_32_55 4.993426e-04
Rgv_31_55 g_31_55 g_31_56 4.993426e-04
Rgh_31_56 g_31_56 g_32_56 4.993426e-04
Rgv_31_56 g_31_56 g_31_57 4.993426e-04
Rgh_31_57 g_31_57 g_32_57 4.993426e-04
Rgv_31_57 g_31_57 g_31_58 4.993426e-04
Rgh_31_58 g_31_58 g_32_58 4.993426e-04
Rgv_31_58 g_31_58 g_31_59 4.993426e-04
Rgh_31_59 g_31_59 g_32_59 4.993426e-04
Rgv_31_59 g_31_59 g_31_60 4.993426e-04
Rgh_31_60 g_31_60 g_32_60 4.993426e-04
Rgv_31_60 g_31_60 g_31_61 4.993426e-04
Rgh_31_61 g_31_61 g_32_61 4.993426e-04
Rgv_31_61 g_31_61 g_31_62 4.993426e-04
Rgh_31_62 g_31_62 g_32_62 4.993426e-04
Rgv_31_62 g_31_62 g_31_63 4.993426e-04
Rgh_31_63 g_31_63 g_32_63 4.993426e-04
Rgv_31_63 g_31_63 g_31_64 4.993426e-04
Rgh_31_64 g_31_64 g_32_64 4.993426e-04
Rgv_31_64 g_31_64 g_31_65 4.993426e-04
Rgh_31_65 g_31_65 g_32_65 4.993426e-04
Rgv_31_65 g_31_65 g_31_66 4.993426e-04
Rgh_31_66 g_31_66 g_32_66 4.993426e-04
Rgv_31_66 g_31_66 g_31_67 4.993426e-04
Rgh_31_67 g_31_67 g_32_67 4.993426e-04
Rgv_31_67 g_31_67 g_31_68 4.993426e-04
Rgh_31_68 g_31_68 g_32_68 4.993426e-04
Rgv_31_68 g_31_68 g_31_69 4.993426e-04
Rgh_31_69 g_31_69 g_32_69 4.993426e-04
Rgv_31_69 g_31_69 g_31_70 4.993426e-04
Rgh_31_70 g_31_70 g_32_70 4.993426e-04
Rgv_31_70 g_31_70 g_31_71 4.993426e-04
Rgh_31_71 g_31_71 g_32_71 4.993426e-04
Rgh_32_0 g_32_0 g_33_0 4.993426e-04
Rgv_32_0 g_32_0 g_32_1 4.993426e-04
Rgh_32_1 g_32_1 g_33_1 4.993426e-04
Rgv_32_1 g_32_1 g_32_2 4.993426e-04
Rgh_32_2 g_32_2 g_33_2 4.993426e-04
Rgv_32_2 g_32_2 g_32_3 4.993426e-04
Rgh_32_3 g_32_3 g_33_3 4.993426e-04
Rgv_32_3 g_32_3 g_32_4 4.993426e-04
Rgh_32_4 g_32_4 g_33_4 4.993426e-04
Rgv_32_4 g_32_4 g_32_5 4.993426e-04
Rgh_32_5 g_32_5 g_33_5 4.993426e-04
Rgv_32_5 g_32_5 g_32_6 4.993426e-04
Rgh_32_6 g_32_6 g_33_6 4.993426e-04
Rgv_32_6 g_32_6 g_32_7 4.993426e-04
Rgh_32_7 g_32_7 g_33_7 4.993426e-04
Rgv_32_7 g_32_7 g_32_8 4.993426e-04
Rgh_32_8 g_32_8 g_33_8 4.993426e-04
Rgv_32_8 g_32_8 g_32_9 4.993426e-04
Rgh_32_9 g_32_9 g_33_9 4.993426e-04
Rgv_32_9 g_32_9 g_32_10 4.993426e-04
Rgh_32_10 g_32_10 g_33_10 4.993426e-04
Rgv_32_10 g_32_10 g_32_11 4.993426e-04
Rgh_32_11 g_32_11 g_33_11 4.993426e-04
Rgv_32_11 g_32_11 g_32_12 4.993426e-04
Rgh_32_12 g_32_12 g_33_12 4.993426e-04
Rgv_32_12 g_32_12 g_32_13 4.993426e-04
Rgh_32_13 g_32_13 g_33_13 4.993426e-04
Rgv_32_13 g_32_13 g_32_14 4.993426e-04
Rgh_32_14 g_32_14 g_33_14 4.993426e-04
Rgv_32_14 g_32_14 g_32_15 4.993426e-04
Rgh_32_15 g_32_15 g_33_15 4.993426e-04
Rgv_32_15 g_32_15 g_32_16 4.993426e-04
Rgh_32_16 g_32_16 g_33_16 4.993426e-04
Rgv_32_16 g_32_16 g_32_17 4.993426e-04
Rgh_32_17 g_32_17 g_33_17 4.993426e-04
Rgv_32_17 g_32_17 g_32_18 4.993426e-04
Rgh_32_18 g_32_18 g_33_18 4.993426e-04
Rgv_32_18 g_32_18 g_32_19 4.993426e-04
Rgh_32_19 g_32_19 g_33_19 4.993426e-04
Rgv_32_19 g_32_19 g_32_20 4.993426e-04
Rgh_32_20 g_32_20 g_33_20 4.993426e-04
Rgv_32_20 g_32_20 g_32_21 4.993426e-04
Rgh_32_21 g_32_21 g_33_21 4.993426e-04
Rgv_32_21 g_32_21 g_32_22 4.993426e-04
Rgh_32_22 g_32_22 g_33_22 4.993426e-04
Rgv_32_22 g_32_22 g_32_23 4.993426e-04
Rgh_32_23 g_32_23 g_33_23 4.993426e-04
Rgv_32_23 g_32_23 g_32_24 4.993426e-04
Rgh_32_24 g_32_24 g_33_24 4.993426e-04
Rgv_32_24 g_32_24 g_32_25 4.993426e-04
Rgh_32_25 g_32_25 g_33_25 4.993426e-04
Rgv_32_25 g_32_25 g_32_26 4.993426e-04
Rgh_32_26 g_32_26 g_33_26 4.993426e-04
Rgv_32_26 g_32_26 g_32_27 4.993426e-04
Rgh_32_27 g_32_27 g_33_27 4.993426e-04
Rgv_32_27 g_32_27 g_32_28 4.993426e-04
Rgh_32_28 g_32_28 g_33_28 4.993426e-04
Rgv_32_28 g_32_28 g_32_29 4.993426e-04
Rgh_32_29 g_32_29 g_33_29 4.993426e-04
Rgv_32_29 g_32_29 g_32_30 4.993426e-04
Rgh_32_30 g_32_30 g_33_30 4.993426e-04
Rgv_32_30 g_32_30 g_32_31 4.993426e-04
Rgh_32_31 g_32_31 g_33_31 4.993426e-04
Rgv_32_31 g_32_31 g_32_32 4.993426e-04
Rgh_32_32 g_32_32 g_33_32 4.993426e-04
Rgv_32_32 g_32_32 g_32_33 4.993426e-04
Rgh_32_33 g_32_33 g_33_33 4.993426e-04
Rgv_32_33 g_32_33 g_32_34 4.993426e-04
Rgh_32_34 g_32_34 g_33_34 4.993426e-04
Rgv_32_34 g_32_34 g_32_35 4.993426e-04
Rgh_32_35 g_32_35 g_33_35 4.993426e-04
Rgv_32_35 g_32_35 g_32_36 4.993426e-04
Rgh_32_36 g_32_36 g_33_36 4.993426e-04
Rgv_32_36 g_32_36 g_32_37 4.993426e-04
Rgh_32_37 g_32_37 g_33_37 4.993426e-04
Rgv_32_37 g_32_37 g_32_38 4.993426e-04
Rgh_32_38 g_32_38 g_33_38 4.993426e-04
Rgv_32_38 g_32_38 g_32_39 4.993426e-04
Rgh_32_39 g_32_39 g_33_39 4.993426e-04
Rgv_32_39 g_32_39 g_32_40 4.993426e-04
Rgh_32_40 g_32_40 g_33_40 4.993426e-04
Rgv_32_40 g_32_40 g_32_41 4.993426e-04
Rgh_32_41 g_32_41 g_33_41 4.993426e-04
Rgv_32_41 g_32_41 g_32_42 4.993426e-04
Rgh_32_42 g_32_42 g_33_42 4.993426e-04
Rgv_32_42 g_32_42 g_32_43 4.993426e-04
Rgh_32_43 g_32_43 g_33_43 4.993426e-04
Rgv_32_43 g_32_43 g_32_44 4.993426e-04
Rgh_32_44 g_32_44 g_33_44 4.993426e-04
Rgv_32_44 g_32_44 g_32_45 4.993426e-04
Rgh_32_45 g_32_45 g_33_45 4.993426e-04
Rgv_32_45 g_32_45 g_32_46 4.993426e-04
Rgh_32_46 g_32_46 g_33_46 4.993426e-04
Rgv_32_46 g_32_46 g_32_47 4.993426e-04
Rgh_32_47 g_32_47 g_33_47 4.993426e-04
Rgv_32_47 g_32_47 g_32_48 4.993426e-04
Rgh_32_48 g_32_48 g_33_48 4.993426e-04
Rgv_32_48 g_32_48 g_32_49 4.993426e-04
Rgh_32_49 g_32_49 g_33_49 4.993426e-04
Rgv_32_49 g_32_49 g_32_50 4.993426e-04
Rgh_32_50 g_32_50 g_33_50 4.993426e-04
Rgv_32_50 g_32_50 g_32_51 4.993426e-04
Rgh_32_51 g_32_51 g_33_51 4.993426e-04
Rgv_32_51 g_32_51 g_32_52 4.993426e-04
Rgh_32_52 g_32_52 g_33_52 4.993426e-04
Rgv_32_52 g_32_52 g_32_53 4.993426e-04
Rgh_32_53 g_32_53 g_33_53 4.993426e-04
Rgv_32_53 g_32_53 g_32_54 4.993426e-04
Rgh_32_54 g_32_54 g_33_54 4.993426e-04
Rgv_32_54 g_32_54 g_32_55 4.993426e-04
Rgh_32_55 g_32_55 g_33_55 4.993426e-04
Rgv_32_55 g_32_55 g_32_56 4.993426e-04
Rgh_32_56 g_32_56 g_33_56 4.993426e-04
Rgv_32_56 g_32_56 g_32_57 4.993426e-04
Rgh_32_57 g_32_57 g_33_57 4.993426e-04
Rgv_32_57 g_32_57 g_32_58 4.993426e-04
Rgh_32_58 g_32_58 g_33_58 4.993426e-04
Rgv_32_58 g_32_58 g_32_59 4.993426e-04
Rgh_32_59 g_32_59 g_33_59 4.993426e-04
Rgv_32_59 g_32_59 g_32_60 4.993426e-04
Rgh_32_60 g_32_60 g_33_60 4.993426e-04
Rgv_32_60 g_32_60 g_32_61 4.993426e-04
Rgh_32_61 g_32_61 g_33_61 4.993426e-04
Rgv_32_61 g_32_61 g_32_62 4.993426e-04
Rgh_32_62 g_32_62 g_33_62 4.993426e-04
Rgv_32_62 g_32_62 g_32_63 4.993426e-04
Rgh_32_63 g_32_63 g_33_63 4.993426e-04
Rgv_32_63 g_32_63 g_32_64 4.993426e-04
Rgh_32_64 g_32_64 g_33_64 4.993426e-04
Rgv_32_64 g_32_64 g_32_65 4.993426e-04
Rgh_32_65 g_32_65 g_33_65 4.993426e-04
Rgv_32_65 g_32_65 g_32_66 4.993426e-04
Rgh_32_66 g_32_66 g_33_66 4.993426e-04
Rgv_32_66 g_32_66 g_32_67 4.993426e-04
Rgh_32_67 g_32_67 g_33_67 4.993426e-04
Rgv_32_67 g_32_67 g_32_68 4.993426e-04
Rgh_32_68 g_32_68 g_33_68 4.993426e-04
Rgv_32_68 g_32_68 g_32_69 4.993426e-04
Rgh_32_69 g_32_69 g_33_69 4.993426e-04
Rgv_32_69 g_32_69 g_32_70 4.993426e-04
Rgh_32_70 g_32_70 g_33_70 4.993426e-04
Rgv_32_70 g_32_70 g_32_71 4.993426e-04
Rgh_32_71 g_32_71 g_33_71 4.993426e-04
Rgh_33_0 g_33_0 g_34_0 4.993426e-04
Rgv_33_0 g_33_0 g_33_1 4.993426e-04
Rgh_33_1 g_33_1 g_34_1 4.993426e-04
Rgv_33_1 g_33_1 g_33_2 4.993426e-04
Rgh_33_2 g_33_2 g_34_2 4.993426e-04
Rgv_33_2 g_33_2 g_33_3 4.993426e-04
Rgh_33_3 g_33_3 g_34_3 4.993426e-04
Rgv_33_3 g_33_3 g_33_4 4.993426e-04
Rgh_33_4 g_33_4 g_34_4 4.993426e-04
Rgv_33_4 g_33_4 g_33_5 4.993426e-04
Rgh_33_5 g_33_5 g_34_5 4.993426e-04
Rgv_33_5 g_33_5 g_33_6 4.993426e-04
Rgh_33_6 g_33_6 g_34_6 4.993426e-04
Rgv_33_6 g_33_6 g_33_7 4.993426e-04
Rgh_33_7 g_33_7 g_34_7 4.993426e-04
Rgv_33_7 g_33_7 g_33_8 4.993426e-04
Rgh_33_8 g_33_8 g_34_8 4.993426e-04
Rgv_33_8 g_33_8 g_33_9 4.993426e-04
Rgh_33_9 g_33_9 g_34_9 4.993426e-04
Rgv_33_9 g_33_9 g_33_10 4.993426e-04
Rgh_33_10 g_33_10 g_34_10 4.993426e-04
Rgv_33_10 g_33_10 g_33_11 4.993426e-04
Rgh_33_11 g_33_11 g_34_11 4.993426e-04
Rgv_33_11 g_33_11 g_33_12 4.993426e-04
Rgh_33_12 g_33_12 g_34_12 4.993426e-04
Rgv_33_12 g_33_12 g_33_13 4.993426e-04
Rgh_33_13 g_33_13 g_34_13 4.993426e-04
Rgv_33_13 g_33_13 g_33_14 4.993426e-04
Rgh_33_14 g_33_14 g_34_14 4.993426e-04
Rgv_33_14 g_33_14 g_33_15 4.993426e-04
Rgh_33_15 g_33_15 g_34_15 4.993426e-04
Rgv_33_15 g_33_15 g_33_16 4.993426e-04
Rgh_33_16 g_33_16 g_34_16 4.993426e-04
Rgv_33_16 g_33_16 g_33_17 4.993426e-04
Rgh_33_17 g_33_17 g_34_17 4.993426e-04
Rgv_33_17 g_33_17 g_33_18 4.993426e-04
Rgh_33_18 g_33_18 g_34_18 4.993426e-04
Rgv_33_18 g_33_18 g_33_19 4.993426e-04
Rgh_33_19 g_33_19 g_34_19 4.993426e-04
Rgv_33_19 g_33_19 g_33_20 4.993426e-04
Rgh_33_20 g_33_20 g_34_20 4.993426e-04
Rgv_33_20 g_33_20 g_33_21 4.993426e-04
Rgh_33_21 g_33_21 g_34_21 4.993426e-04
Rgv_33_21 g_33_21 g_33_22 4.993426e-04
Rgh_33_22 g_33_22 g_34_22 4.993426e-04
Rgv_33_22 g_33_22 g_33_23 4.993426e-04
Rgh_33_23 g_33_23 g_34_23 4.993426e-04
Rgv_33_23 g_33_23 g_33_24 4.993426e-04
Rgh_33_24 g_33_24 g_34_24 4.993426e-04
Rgv_33_24 g_33_24 g_33_25 4.993426e-04
Rgh_33_25 g_33_25 g_34_25 4.993426e-04
Rgv_33_25 g_33_25 g_33_26 4.993426e-04
Rgh_33_26 g_33_26 g_34_26 4.993426e-04
Rgv_33_26 g_33_26 g_33_27 4.993426e-04
Rgh_33_27 g_33_27 g_34_27 4.993426e-04
Rgv_33_27 g_33_27 g_33_28 4.993426e-04
Rgh_33_28 g_33_28 g_34_28 4.993426e-04
Rgv_33_28 g_33_28 g_33_29 4.993426e-04
Rgh_33_29 g_33_29 g_34_29 4.993426e-04
Rgv_33_29 g_33_29 g_33_30 4.993426e-04
Rgh_33_30 g_33_30 g_34_30 4.993426e-04
Rgv_33_30 g_33_30 g_33_31 4.993426e-04
Rgh_33_31 g_33_31 g_34_31 4.993426e-04
Rgv_33_31 g_33_31 g_33_32 4.993426e-04
Rgh_33_32 g_33_32 g_34_32 4.993426e-04
Rgv_33_32 g_33_32 g_33_33 4.993426e-04
Rgh_33_33 g_33_33 g_34_33 4.993426e-04
Rgv_33_33 g_33_33 g_33_34 4.993426e-04
Rgh_33_34 g_33_34 g_34_34 4.993426e-04
Rgv_33_34 g_33_34 g_33_35 4.993426e-04
Rgh_33_35 g_33_35 g_34_35 4.993426e-04
Rgv_33_35 g_33_35 g_33_36 4.993426e-04
Rgh_33_36 g_33_36 g_34_36 4.993426e-04
Rgv_33_36 g_33_36 g_33_37 4.993426e-04
Rgh_33_37 g_33_37 g_34_37 4.993426e-04
Rgv_33_37 g_33_37 g_33_38 4.993426e-04
Rgh_33_38 g_33_38 g_34_38 4.993426e-04
Rgv_33_38 g_33_38 g_33_39 4.993426e-04
Rgh_33_39 g_33_39 g_34_39 4.993426e-04
Rgv_33_39 g_33_39 g_33_40 4.993426e-04
Rgh_33_40 g_33_40 g_34_40 4.993426e-04
Rgv_33_40 g_33_40 g_33_41 4.993426e-04
Rgh_33_41 g_33_41 g_34_41 4.993426e-04
Rgv_33_41 g_33_41 g_33_42 4.993426e-04
Rgh_33_42 g_33_42 g_34_42 4.993426e-04
Rgv_33_42 g_33_42 g_33_43 4.993426e-04
Rgh_33_43 g_33_43 g_34_43 4.993426e-04
Rgv_33_43 g_33_43 g_33_44 4.993426e-04
Rgh_33_44 g_33_44 g_34_44 4.993426e-04
Rgv_33_44 g_33_44 g_33_45 4.993426e-04
Rgh_33_45 g_33_45 g_34_45 4.993426e-04
Rgv_33_45 g_33_45 g_33_46 4.993426e-04
Rgh_33_46 g_33_46 g_34_46 4.993426e-04
Rgv_33_46 g_33_46 g_33_47 4.993426e-04
Rgh_33_47 g_33_47 g_34_47 4.993426e-04
Rgv_33_47 g_33_47 g_33_48 4.993426e-04
Rgh_33_48 g_33_48 g_34_48 4.993426e-04
Rgv_33_48 g_33_48 g_33_49 4.993426e-04
Rgh_33_49 g_33_49 g_34_49 4.993426e-04
Rgv_33_49 g_33_49 g_33_50 4.993426e-04
Rgh_33_50 g_33_50 g_34_50 4.993426e-04
Rgv_33_50 g_33_50 g_33_51 4.993426e-04
Rgh_33_51 g_33_51 g_34_51 4.993426e-04
Rgv_33_51 g_33_51 g_33_52 4.993426e-04
Rgh_33_52 g_33_52 g_34_52 4.993426e-04
Rgv_33_52 g_33_52 g_33_53 4.993426e-04
Rgh_33_53 g_33_53 g_34_53 4.993426e-04
Rgv_33_53 g_33_53 g_33_54 4.993426e-04
Rgh_33_54 g_33_54 g_34_54 4.993426e-04
Rgv_33_54 g_33_54 g_33_55 4.993426e-04
Rgh_33_55 g_33_55 g_34_55 4.993426e-04
Rgv_33_55 g_33_55 g_33_56 4.993426e-04
Rgh_33_56 g_33_56 g_34_56 4.993426e-04
Rgv_33_56 g_33_56 g_33_57 4.993426e-04
Rgh_33_57 g_33_57 g_34_57 4.993426e-04
Rgv_33_57 g_33_57 g_33_58 4.993426e-04
Rgh_33_58 g_33_58 g_34_58 4.993426e-04
Rgv_33_58 g_33_58 g_33_59 4.993426e-04
Rgh_33_59 g_33_59 g_34_59 4.993426e-04
Rgv_33_59 g_33_59 g_33_60 4.993426e-04
Rgh_33_60 g_33_60 g_34_60 4.993426e-04
Rgv_33_60 g_33_60 g_33_61 4.993426e-04
Rgh_33_61 g_33_61 g_34_61 4.993426e-04
Rgv_33_61 g_33_61 g_33_62 4.993426e-04
Rgh_33_62 g_33_62 g_34_62 4.993426e-04
Rgv_33_62 g_33_62 g_33_63 4.993426e-04
Rgh_33_63 g_33_63 g_34_63 4.993426e-04
Rgv_33_63 g_33_63 g_33_64 4.993426e-04
Rgh_33_64 g_33_64 g_34_64 4.993426e-04
Rgv_33_64 g_33_64 g_33_65 4.993426e-04
Rgh_33_65 g_33_65 g_34_65 4.993426e-04
Rgv_33_65 g_33_65 g_33_66 4.993426e-04
Rgh_33_66 g_33_66 g_34_66 4.993426e-04
Rgv_33_66 g_33_66 g_33_67 4.993426e-04
Rgh_33_67 g_33_67 g_34_67 4.993426e-04
Rgv_33_67 g_33_67 g_33_68 4.993426e-04
Rgh_33_68 g_33_68 g_34_68 4.993426e-04
Rgv_33_68 g_33_68 g_33_69 4.993426e-04
Rgh_33_69 g_33_69 g_34_69 4.993426e-04
Rgv_33_69 g_33_69 g_33_70 4.993426e-04
Rgh_33_70 g_33_70 g_34_70 4.993426e-04
Rgv_33_70 g_33_70 g_33_71 4.993426e-04
Rgh_33_71 g_33_71 g_34_71 4.993426e-04
Rgh_34_0 g_34_0 g_35_0 4.993426e-04
Rgv_34_0 g_34_0 g_34_1 4.993426e-04
Rgh_34_1 g_34_1 g_35_1 4.993426e-04
Rgv_34_1 g_34_1 g_34_2 4.993426e-04
Rgh_34_2 g_34_2 g_35_2 4.993426e-04
Rgv_34_2 g_34_2 g_34_3 4.993426e-04
Rgh_34_3 g_34_3 g_35_3 4.993426e-04
Rgv_34_3 g_34_3 g_34_4 4.993426e-04
Rgh_34_4 g_34_4 g_35_4 4.993426e-04
Rgv_34_4 g_34_4 g_34_5 4.993426e-04
Rgh_34_5 g_34_5 g_35_5 4.993426e-04
Rgv_34_5 g_34_5 g_34_6 4.993426e-04
Rgh_34_6 g_34_6 g_35_6 4.993426e-04
Rgv_34_6 g_34_6 g_34_7 4.993426e-04
Rgh_34_7 g_34_7 g_35_7 4.993426e-04
Rgv_34_7 g_34_7 g_34_8 4.993426e-04
Rgh_34_8 g_34_8 g_35_8 4.993426e-04
Rgv_34_8 g_34_8 g_34_9 4.993426e-04
Rgh_34_9 g_34_9 g_35_9 4.993426e-04
Rgv_34_9 g_34_9 g_34_10 4.993426e-04
Rgh_34_10 g_34_10 g_35_10 4.993426e-04
Rgv_34_10 g_34_10 g_34_11 4.993426e-04
Rgh_34_11 g_34_11 g_35_11 4.993426e-04
Rgv_34_11 g_34_11 g_34_12 4.993426e-04
Rgh_34_12 g_34_12 g_35_12 4.993426e-04
Rgv_34_12 g_34_12 g_34_13 4.993426e-04
Rgh_34_13 g_34_13 g_35_13 4.993426e-04
Rgv_34_13 g_34_13 g_34_14 4.993426e-04
Rgh_34_14 g_34_14 g_35_14 4.993426e-04
Rgv_34_14 g_34_14 g_34_15 4.993426e-04
Rgh_34_15 g_34_15 g_35_15 4.993426e-04
Rgv_34_15 g_34_15 g_34_16 4.993426e-04
Rgh_34_16 g_34_16 g_35_16 4.993426e-04
Rgv_34_16 g_34_16 g_34_17 4.993426e-04
Rgh_34_17 g_34_17 g_35_17 4.993426e-04
Rgv_34_17 g_34_17 g_34_18 4.993426e-04
Rgh_34_18 g_34_18 g_35_18 4.993426e-04
Rgv_34_18 g_34_18 g_34_19 4.993426e-04
Rgh_34_19 g_34_19 g_35_19 4.993426e-04
Rgv_34_19 g_34_19 g_34_20 4.993426e-04
Rgh_34_20 g_34_20 g_35_20 4.993426e-04
Rgv_34_20 g_34_20 g_34_21 4.993426e-04
Rgh_34_21 g_34_21 g_35_21 4.993426e-04
Rgv_34_21 g_34_21 g_34_22 4.993426e-04
Rgh_34_22 g_34_22 g_35_22 4.993426e-04
Rgv_34_22 g_34_22 g_34_23 4.993426e-04
Rgh_34_23 g_34_23 g_35_23 4.993426e-04
Rgv_34_23 g_34_23 g_34_24 4.993426e-04
Rgh_34_24 g_34_24 g_35_24 4.993426e-04
Rgv_34_24 g_34_24 g_34_25 4.993426e-04
Rgh_34_25 g_34_25 g_35_25 4.993426e-04
Rgv_34_25 g_34_25 g_34_26 4.993426e-04
Rgh_34_26 g_34_26 g_35_26 4.993426e-04
Rgv_34_26 g_34_26 g_34_27 4.993426e-04
Rgh_34_27 g_34_27 g_35_27 4.993426e-04
Rgv_34_27 g_34_27 g_34_28 4.993426e-04
Rgh_34_28 g_34_28 g_35_28 4.993426e-04
Rgv_34_28 g_34_28 g_34_29 4.993426e-04
Rgh_34_29 g_34_29 g_35_29 4.993426e-04
Rgv_34_29 g_34_29 g_34_30 4.993426e-04
Rgh_34_30 g_34_30 g_35_30 4.993426e-04
Rgv_34_30 g_34_30 g_34_31 4.993426e-04
Rgh_34_31 g_34_31 g_35_31 4.993426e-04
Rgv_34_31 g_34_31 g_34_32 4.993426e-04
Rgh_34_32 g_34_32 g_35_32 4.993426e-04
Rgv_34_32 g_34_32 g_34_33 4.993426e-04
Rgh_34_33 g_34_33 g_35_33 4.993426e-04
Rgv_34_33 g_34_33 g_34_34 4.993426e-04
Rgh_34_34 g_34_34 g_35_34 4.993426e-04
Rgv_34_34 g_34_34 g_34_35 4.993426e-04
Rgh_34_35 g_34_35 g_35_35 4.993426e-04
Rgv_34_35 g_34_35 g_34_36 4.993426e-04
Rgh_34_36 g_34_36 g_35_36 4.993426e-04
Rgv_34_36 g_34_36 g_34_37 4.993426e-04
Rgh_34_37 g_34_37 g_35_37 4.993426e-04
Rgv_34_37 g_34_37 g_34_38 4.993426e-04
Rgh_34_38 g_34_38 g_35_38 4.993426e-04
Rgv_34_38 g_34_38 g_34_39 4.993426e-04
Rgh_34_39 g_34_39 g_35_39 4.993426e-04
Rgv_34_39 g_34_39 g_34_40 4.993426e-04
Rgh_34_40 g_34_40 g_35_40 4.993426e-04
Rgv_34_40 g_34_40 g_34_41 4.993426e-04
Rgh_34_41 g_34_41 g_35_41 4.993426e-04
Rgv_34_41 g_34_41 g_34_42 4.993426e-04
Rgh_34_42 g_34_42 g_35_42 4.993426e-04
Rgv_34_42 g_34_42 g_34_43 4.993426e-04
Rgh_34_43 g_34_43 g_35_43 4.993426e-04
Rgv_34_43 g_34_43 g_34_44 4.993426e-04
Rgh_34_44 g_34_44 g_35_44 4.993426e-04
Rgv_34_44 g_34_44 g_34_45 4.993426e-04
Rgh_34_45 g_34_45 g_35_45 4.993426e-04
Rgv_34_45 g_34_45 g_34_46 4.993426e-04
Rgh_34_46 g_34_46 g_35_46 4.993426e-04
Rgv_34_46 g_34_46 g_34_47 4.993426e-04
Rgh_34_47 g_34_47 g_35_47 4.993426e-04
Rgv_34_47 g_34_47 g_34_48 4.993426e-04
Rgh_34_48 g_34_48 g_35_48 4.993426e-04
Rgv_34_48 g_34_48 g_34_49 4.993426e-04
Rgh_34_49 g_34_49 g_35_49 4.993426e-04
Rgv_34_49 g_34_49 g_34_50 4.993426e-04
Rgh_34_50 g_34_50 g_35_50 4.993426e-04
Rgv_34_50 g_34_50 g_34_51 4.993426e-04
Rgh_34_51 g_34_51 g_35_51 4.993426e-04
Rgv_34_51 g_34_51 g_34_52 4.993426e-04
Rgh_34_52 g_34_52 g_35_52 4.993426e-04
Rgv_34_52 g_34_52 g_34_53 4.993426e-04
Rgh_34_53 g_34_53 g_35_53 4.993426e-04
Rgv_34_53 g_34_53 g_34_54 4.993426e-04
Rgh_34_54 g_34_54 g_35_54 4.993426e-04
Rgv_34_54 g_34_54 g_34_55 4.993426e-04
Rgh_34_55 g_34_55 g_35_55 4.993426e-04
Rgv_34_55 g_34_55 g_34_56 4.993426e-04
Rgh_34_56 g_34_56 g_35_56 4.993426e-04
Rgv_34_56 g_34_56 g_34_57 4.993426e-04
Rgh_34_57 g_34_57 g_35_57 4.993426e-04
Rgv_34_57 g_34_57 g_34_58 4.993426e-04
Rgh_34_58 g_34_58 g_35_58 4.993426e-04
Rgv_34_58 g_34_58 g_34_59 4.993426e-04
Rgh_34_59 g_34_59 g_35_59 4.993426e-04
Rgv_34_59 g_34_59 g_34_60 4.993426e-04
Rgh_34_60 g_34_60 g_35_60 4.993426e-04
Rgv_34_60 g_34_60 g_34_61 4.993426e-04
Rgh_34_61 g_34_61 g_35_61 4.993426e-04
Rgv_34_61 g_34_61 g_34_62 4.993426e-04
Rgh_34_62 g_34_62 g_35_62 4.993426e-04
Rgv_34_62 g_34_62 g_34_63 4.993426e-04
Rgh_34_63 g_34_63 g_35_63 4.993426e-04
Rgv_34_63 g_34_63 g_34_64 4.993426e-04
Rgh_34_64 g_34_64 g_35_64 4.993426e-04
Rgv_34_64 g_34_64 g_34_65 4.993426e-04
Rgh_34_65 g_34_65 g_35_65 4.993426e-04
Rgv_34_65 g_34_65 g_34_66 4.993426e-04
Rgh_34_66 g_34_66 g_35_66 4.993426e-04
Rgv_34_66 g_34_66 g_34_67 4.993426e-04
Rgh_34_67 g_34_67 g_35_67 4.993426e-04
Rgv_34_67 g_34_67 g_34_68 4.993426e-04
Rgh_34_68 g_34_68 g_35_68 4.993426e-04
Rgv_34_68 g_34_68 g_34_69 4.993426e-04
Rgh_34_69 g_34_69 g_35_69 4.993426e-04
Rgv_34_69 g_34_69 g_34_70 4.993426e-04
Rgh_34_70 g_34_70 g_35_70 4.993426e-04
Rgv_34_70 g_34_70 g_34_71 4.993426e-04
Rgh_34_71 g_34_71 g_35_71 4.993426e-04
Rgh_35_0 g_35_0 g_36_0 4.993426e-04
Rgv_35_0 g_35_0 g_35_1 4.993426e-04
Rgh_35_1 g_35_1 g_36_1 4.993426e-04
Rgv_35_1 g_35_1 g_35_2 4.993426e-04
Rgh_35_2 g_35_2 g_36_2 4.993426e-04
Rgv_35_2 g_35_2 g_35_3 4.993426e-04
Rgh_35_3 g_35_3 g_36_3 4.993426e-04
Rgv_35_3 g_35_3 g_35_4 4.993426e-04
Rgh_35_4 g_35_4 g_36_4 4.993426e-04
Rgv_35_4 g_35_4 g_35_5 4.993426e-04
Rgh_35_5 g_35_5 g_36_5 4.993426e-04
Rgv_35_5 g_35_5 g_35_6 4.993426e-04
Rgh_35_6 g_35_6 g_36_6 4.993426e-04
Rgv_35_6 g_35_6 g_35_7 4.993426e-04
Rgh_35_7 g_35_7 g_36_7 4.993426e-04
Rgv_35_7 g_35_7 g_35_8 4.993426e-04
Rgh_35_8 g_35_8 g_36_8 4.993426e-04
Rgv_35_8 g_35_8 g_35_9 4.993426e-04
Rgh_35_9 g_35_9 g_36_9 4.993426e-04
Rgv_35_9 g_35_9 g_35_10 4.993426e-04
Rgh_35_10 g_35_10 g_36_10 4.993426e-04
Rgv_35_10 g_35_10 g_35_11 4.993426e-04
Rgh_35_11 g_35_11 g_36_11 4.993426e-04
Rgv_35_11 g_35_11 g_35_12 4.993426e-04
Rgh_35_12 g_35_12 g_36_12 4.993426e-04
Rgv_35_12 g_35_12 g_35_13 4.993426e-04
Rgh_35_13 g_35_13 g_36_13 4.993426e-04
Rgv_35_13 g_35_13 g_35_14 4.993426e-04
Rgh_35_14 g_35_14 g_36_14 4.993426e-04
Rgv_35_14 g_35_14 g_35_15 4.993426e-04
Rgh_35_15 g_35_15 g_36_15 4.993426e-04
Rgv_35_15 g_35_15 g_35_16 4.993426e-04
Rgh_35_16 g_35_16 g_36_16 4.993426e-04
Rgv_35_16 g_35_16 g_35_17 4.993426e-04
Rgh_35_17 g_35_17 g_36_17 4.993426e-04
Rgv_35_17 g_35_17 g_35_18 4.993426e-04
Rgh_35_18 g_35_18 g_36_18 4.993426e-04
Rgv_35_18 g_35_18 g_35_19 4.993426e-04
Rgh_35_19 g_35_19 g_36_19 4.993426e-04
Rgv_35_19 g_35_19 g_35_20 4.993426e-04
Rgh_35_20 g_35_20 g_36_20 4.993426e-04
Rgv_35_20 g_35_20 g_35_21 4.993426e-04
Rgh_35_21 g_35_21 g_36_21 4.993426e-04
Rgv_35_21 g_35_21 g_35_22 4.993426e-04
Rgh_35_22 g_35_22 g_36_22 4.993426e-04
Rgv_35_22 g_35_22 g_35_23 4.993426e-04
Rgh_35_23 g_35_23 g_36_23 4.993426e-04
Rgv_35_23 g_35_23 g_35_24 4.993426e-04
Rgh_35_24 g_35_24 g_36_24 4.993426e-04
Rgv_35_24 g_35_24 g_35_25 4.993426e-04
Rgh_35_25 g_35_25 g_36_25 4.993426e-04
Rgv_35_25 g_35_25 g_35_26 4.993426e-04
Rgh_35_26 g_35_26 g_36_26 4.993426e-04
Rgv_35_26 g_35_26 g_35_27 4.993426e-04
Rgh_35_27 g_35_27 g_36_27 4.993426e-04
Rgv_35_27 g_35_27 g_35_28 4.993426e-04
Rgh_35_28 g_35_28 g_36_28 4.993426e-04
Rgv_35_28 g_35_28 g_35_29 4.993426e-04
Rgh_35_29 g_35_29 g_36_29 4.993426e-04
Rgv_35_29 g_35_29 g_35_30 4.993426e-04
Rgh_35_30 g_35_30 g_36_30 4.993426e-04
Rgv_35_30 g_35_30 g_35_31 4.993426e-04
Rgh_35_31 g_35_31 g_36_31 4.993426e-04
Rgv_35_31 g_35_31 g_35_32 4.993426e-04
Rgh_35_32 g_35_32 g_36_32 4.993426e-04
Rgv_35_32 g_35_32 g_35_33 4.993426e-04
Rgh_35_33 g_35_33 g_36_33 4.993426e-04
Rgv_35_33 g_35_33 g_35_34 4.993426e-04
Rgh_35_34 g_35_34 g_36_34 4.993426e-04
Rgv_35_34 g_35_34 g_35_35 4.993426e-04
Rgh_35_35 g_35_35 g_36_35 4.993426e-04
Rgv_35_35 g_35_35 g_35_36 4.993426e-04
Rgh_35_36 g_35_36 g_36_36 4.993426e-04
Rgv_35_36 g_35_36 g_35_37 4.993426e-04
Rgh_35_37 g_35_37 g_36_37 4.993426e-04
Rgv_35_37 g_35_37 g_35_38 4.993426e-04
Rgh_35_38 g_35_38 g_36_38 4.993426e-04
Rgv_35_38 g_35_38 g_35_39 4.993426e-04
Rgh_35_39 g_35_39 g_36_39 4.993426e-04
Rgv_35_39 g_35_39 g_35_40 4.993426e-04
Rgh_35_40 g_35_40 g_36_40 4.993426e-04
Rgv_35_40 g_35_40 g_35_41 4.993426e-04
Rgh_35_41 g_35_41 g_36_41 4.993426e-04
Rgv_35_41 g_35_41 g_35_42 4.993426e-04
Rgh_35_42 g_35_42 g_36_42 4.993426e-04
Rgv_35_42 g_35_42 g_35_43 4.993426e-04
Rgh_35_43 g_35_43 g_36_43 4.993426e-04
Rgv_35_43 g_35_43 g_35_44 4.993426e-04
Rgh_35_44 g_35_44 g_36_44 4.993426e-04
Rgv_35_44 g_35_44 g_35_45 4.993426e-04
Rgh_35_45 g_35_45 g_36_45 4.993426e-04
Rgv_35_45 g_35_45 g_35_46 4.993426e-04
Rgh_35_46 g_35_46 g_36_46 4.993426e-04
Rgv_35_46 g_35_46 g_35_47 4.993426e-04
Rgh_35_47 g_35_47 g_36_47 4.993426e-04
Rgv_35_47 g_35_47 g_35_48 4.993426e-04
Rgh_35_48 g_35_48 g_36_48 4.993426e-04
Rgv_35_48 g_35_48 g_35_49 4.993426e-04
Rgh_35_49 g_35_49 g_36_49 4.993426e-04
Rgv_35_49 g_35_49 g_35_50 4.993426e-04
Rgh_35_50 g_35_50 g_36_50 4.993426e-04
Rgv_35_50 g_35_50 g_35_51 4.993426e-04
Rgh_35_51 g_35_51 g_36_51 4.993426e-04
Rgv_35_51 g_35_51 g_35_52 4.993426e-04
Rgh_35_52 g_35_52 g_36_52 4.993426e-04
Rgv_35_52 g_35_52 g_35_53 4.993426e-04
Rgh_35_53 g_35_53 g_36_53 4.993426e-04
Rgv_35_53 g_35_53 g_35_54 4.993426e-04
Rgh_35_54 g_35_54 g_36_54 4.993426e-04
Rgv_35_54 g_35_54 g_35_55 4.993426e-04
Rgh_35_55 g_35_55 g_36_55 4.993426e-04
Rgv_35_55 g_35_55 g_35_56 4.993426e-04
Rgh_35_56 g_35_56 g_36_56 4.993426e-04
Rgv_35_56 g_35_56 g_35_57 4.993426e-04
Rgh_35_57 g_35_57 g_36_57 4.993426e-04
Rgv_35_57 g_35_57 g_35_58 4.993426e-04
Rgh_35_58 g_35_58 g_36_58 4.993426e-04
Rgv_35_58 g_35_58 g_35_59 4.993426e-04
Rgh_35_59 g_35_59 g_36_59 4.993426e-04
Rgv_35_59 g_35_59 g_35_60 4.993426e-04
Rgh_35_60 g_35_60 g_36_60 4.993426e-04
Rgv_35_60 g_35_60 g_35_61 4.993426e-04
Rgh_35_61 g_35_61 g_36_61 4.993426e-04
Rgv_35_61 g_35_61 g_35_62 4.993426e-04
Rgh_35_62 g_35_62 g_36_62 4.993426e-04
Rgv_35_62 g_35_62 g_35_63 4.993426e-04
Rgh_35_63 g_35_63 g_36_63 4.993426e-04
Rgv_35_63 g_35_63 g_35_64 4.993426e-04
Rgh_35_64 g_35_64 g_36_64 4.993426e-04
Rgv_35_64 g_35_64 g_35_65 4.993426e-04
Rgh_35_65 g_35_65 g_36_65 4.993426e-04
Rgv_35_65 g_35_65 g_35_66 4.993426e-04
Rgh_35_66 g_35_66 g_36_66 4.993426e-04
Rgv_35_66 g_35_66 g_35_67 4.993426e-04
Rgh_35_67 g_35_67 g_36_67 4.993426e-04
Rgv_35_67 g_35_67 g_35_68 4.993426e-04
Rgh_35_68 g_35_68 g_36_68 4.993426e-04
Rgv_35_68 g_35_68 g_35_69 4.993426e-04
Rgh_35_69 g_35_69 g_36_69 4.993426e-04
Rgv_35_69 g_35_69 g_35_70 4.993426e-04
Rgh_35_70 g_35_70 g_36_70 4.993426e-04
Rgv_35_70 g_35_70 g_35_71 4.993426e-04
Rgh_35_71 g_35_71 g_36_71 4.993426e-04
Rgh_36_0 g_36_0 g_37_0 4.993426e-04
Rgv_36_0 g_36_0 g_36_1 4.993426e-04
Rgh_36_1 g_36_1 g_37_1 4.993426e-04
Rgv_36_1 g_36_1 g_36_2 4.993426e-04
Rgh_36_2 g_36_2 g_37_2 4.993426e-04
Rgv_36_2 g_36_2 g_36_3 4.993426e-04
Rgh_36_3 g_36_3 g_37_3 4.993426e-04
Rgv_36_3 g_36_3 g_36_4 4.993426e-04
Rgh_36_4 g_36_4 g_37_4 4.993426e-04
Rgv_36_4 g_36_4 g_36_5 4.993426e-04
Rgh_36_5 g_36_5 g_37_5 4.993426e-04
Rgv_36_5 g_36_5 g_36_6 4.993426e-04
Rgh_36_6 g_36_6 g_37_6 4.993426e-04
Rgv_36_6 g_36_6 g_36_7 4.993426e-04
Rgh_36_7 g_36_7 g_37_7 4.993426e-04
Rgv_36_7 g_36_7 g_36_8 4.993426e-04
Rgh_36_8 g_36_8 g_37_8 4.993426e-04
Rgv_36_8 g_36_8 g_36_9 4.993426e-04
Rgh_36_9 g_36_9 g_37_9 4.993426e-04
Rgv_36_9 g_36_9 g_36_10 4.993426e-04
Rgh_36_10 g_36_10 g_37_10 4.993426e-04
Rgv_36_10 g_36_10 g_36_11 4.993426e-04
Rgh_36_11 g_36_11 g_37_11 4.993426e-04
Rgv_36_11 g_36_11 g_36_12 4.993426e-04
Rgh_36_12 g_36_12 g_37_12 4.993426e-04
Rgv_36_12 g_36_12 g_36_13 4.993426e-04
Rgh_36_13 g_36_13 g_37_13 4.993426e-04
Rgv_36_13 g_36_13 g_36_14 4.993426e-04
Rgh_36_14 g_36_14 g_37_14 4.993426e-04
Rgv_36_14 g_36_14 g_36_15 4.993426e-04
Rgh_36_15 g_36_15 g_37_15 4.993426e-04
Rgv_36_15 g_36_15 g_36_16 4.993426e-04
Rgh_36_16 g_36_16 g_37_16 4.993426e-04
Rgv_36_16 g_36_16 g_36_17 4.993426e-04
Rgh_36_17 g_36_17 g_37_17 4.993426e-04
Rgv_36_17 g_36_17 g_36_18 4.993426e-04
Rgh_36_18 g_36_18 g_37_18 4.993426e-04
Rgv_36_18 g_36_18 g_36_19 4.993426e-04
Rgh_36_19 g_36_19 g_37_19 4.993426e-04
Rgv_36_19 g_36_19 g_36_20 4.993426e-04
Rgh_36_20 g_36_20 g_37_20 4.993426e-04
Rgv_36_20 g_36_20 g_36_21 4.993426e-04
Rgh_36_21 g_36_21 g_37_21 4.993426e-04
Rgv_36_21 g_36_21 g_36_22 4.993426e-04
Rgh_36_22 g_36_22 g_37_22 4.993426e-04
Rgv_36_22 g_36_22 g_36_23 4.993426e-04
Rgh_36_23 g_36_23 g_37_23 4.993426e-04
Rgv_36_23 g_36_23 g_36_24 4.993426e-04
Rgh_36_24 g_36_24 g_37_24 4.993426e-04
Rgv_36_24 g_36_24 g_36_25 4.993426e-04
Rgh_36_25 g_36_25 g_37_25 4.993426e-04
Rgv_36_25 g_36_25 g_36_26 4.993426e-04
Rgh_36_26 g_36_26 g_37_26 4.993426e-04
Rgv_36_26 g_36_26 g_36_27 4.993426e-04
Rgh_36_27 g_36_27 g_37_27 4.993426e-04
Rgv_36_27 g_36_27 g_36_28 4.993426e-04
Rgh_36_28 g_36_28 g_37_28 4.993426e-04
Rgv_36_28 g_36_28 g_36_29 4.993426e-04
Rgh_36_29 g_36_29 g_37_29 4.993426e-04
Rgv_36_29 g_36_29 g_36_30 4.993426e-04
Rgh_36_30 g_36_30 g_37_30 4.993426e-04
Rgv_36_30 g_36_30 g_36_31 4.993426e-04
Rgh_36_31 g_36_31 g_37_31 4.993426e-04
Rgv_36_31 g_36_31 g_36_32 4.993426e-04
Rgh_36_32 g_36_32 g_37_32 4.993426e-04
Rgv_36_32 g_36_32 g_36_33 4.993426e-04
Rgh_36_33 g_36_33 g_37_33 4.993426e-04
Rgv_36_33 g_36_33 g_36_34 4.993426e-04
Rgh_36_34 g_36_34 g_37_34 4.993426e-04
Rgv_36_34 g_36_34 g_36_35 4.993426e-04
Rgh_36_35 g_36_35 g_37_35 4.993426e-04
Rgv_36_35 g_36_35 g_36_36 4.993426e-04
Rgh_36_36 g_36_36 g_37_36 4.993426e-04
Rgv_36_36 g_36_36 g_36_37 4.993426e-04
Rgh_36_37 g_36_37 g_37_37 4.993426e-04
Rgv_36_37 g_36_37 g_36_38 4.993426e-04
Rgh_36_38 g_36_38 g_37_38 4.993426e-04
Rgv_36_38 g_36_38 g_36_39 4.993426e-04
Rgh_36_39 g_36_39 g_37_39 4.993426e-04
Rgv_36_39 g_36_39 g_36_40 4.993426e-04
Rgh_36_40 g_36_40 g_37_40 4.993426e-04
Rgv_36_40 g_36_40 g_36_41 4.993426e-04
Rgh_36_41 g_36_41 g_37_41 4.993426e-04
Rgv_36_41 g_36_41 g_36_42 4.993426e-04
Rgh_36_42 g_36_42 g_37_42 4.993426e-04
Rgv_36_42 g_36_42 g_36_43 4.993426e-04
Rgh_36_43 g_36_43 g_37_43 4.993426e-04
Rgv_36_43 g_36_43 g_36_44 4.993426e-04
Rgh_36_44 g_36_44 g_37_44 4.993426e-04
Rgv_36_44 g_36_44 g_36_45 4.993426e-04
Rgh_36_45 g_36_45 g_37_45 4.993426e-04
Rgv_36_45 g_36_45 g_36_46 4.993426e-04
Rgh_36_46 g_36_46 g_37_46 4.993426e-04
Rgv_36_46 g_36_46 g_36_47 4.993426e-04
Rgh_36_47 g_36_47 g_37_47 4.993426e-04
Rgv_36_47 g_36_47 g_36_48 4.993426e-04
Rgh_36_48 g_36_48 g_37_48 4.993426e-04
Rgv_36_48 g_36_48 g_36_49 4.993426e-04
Rgh_36_49 g_36_49 g_37_49 4.993426e-04
Rgv_36_49 g_36_49 g_36_50 4.993426e-04
Rgh_36_50 g_36_50 g_37_50 4.993426e-04
Rgv_36_50 g_36_50 g_36_51 4.993426e-04
Rgh_36_51 g_36_51 g_37_51 4.993426e-04
Rgv_36_51 g_36_51 g_36_52 4.993426e-04
Rgh_36_52 g_36_52 g_37_52 4.993426e-04
Rgv_36_52 g_36_52 g_36_53 4.993426e-04
Rgh_36_53 g_36_53 g_37_53 4.993426e-04
Rgv_36_53 g_36_53 g_36_54 4.993426e-04
Rgh_36_54 g_36_54 g_37_54 4.993426e-04
Rgv_36_54 g_36_54 g_36_55 4.993426e-04
Rgh_36_55 g_36_55 g_37_55 4.993426e-04
Rgv_36_55 g_36_55 g_36_56 4.993426e-04
Rgh_36_56 g_36_56 g_37_56 4.993426e-04
Rgv_36_56 g_36_56 g_36_57 4.993426e-04
Rgh_36_57 g_36_57 g_37_57 4.993426e-04
Rgv_36_57 g_36_57 g_36_58 4.993426e-04
Rgh_36_58 g_36_58 g_37_58 4.993426e-04
Rgv_36_58 g_36_58 g_36_59 4.993426e-04
Rgh_36_59 g_36_59 g_37_59 4.993426e-04
Rgv_36_59 g_36_59 g_36_60 4.993426e-04
Rgh_36_60 g_36_60 g_37_60 4.993426e-04
Rgv_36_60 g_36_60 g_36_61 4.993426e-04
Rgh_36_61 g_36_61 g_37_61 4.993426e-04
Rgv_36_61 g_36_61 g_36_62 4.993426e-04
Rgh_36_62 g_36_62 g_37_62 4.993426e-04
Rgv_36_62 g_36_62 g_36_63 4.993426e-04
Rgh_36_63 g_36_63 g_37_63 4.993426e-04
Rgv_36_63 g_36_63 g_36_64 4.993426e-04
Rgh_36_64 g_36_64 g_37_64 4.993426e-04
Rgv_36_64 g_36_64 g_36_65 4.993426e-04
Rgh_36_65 g_36_65 g_37_65 4.993426e-04
Rgv_36_65 g_36_65 g_36_66 4.993426e-04
Rgh_36_66 g_36_66 g_37_66 4.993426e-04
Rgv_36_66 g_36_66 g_36_67 4.993426e-04
Rgh_36_67 g_36_67 g_37_67 4.993426e-04
Rgv_36_67 g_36_67 g_36_68 4.993426e-04
Rgh_36_68 g_36_68 g_37_68 4.993426e-04
Rgv_36_68 g_36_68 g_36_69 4.993426e-04
Rgh_36_69 g_36_69 g_37_69 4.993426e-04
Rgv_36_69 g_36_69 g_36_70 4.993426e-04
Rgh_36_70 g_36_70 g_37_70 4.993426e-04
Rgv_36_70 g_36_70 g_36_71 4.993426e-04
Rgh_36_71 g_36_71 g_37_71 4.993426e-04
Rgh_37_0 g_37_0 g_38_0 4.993426e-04
Rgv_37_0 g_37_0 g_37_1 4.993426e-04
Rgh_37_1 g_37_1 g_38_1 4.993426e-04
Rgv_37_1 g_37_1 g_37_2 4.993426e-04
Rgh_37_2 g_37_2 g_38_2 4.993426e-04
Rgv_37_2 g_37_2 g_37_3 4.993426e-04
Rgh_37_3 g_37_3 g_38_3 4.993426e-04
Rgv_37_3 g_37_3 g_37_4 4.993426e-04
Rgh_37_4 g_37_4 g_38_4 4.993426e-04
Rgv_37_4 g_37_4 g_37_5 4.993426e-04
Rgh_37_5 g_37_5 g_38_5 4.993426e-04
Rgv_37_5 g_37_5 g_37_6 4.993426e-04
Rgh_37_6 g_37_6 g_38_6 4.993426e-04
Rgv_37_6 g_37_6 g_37_7 4.993426e-04
Rgh_37_7 g_37_7 g_38_7 4.993426e-04
Rgv_37_7 g_37_7 g_37_8 4.993426e-04
Rgh_37_8 g_37_8 g_38_8 4.993426e-04
Rgv_37_8 g_37_8 g_37_9 4.993426e-04
Rgh_37_9 g_37_9 g_38_9 4.993426e-04
Rgv_37_9 g_37_9 g_37_10 4.993426e-04
Rgh_37_10 g_37_10 g_38_10 4.993426e-04
Rgv_37_10 g_37_10 g_37_11 4.993426e-04
Rgh_37_11 g_37_11 g_38_11 4.993426e-04
Rgv_37_11 g_37_11 g_37_12 4.993426e-04
Rgh_37_12 g_37_12 g_38_12 4.993426e-04
Rgv_37_12 g_37_12 g_37_13 4.993426e-04
Rgh_37_13 g_37_13 g_38_13 4.993426e-04
Rgv_37_13 g_37_13 g_37_14 4.993426e-04
Rgh_37_14 g_37_14 g_38_14 4.993426e-04
Rgv_37_14 g_37_14 g_37_15 4.993426e-04
Rgh_37_15 g_37_15 g_38_15 4.993426e-04
Rgv_37_15 g_37_15 g_37_16 4.993426e-04
Rgh_37_16 g_37_16 g_38_16 4.993426e-04
Rgv_37_16 g_37_16 g_37_17 4.993426e-04
Rgh_37_17 g_37_17 g_38_17 4.993426e-04
Rgv_37_17 g_37_17 g_37_18 4.993426e-04
Rgh_37_18 g_37_18 g_38_18 4.993426e-04
Rgv_37_18 g_37_18 g_37_19 4.993426e-04
Rgh_37_19 g_37_19 g_38_19 4.993426e-04
Rgv_37_19 g_37_19 g_37_20 4.993426e-04
Rgh_37_20 g_37_20 g_38_20 4.993426e-04
Rgv_37_20 g_37_20 g_37_21 4.993426e-04
Rgh_37_21 g_37_21 g_38_21 4.993426e-04
Rgv_37_21 g_37_21 g_37_22 4.993426e-04
Rgh_37_22 g_37_22 g_38_22 4.993426e-04
Rgv_37_22 g_37_22 g_37_23 4.993426e-04
Rgh_37_23 g_37_23 g_38_23 4.993426e-04
Rgv_37_23 g_37_23 g_37_24 4.993426e-04
Rgh_37_24 g_37_24 g_38_24 4.993426e-04
Rgv_37_24 g_37_24 g_37_25 4.993426e-04
Rgh_37_25 g_37_25 g_38_25 4.993426e-04
Rgv_37_25 g_37_25 g_37_26 4.993426e-04
Rgh_37_26 g_37_26 g_38_26 4.993426e-04
Rgv_37_26 g_37_26 g_37_27 4.993426e-04
Rgh_37_27 g_37_27 g_38_27 4.993426e-04
Rgv_37_27 g_37_27 g_37_28 4.993426e-04
Rgh_37_28 g_37_28 g_38_28 4.993426e-04
Rgv_37_28 g_37_28 g_37_29 4.993426e-04
Rgh_37_29 g_37_29 g_38_29 4.993426e-04
Rgv_37_29 g_37_29 g_37_30 4.993426e-04
Rgh_37_30 g_37_30 g_38_30 4.993426e-04
Rgv_37_30 g_37_30 g_37_31 4.993426e-04
Rgh_37_31 g_37_31 g_38_31 4.993426e-04
Rgv_37_31 g_37_31 g_37_32 4.993426e-04
Rgh_37_32 g_37_32 g_38_32 4.993426e-04
Rgv_37_32 g_37_32 g_37_33 4.993426e-04
Rgh_37_33 g_37_33 g_38_33 4.993426e-04
Rgv_37_33 g_37_33 g_37_34 4.993426e-04
Rgh_37_34 g_37_34 g_38_34 4.993426e-04
Rgv_37_34 g_37_34 g_37_35 4.993426e-04
Rgh_37_35 g_37_35 g_38_35 4.993426e-04
Rgv_37_35 g_37_35 g_37_36 4.993426e-04
Rgh_37_36 g_37_36 g_38_36 4.993426e-04
Rgv_37_36 g_37_36 g_37_37 4.993426e-04
Rgh_37_37 g_37_37 g_38_37 4.993426e-04
Rgv_37_37 g_37_37 g_37_38 4.993426e-04
Rgh_37_38 g_37_38 g_38_38 4.993426e-04
Rgv_37_38 g_37_38 g_37_39 4.993426e-04
Rgh_37_39 g_37_39 g_38_39 4.993426e-04
Rgv_37_39 g_37_39 g_37_40 4.993426e-04
Rgh_37_40 g_37_40 g_38_40 4.993426e-04
Rgv_37_40 g_37_40 g_37_41 4.993426e-04
Rgh_37_41 g_37_41 g_38_41 4.993426e-04
Rgv_37_41 g_37_41 g_37_42 4.993426e-04
Rgh_37_42 g_37_42 g_38_42 4.993426e-04
Rgv_37_42 g_37_42 g_37_43 4.993426e-04
Rgh_37_43 g_37_43 g_38_43 4.993426e-04
Rgv_37_43 g_37_43 g_37_44 4.993426e-04
Rgh_37_44 g_37_44 g_38_44 4.993426e-04
Rgv_37_44 g_37_44 g_37_45 4.993426e-04
Rgh_37_45 g_37_45 g_38_45 4.993426e-04
Rgv_37_45 g_37_45 g_37_46 4.993426e-04
Rgh_37_46 g_37_46 g_38_46 4.993426e-04
Rgv_37_46 g_37_46 g_37_47 4.993426e-04
Rgh_37_47 g_37_47 g_38_47 4.993426e-04
Rgv_37_47 g_37_47 g_37_48 4.993426e-04
Rgh_37_48 g_37_48 g_38_48 4.993426e-04
Rgv_37_48 g_37_48 g_37_49 4.993426e-04
Rgh_37_49 g_37_49 g_38_49 4.993426e-04
Rgv_37_49 g_37_49 g_37_50 4.993426e-04
Rgh_37_50 g_37_50 g_38_50 4.993426e-04
Rgv_37_50 g_37_50 g_37_51 4.993426e-04
Rgh_37_51 g_37_51 g_38_51 4.993426e-04
Rgv_37_51 g_37_51 g_37_52 4.993426e-04
Rgh_37_52 g_37_52 g_38_52 4.993426e-04
Rgv_37_52 g_37_52 g_37_53 4.993426e-04
Rgh_37_53 g_37_53 g_38_53 4.993426e-04
Rgv_37_53 g_37_53 g_37_54 4.993426e-04
Rgh_37_54 g_37_54 g_38_54 4.993426e-04
Rgv_37_54 g_37_54 g_37_55 4.993426e-04
Rgh_37_55 g_37_55 g_38_55 4.993426e-04
Rgv_37_55 g_37_55 g_37_56 4.993426e-04
Rgh_37_56 g_37_56 g_38_56 4.993426e-04
Rgv_37_56 g_37_56 g_37_57 4.993426e-04
Rgh_37_57 g_37_57 g_38_57 4.993426e-04
Rgv_37_57 g_37_57 g_37_58 4.993426e-04
Rgh_37_58 g_37_58 g_38_58 4.993426e-04
Rgv_37_58 g_37_58 g_37_59 4.993426e-04
Rgh_37_59 g_37_59 g_38_59 4.993426e-04
Rgv_37_59 g_37_59 g_37_60 4.993426e-04
Rgh_37_60 g_37_60 g_38_60 4.993426e-04
Rgv_37_60 g_37_60 g_37_61 4.993426e-04
Rgh_37_61 g_37_61 g_38_61 4.993426e-04
Rgv_37_61 g_37_61 g_37_62 4.993426e-04
Rgh_37_62 g_37_62 g_38_62 4.993426e-04
Rgv_37_62 g_37_62 g_37_63 4.993426e-04
Rgh_37_63 g_37_63 g_38_63 4.993426e-04
Rgv_37_63 g_37_63 g_37_64 4.993426e-04
Rgh_37_64 g_37_64 g_38_64 4.993426e-04
Rgv_37_64 g_37_64 g_37_65 4.993426e-04
Rgh_37_65 g_37_65 g_38_65 4.993426e-04
Rgv_37_65 g_37_65 g_37_66 4.993426e-04
Rgh_37_66 g_37_66 g_38_66 4.993426e-04
Rgv_37_66 g_37_66 g_37_67 4.993426e-04
Rgh_37_67 g_37_67 g_38_67 4.993426e-04
Rgv_37_67 g_37_67 g_37_68 4.993426e-04
Rgh_37_68 g_37_68 g_38_68 4.993426e-04
Rgv_37_68 g_37_68 g_37_69 4.993426e-04
Rgh_37_69 g_37_69 g_38_69 4.993426e-04
Rgv_37_69 g_37_69 g_37_70 4.993426e-04
Rgh_37_70 g_37_70 g_38_70 4.993426e-04
Rgv_37_70 g_37_70 g_37_71 4.993426e-04
Rgh_37_71 g_37_71 g_38_71 4.993426e-04
Rgh_38_0 g_38_0 g_39_0 4.993426e-04
Rgv_38_0 g_38_0 g_38_1 4.993426e-04
Rgh_38_1 g_38_1 g_39_1 4.993426e-04
Rgv_38_1 g_38_1 g_38_2 4.993426e-04
Rgh_38_2 g_38_2 g_39_2 4.993426e-04
Rgv_38_2 g_38_2 g_38_3 4.993426e-04
Rgh_38_3 g_38_3 g_39_3 4.993426e-04
Rgv_38_3 g_38_3 g_38_4 4.993426e-04
Rgh_38_4 g_38_4 g_39_4 4.993426e-04
Rgv_38_4 g_38_4 g_38_5 4.993426e-04
Rgh_38_5 g_38_5 g_39_5 4.993426e-04
Rgv_38_5 g_38_5 g_38_6 4.993426e-04
Rgh_38_6 g_38_6 g_39_6 4.993426e-04
Rgv_38_6 g_38_6 g_38_7 4.993426e-04
Rgh_38_7 g_38_7 g_39_7 4.993426e-04
Rgv_38_7 g_38_7 g_38_8 4.993426e-04
Rgh_38_8 g_38_8 g_39_8 4.993426e-04
Rgv_38_8 g_38_8 g_38_9 4.993426e-04
Rgh_38_9 g_38_9 g_39_9 4.993426e-04
Rgv_38_9 g_38_9 g_38_10 4.993426e-04
Rgh_38_10 g_38_10 g_39_10 4.993426e-04
Rgv_38_10 g_38_10 g_38_11 4.993426e-04
Rgh_38_11 g_38_11 g_39_11 4.993426e-04
Rgv_38_11 g_38_11 g_38_12 4.993426e-04
Rgh_38_12 g_38_12 g_39_12 4.993426e-04
Rgv_38_12 g_38_12 g_38_13 4.993426e-04
Rgh_38_13 g_38_13 g_39_13 4.993426e-04
Rgv_38_13 g_38_13 g_38_14 4.993426e-04
Rgh_38_14 g_38_14 g_39_14 4.993426e-04
Rgv_38_14 g_38_14 g_38_15 4.993426e-04
Rgh_38_15 g_38_15 g_39_15 4.993426e-04
Rgv_38_15 g_38_15 g_38_16 4.993426e-04
Rgh_38_16 g_38_16 g_39_16 4.993426e-04
Rgv_38_16 g_38_16 g_38_17 4.993426e-04
Rgh_38_17 g_38_17 g_39_17 4.993426e-04
Rgv_38_17 g_38_17 g_38_18 4.993426e-04
Rgh_38_18 g_38_18 g_39_18 4.993426e-04
Rgv_38_18 g_38_18 g_38_19 4.993426e-04
Rgh_38_19 g_38_19 g_39_19 4.993426e-04
Rgv_38_19 g_38_19 g_38_20 4.993426e-04
Rgh_38_20 g_38_20 g_39_20 4.993426e-04
Rgv_38_20 g_38_20 g_38_21 4.993426e-04
Rgh_38_21 g_38_21 g_39_21 4.993426e-04
Rgv_38_21 g_38_21 g_38_22 4.993426e-04
Rgh_38_22 g_38_22 g_39_22 4.993426e-04
Rgv_38_22 g_38_22 g_38_23 4.993426e-04
Rgh_38_23 g_38_23 g_39_23 4.993426e-04
Rgv_38_23 g_38_23 g_38_24 4.993426e-04
Rgh_38_24 g_38_24 g_39_24 4.993426e-04
Rgv_38_24 g_38_24 g_38_25 4.993426e-04
Rgh_38_25 g_38_25 g_39_25 4.993426e-04
Rgv_38_25 g_38_25 g_38_26 4.993426e-04
Rgh_38_26 g_38_26 g_39_26 4.993426e-04
Rgv_38_26 g_38_26 g_38_27 4.993426e-04
Rgh_38_27 g_38_27 g_39_27 4.993426e-04
Rgv_38_27 g_38_27 g_38_28 4.993426e-04
Rgh_38_28 g_38_28 g_39_28 4.993426e-04
Rgv_38_28 g_38_28 g_38_29 4.993426e-04
Rgh_38_29 g_38_29 g_39_29 4.993426e-04
Rgv_38_29 g_38_29 g_38_30 4.993426e-04
Rgh_38_30 g_38_30 g_39_30 4.993426e-04
Rgv_38_30 g_38_30 g_38_31 4.993426e-04
Rgh_38_31 g_38_31 g_39_31 4.993426e-04
Rgv_38_31 g_38_31 g_38_32 4.993426e-04
Rgh_38_32 g_38_32 g_39_32 4.993426e-04
Rgv_38_32 g_38_32 g_38_33 4.993426e-04
Rgh_38_33 g_38_33 g_39_33 4.993426e-04
Rgv_38_33 g_38_33 g_38_34 4.993426e-04
Rgh_38_34 g_38_34 g_39_34 4.993426e-04
Rgv_38_34 g_38_34 g_38_35 4.993426e-04
Rgh_38_35 g_38_35 g_39_35 4.993426e-04
Rgv_38_35 g_38_35 g_38_36 4.993426e-04
Rgh_38_36 g_38_36 g_39_36 4.993426e-04
Rgv_38_36 g_38_36 g_38_37 4.993426e-04
Rgh_38_37 g_38_37 g_39_37 4.993426e-04
Rgv_38_37 g_38_37 g_38_38 4.993426e-04
Rgh_38_38 g_38_38 g_39_38 4.993426e-04
Rgv_38_38 g_38_38 g_38_39 4.993426e-04
Rgh_38_39 g_38_39 g_39_39 4.993426e-04
Rgv_38_39 g_38_39 g_38_40 4.993426e-04
Rgh_38_40 g_38_40 g_39_40 4.993426e-04
Rgv_38_40 g_38_40 g_38_41 4.993426e-04
Rgh_38_41 g_38_41 g_39_41 4.993426e-04
Rgv_38_41 g_38_41 g_38_42 4.993426e-04
Rgh_38_42 g_38_42 g_39_42 4.993426e-04
Rgv_38_42 g_38_42 g_38_43 4.993426e-04
Rgh_38_43 g_38_43 g_39_43 4.993426e-04
Rgv_38_43 g_38_43 g_38_44 4.993426e-04
Rgh_38_44 g_38_44 g_39_44 4.993426e-04
Rgv_38_44 g_38_44 g_38_45 4.993426e-04
Rgh_38_45 g_38_45 g_39_45 4.993426e-04
Rgv_38_45 g_38_45 g_38_46 4.993426e-04
Rgh_38_46 g_38_46 g_39_46 4.993426e-04
Rgv_38_46 g_38_46 g_38_47 4.993426e-04
Rgh_38_47 g_38_47 g_39_47 4.993426e-04
Rgv_38_47 g_38_47 g_38_48 4.993426e-04
Rgh_38_48 g_38_48 g_39_48 4.993426e-04
Rgv_38_48 g_38_48 g_38_49 4.993426e-04
Rgh_38_49 g_38_49 g_39_49 4.993426e-04
Rgv_38_49 g_38_49 g_38_50 4.993426e-04
Rgh_38_50 g_38_50 g_39_50 4.993426e-04
Rgv_38_50 g_38_50 g_38_51 4.993426e-04
Rgh_38_51 g_38_51 g_39_51 4.993426e-04
Rgv_38_51 g_38_51 g_38_52 4.993426e-04
Rgh_38_52 g_38_52 g_39_52 4.993426e-04
Rgv_38_52 g_38_52 g_38_53 4.993426e-04
Rgh_38_53 g_38_53 g_39_53 4.993426e-04
Rgv_38_53 g_38_53 g_38_54 4.993426e-04
Rgh_38_54 g_38_54 g_39_54 4.993426e-04
Rgv_38_54 g_38_54 g_38_55 4.993426e-04
Rgh_38_55 g_38_55 g_39_55 4.993426e-04
Rgv_38_55 g_38_55 g_38_56 4.993426e-04
Rgh_38_56 g_38_56 g_39_56 4.993426e-04
Rgv_38_56 g_38_56 g_38_57 4.993426e-04
Rgh_38_57 g_38_57 g_39_57 4.993426e-04
Rgv_38_57 g_38_57 g_38_58 4.993426e-04
Rgh_38_58 g_38_58 g_39_58 4.993426e-04
Rgv_38_58 g_38_58 g_38_59 4.993426e-04
Rgh_38_59 g_38_59 g_39_59 4.993426e-04
Rgv_38_59 g_38_59 g_38_60 4.993426e-04
Rgh_38_60 g_38_60 g_39_60 4.993426e-04
Rgv_38_60 g_38_60 g_38_61 4.993426e-04
Rgh_38_61 g_38_61 g_39_61 4.993426e-04
Rgv_38_61 g_38_61 g_38_62 4.993426e-04
Rgh_38_62 g_38_62 g_39_62 4.993426e-04
Rgv_38_62 g_38_62 g_38_63 4.993426e-04
Rgh_38_63 g_38_63 g_39_63 4.993426e-04
Rgv_38_63 g_38_63 g_38_64 4.993426e-04
Rgh_38_64 g_38_64 g_39_64 4.993426e-04
Rgv_38_64 g_38_64 g_38_65 4.993426e-04
Rgh_38_65 g_38_65 g_39_65 4.993426e-04
Rgv_38_65 g_38_65 g_38_66 4.993426e-04
Rgh_38_66 g_38_66 g_39_66 4.993426e-04
Rgv_38_66 g_38_66 g_38_67 4.993426e-04
Rgh_38_67 g_38_67 g_39_67 4.993426e-04
Rgv_38_67 g_38_67 g_38_68 4.993426e-04
Rgh_38_68 g_38_68 g_39_68 4.993426e-04
Rgv_38_68 g_38_68 g_38_69 4.993426e-04
Rgh_38_69 g_38_69 g_39_69 4.993426e-04
Rgv_38_69 g_38_69 g_38_70 4.993426e-04
Rgh_38_70 g_38_70 g_39_70 4.993426e-04
Rgv_38_70 g_38_70 g_38_71 4.993426e-04
Rgh_38_71 g_38_71 g_39_71 4.993426e-04
Rgh_39_0 g_39_0 g_40_0 4.993426e-04
Rgv_39_0 g_39_0 g_39_1 4.993426e-04
Rgh_39_1 g_39_1 g_40_1 4.993426e-04
Rgv_39_1 g_39_1 g_39_2 4.993426e-04
Rgh_39_2 g_39_2 g_40_2 4.993426e-04
Rgv_39_2 g_39_2 g_39_3 4.993426e-04
Rgh_39_3 g_39_3 g_40_3 4.993426e-04
Rgv_39_3 g_39_3 g_39_4 4.993426e-04
Rgh_39_4 g_39_4 g_40_4 4.993426e-04
Rgv_39_4 g_39_4 g_39_5 4.993426e-04
Rgh_39_5 g_39_5 g_40_5 4.993426e-04
Rgv_39_5 g_39_5 g_39_6 4.993426e-04
Rgh_39_6 g_39_6 g_40_6 4.993426e-04
Rgv_39_6 g_39_6 g_39_7 4.993426e-04
Rgh_39_7 g_39_7 g_40_7 4.993426e-04
Rgv_39_7 g_39_7 g_39_8 4.993426e-04
Rgh_39_8 g_39_8 g_40_8 4.993426e-04
Rgv_39_8 g_39_8 g_39_9 4.993426e-04
Rgh_39_9 g_39_9 g_40_9 4.993426e-04
Rgv_39_9 g_39_9 g_39_10 4.993426e-04
Rgh_39_10 g_39_10 g_40_10 4.993426e-04
Rgv_39_10 g_39_10 g_39_11 4.993426e-04
Rgh_39_11 g_39_11 g_40_11 4.993426e-04
Rgv_39_11 g_39_11 g_39_12 4.993426e-04
Rgh_39_12 g_39_12 g_40_12 4.993426e-04
Rgv_39_12 g_39_12 g_39_13 4.993426e-04
Rgh_39_13 g_39_13 g_40_13 4.993426e-04
Rgv_39_13 g_39_13 g_39_14 4.993426e-04
Rgh_39_14 g_39_14 g_40_14 4.993426e-04
Rgv_39_14 g_39_14 g_39_15 4.993426e-04
Rgh_39_15 g_39_15 g_40_15 4.993426e-04
Rgv_39_15 g_39_15 g_39_16 4.993426e-04
Rgh_39_16 g_39_16 g_40_16 4.993426e-04
Rgv_39_16 g_39_16 g_39_17 4.993426e-04
Rgh_39_17 g_39_17 g_40_17 4.993426e-04
Rgv_39_17 g_39_17 g_39_18 4.993426e-04
Rgh_39_18 g_39_18 g_40_18 4.993426e-04
Rgv_39_18 g_39_18 g_39_19 4.993426e-04
Rgh_39_19 g_39_19 g_40_19 4.993426e-04
Rgv_39_19 g_39_19 g_39_20 4.993426e-04
Rgh_39_20 g_39_20 g_40_20 4.993426e-04
Rgv_39_20 g_39_20 g_39_21 4.993426e-04
Rgh_39_21 g_39_21 g_40_21 4.993426e-04
Rgv_39_21 g_39_21 g_39_22 4.993426e-04
Rgh_39_22 g_39_22 g_40_22 4.993426e-04
Rgv_39_22 g_39_22 g_39_23 4.993426e-04
Rgh_39_23 g_39_23 g_40_23 4.993426e-04
Rgv_39_23 g_39_23 g_39_24 4.993426e-04
Rgh_39_24 g_39_24 g_40_24 4.993426e-04
Rgv_39_24 g_39_24 g_39_25 4.993426e-04
Rgh_39_25 g_39_25 g_40_25 4.993426e-04
Rgv_39_25 g_39_25 g_39_26 4.993426e-04
Rgh_39_26 g_39_26 g_40_26 4.993426e-04
Rgv_39_26 g_39_26 g_39_27 4.993426e-04
Rgh_39_27 g_39_27 g_40_27 4.993426e-04
Rgv_39_27 g_39_27 g_39_28 4.993426e-04
Rgh_39_28 g_39_28 g_40_28 4.993426e-04
Rgv_39_28 g_39_28 g_39_29 4.993426e-04
Rgh_39_29 g_39_29 g_40_29 4.993426e-04
Rgv_39_29 g_39_29 g_39_30 4.993426e-04
Rgh_39_30 g_39_30 g_40_30 4.993426e-04
Rgv_39_30 g_39_30 g_39_31 4.993426e-04
Rgh_39_31 g_39_31 g_40_31 4.993426e-04
Rgv_39_31 g_39_31 g_39_32 4.993426e-04
Rgh_39_32 g_39_32 g_40_32 4.993426e-04
Rgv_39_32 g_39_32 g_39_33 4.993426e-04
Rgh_39_33 g_39_33 g_40_33 4.993426e-04
Rgv_39_33 g_39_33 g_39_34 4.993426e-04
Rgh_39_34 g_39_34 g_40_34 4.993426e-04
Rgv_39_34 g_39_34 g_39_35 4.993426e-04
Rgh_39_35 g_39_35 g_40_35 4.993426e-04
Rgv_39_35 g_39_35 g_39_36 4.993426e-04
Rgh_39_36 g_39_36 g_40_36 4.993426e-04
Rgv_39_36 g_39_36 g_39_37 4.993426e-04
Rgh_39_37 g_39_37 g_40_37 4.993426e-04
Rgv_39_37 g_39_37 g_39_38 4.993426e-04
Rgh_39_38 g_39_38 g_40_38 4.993426e-04
Rgv_39_38 g_39_38 g_39_39 4.993426e-04
Rgh_39_39 g_39_39 g_40_39 4.993426e-04
Rgv_39_39 g_39_39 g_39_40 4.993426e-04
Rgh_39_40 g_39_40 g_40_40 4.993426e-04
Rgv_39_40 g_39_40 g_39_41 4.993426e-04
Rgh_39_41 g_39_41 g_40_41 4.993426e-04
Rgv_39_41 g_39_41 g_39_42 4.993426e-04
Rgh_39_42 g_39_42 g_40_42 4.993426e-04
Rgv_39_42 g_39_42 g_39_43 4.993426e-04
Rgh_39_43 g_39_43 g_40_43 4.993426e-04
Rgv_39_43 g_39_43 g_39_44 4.993426e-04
Rgh_39_44 g_39_44 g_40_44 4.993426e-04
Rgv_39_44 g_39_44 g_39_45 4.993426e-04
Rgh_39_45 g_39_45 g_40_45 4.993426e-04
Rgv_39_45 g_39_45 g_39_46 4.993426e-04
Rgh_39_46 g_39_46 g_40_46 4.993426e-04
Rgv_39_46 g_39_46 g_39_47 4.993426e-04
Rgh_39_47 g_39_47 g_40_47 4.993426e-04
Rgv_39_47 g_39_47 g_39_48 4.993426e-04
Rgh_39_48 g_39_48 g_40_48 4.993426e-04
Rgv_39_48 g_39_48 g_39_49 4.993426e-04
Rgh_39_49 g_39_49 g_40_49 4.993426e-04
Rgv_39_49 g_39_49 g_39_50 4.993426e-04
Rgh_39_50 g_39_50 g_40_50 4.993426e-04
Rgv_39_50 g_39_50 g_39_51 4.993426e-04
Rgh_39_51 g_39_51 g_40_51 4.993426e-04
Rgv_39_51 g_39_51 g_39_52 4.993426e-04
Rgh_39_52 g_39_52 g_40_52 4.993426e-04
Rgv_39_52 g_39_52 g_39_53 4.993426e-04
Rgh_39_53 g_39_53 g_40_53 4.993426e-04
Rgv_39_53 g_39_53 g_39_54 4.993426e-04
Rgh_39_54 g_39_54 g_40_54 4.993426e-04
Rgv_39_54 g_39_54 g_39_55 4.993426e-04
Rgh_39_55 g_39_55 g_40_55 4.993426e-04
Rgv_39_55 g_39_55 g_39_56 4.993426e-04
Rgh_39_56 g_39_56 g_40_56 4.993426e-04
Rgv_39_56 g_39_56 g_39_57 4.993426e-04
Rgh_39_57 g_39_57 g_40_57 4.993426e-04
Rgv_39_57 g_39_57 g_39_58 4.993426e-04
Rgh_39_58 g_39_58 g_40_58 4.993426e-04
Rgv_39_58 g_39_58 g_39_59 4.993426e-04
Rgh_39_59 g_39_59 g_40_59 4.993426e-04
Rgv_39_59 g_39_59 g_39_60 4.993426e-04
Rgh_39_60 g_39_60 g_40_60 4.993426e-04
Rgv_39_60 g_39_60 g_39_61 4.993426e-04
Rgh_39_61 g_39_61 g_40_61 4.993426e-04
Rgv_39_61 g_39_61 g_39_62 4.993426e-04
Rgh_39_62 g_39_62 g_40_62 4.993426e-04
Rgv_39_62 g_39_62 g_39_63 4.993426e-04
Rgh_39_63 g_39_63 g_40_63 4.993426e-04
Rgv_39_63 g_39_63 g_39_64 4.993426e-04
Rgh_39_64 g_39_64 g_40_64 4.993426e-04
Rgv_39_64 g_39_64 g_39_65 4.993426e-04
Rgh_39_65 g_39_65 g_40_65 4.993426e-04
Rgv_39_65 g_39_65 g_39_66 4.993426e-04
Rgh_39_66 g_39_66 g_40_66 4.993426e-04
Rgv_39_66 g_39_66 g_39_67 4.993426e-04
Rgh_39_67 g_39_67 g_40_67 4.993426e-04
Rgv_39_67 g_39_67 g_39_68 4.993426e-04
Rgh_39_68 g_39_68 g_40_68 4.993426e-04
Rgv_39_68 g_39_68 g_39_69 4.993426e-04
Rgh_39_69 g_39_69 g_40_69 4.993426e-04
Rgv_39_69 g_39_69 g_39_70 4.993426e-04
Rgh_39_70 g_39_70 g_40_70 4.993426e-04
Rgv_39_70 g_39_70 g_39_71 4.993426e-04
Rgh_39_71 g_39_71 g_40_71 4.993426e-04
Rgh_40_0 g_40_0 g_41_0 4.993426e-04
Rgv_40_0 g_40_0 g_40_1 4.993426e-04
Rgh_40_1 g_40_1 g_41_1 4.993426e-04
Rgv_40_1 g_40_1 g_40_2 4.993426e-04
Rgh_40_2 g_40_2 g_41_2 4.993426e-04
Rgv_40_2 g_40_2 g_40_3 4.993426e-04
Rgh_40_3 g_40_3 g_41_3 4.993426e-04
Rgv_40_3 g_40_3 g_40_4 4.993426e-04
Rgh_40_4 g_40_4 g_41_4 4.993426e-04
Rgv_40_4 g_40_4 g_40_5 4.993426e-04
Rgh_40_5 g_40_5 g_41_5 4.993426e-04
Rgv_40_5 g_40_5 g_40_6 4.993426e-04
Rgh_40_6 g_40_6 g_41_6 4.993426e-04
Rgv_40_6 g_40_6 g_40_7 4.993426e-04
Rgh_40_7 g_40_7 g_41_7 4.993426e-04
Rgv_40_7 g_40_7 g_40_8 4.993426e-04
Rgh_40_8 g_40_8 g_41_8 4.993426e-04
Rgv_40_8 g_40_8 g_40_9 4.993426e-04
Rgh_40_9 g_40_9 g_41_9 4.993426e-04
Rgv_40_9 g_40_9 g_40_10 4.993426e-04
Rgh_40_10 g_40_10 g_41_10 4.993426e-04
Rgv_40_10 g_40_10 g_40_11 4.993426e-04
Rgh_40_11 g_40_11 g_41_11 4.993426e-04
Rgv_40_11 g_40_11 g_40_12 4.993426e-04
Rgh_40_12 g_40_12 g_41_12 4.993426e-04
Rgv_40_12 g_40_12 g_40_13 4.993426e-04
Rgh_40_13 g_40_13 g_41_13 4.993426e-04
Rgv_40_13 g_40_13 g_40_14 4.993426e-04
Rgh_40_14 g_40_14 g_41_14 4.993426e-04
Rgv_40_14 g_40_14 g_40_15 4.993426e-04
Rgh_40_15 g_40_15 g_41_15 4.993426e-04
Rgv_40_15 g_40_15 g_40_16 4.993426e-04
Rgh_40_16 g_40_16 g_41_16 4.993426e-04
Rgv_40_16 g_40_16 g_40_17 4.993426e-04
Rgh_40_17 g_40_17 g_41_17 4.993426e-04
Rgv_40_17 g_40_17 g_40_18 4.993426e-04
Rgh_40_18 g_40_18 g_41_18 4.993426e-04
Rgv_40_18 g_40_18 g_40_19 4.993426e-04
Rgh_40_19 g_40_19 g_41_19 4.993426e-04
Rgv_40_19 g_40_19 g_40_20 4.993426e-04
Rgh_40_20 g_40_20 g_41_20 4.993426e-04
Rgv_40_20 g_40_20 g_40_21 4.993426e-04
Rgh_40_21 g_40_21 g_41_21 4.993426e-04
Rgv_40_21 g_40_21 g_40_22 4.993426e-04
Rgh_40_22 g_40_22 g_41_22 4.993426e-04
Rgv_40_22 g_40_22 g_40_23 4.993426e-04
Rgh_40_23 g_40_23 g_41_23 4.993426e-04
Rgv_40_23 g_40_23 g_40_24 4.993426e-04
Rgh_40_24 g_40_24 g_41_24 4.993426e-04
Rgv_40_24 g_40_24 g_40_25 4.993426e-04
Rgh_40_25 g_40_25 g_41_25 4.993426e-04
Rgv_40_25 g_40_25 g_40_26 4.993426e-04
Rgh_40_26 g_40_26 g_41_26 4.993426e-04
Rgv_40_26 g_40_26 g_40_27 4.993426e-04
Rgh_40_27 g_40_27 g_41_27 4.993426e-04
Rgv_40_27 g_40_27 g_40_28 4.993426e-04
Rgh_40_28 g_40_28 g_41_28 4.993426e-04
Rgv_40_28 g_40_28 g_40_29 4.993426e-04
Rgh_40_29 g_40_29 g_41_29 4.993426e-04
Rgv_40_29 g_40_29 g_40_30 4.993426e-04
Rgh_40_30 g_40_30 g_41_30 4.993426e-04
Rgv_40_30 g_40_30 g_40_31 4.993426e-04
Rgh_40_31 g_40_31 g_41_31 4.993426e-04
Rgv_40_31 g_40_31 g_40_32 4.993426e-04
Rgh_40_32 g_40_32 g_41_32 4.993426e-04
Rgv_40_32 g_40_32 g_40_33 4.993426e-04
Rgh_40_33 g_40_33 g_41_33 4.993426e-04
Rgv_40_33 g_40_33 g_40_34 4.993426e-04
Rgh_40_34 g_40_34 g_41_34 4.993426e-04
Rgv_40_34 g_40_34 g_40_35 4.993426e-04
Rgh_40_35 g_40_35 g_41_35 4.993426e-04
Rgv_40_35 g_40_35 g_40_36 4.993426e-04
Rgh_40_36 g_40_36 g_41_36 4.993426e-04
Rgv_40_36 g_40_36 g_40_37 4.993426e-04
Rgh_40_37 g_40_37 g_41_37 4.993426e-04
Rgv_40_37 g_40_37 g_40_38 4.993426e-04
Rgh_40_38 g_40_38 g_41_38 4.993426e-04
Rgv_40_38 g_40_38 g_40_39 4.993426e-04
Rgh_40_39 g_40_39 g_41_39 4.993426e-04
Rgv_40_39 g_40_39 g_40_40 4.993426e-04
Rgh_40_40 g_40_40 g_41_40 4.993426e-04
Rgv_40_40 g_40_40 g_40_41 4.993426e-04
Rgh_40_41 g_40_41 g_41_41 4.993426e-04
Rgv_40_41 g_40_41 g_40_42 4.993426e-04
Rgh_40_42 g_40_42 g_41_42 4.993426e-04
Rgv_40_42 g_40_42 g_40_43 4.993426e-04
Rgh_40_43 g_40_43 g_41_43 4.993426e-04
Rgv_40_43 g_40_43 g_40_44 4.993426e-04
Rgh_40_44 g_40_44 g_41_44 4.993426e-04
Rgv_40_44 g_40_44 g_40_45 4.993426e-04
Rgh_40_45 g_40_45 g_41_45 4.993426e-04
Rgv_40_45 g_40_45 g_40_46 4.993426e-04
Rgh_40_46 g_40_46 g_41_46 4.993426e-04
Rgv_40_46 g_40_46 g_40_47 4.993426e-04
Rgh_40_47 g_40_47 g_41_47 4.993426e-04
Rgv_40_47 g_40_47 g_40_48 4.993426e-04
Rgh_40_48 g_40_48 g_41_48 4.993426e-04
Rgv_40_48 g_40_48 g_40_49 4.993426e-04
Rgh_40_49 g_40_49 g_41_49 4.993426e-04
Rgv_40_49 g_40_49 g_40_50 4.993426e-04
Rgh_40_50 g_40_50 g_41_50 4.993426e-04
Rgv_40_50 g_40_50 g_40_51 4.993426e-04
Rgh_40_51 g_40_51 g_41_51 4.993426e-04
Rgv_40_51 g_40_51 g_40_52 4.993426e-04
Rgh_40_52 g_40_52 g_41_52 4.993426e-04
Rgv_40_52 g_40_52 g_40_53 4.993426e-04
Rgh_40_53 g_40_53 g_41_53 4.993426e-04
Rgv_40_53 g_40_53 g_40_54 4.993426e-04
Rgh_40_54 g_40_54 g_41_54 4.993426e-04
Rgv_40_54 g_40_54 g_40_55 4.993426e-04
Rgh_40_55 g_40_55 g_41_55 4.993426e-04
Rgv_40_55 g_40_55 g_40_56 4.993426e-04
Rgh_40_56 g_40_56 g_41_56 4.993426e-04
Rgv_40_56 g_40_56 g_40_57 4.993426e-04
Rgh_40_57 g_40_57 g_41_57 4.993426e-04
Rgv_40_57 g_40_57 g_40_58 4.993426e-04
Rgh_40_58 g_40_58 g_41_58 4.993426e-04
Rgv_40_58 g_40_58 g_40_59 4.993426e-04
Rgh_40_59 g_40_59 g_41_59 4.993426e-04
Rgv_40_59 g_40_59 g_40_60 4.993426e-04
Rgh_40_60 g_40_60 g_41_60 4.993426e-04
Rgv_40_60 g_40_60 g_40_61 4.993426e-04
Rgh_40_61 g_40_61 g_41_61 4.993426e-04
Rgv_40_61 g_40_61 g_40_62 4.993426e-04
Rgh_40_62 g_40_62 g_41_62 4.993426e-04
Rgv_40_62 g_40_62 g_40_63 4.993426e-04
Rgh_40_63 g_40_63 g_41_63 4.993426e-04
Rgv_40_63 g_40_63 g_40_64 4.993426e-04
Rgh_40_64 g_40_64 g_41_64 4.993426e-04
Rgv_40_64 g_40_64 g_40_65 4.993426e-04
Rgh_40_65 g_40_65 g_41_65 4.993426e-04
Rgv_40_65 g_40_65 g_40_66 4.993426e-04
Rgh_40_66 g_40_66 g_41_66 4.993426e-04
Rgv_40_66 g_40_66 g_40_67 4.993426e-04
Rgh_40_67 g_40_67 g_41_67 4.993426e-04
Rgv_40_67 g_40_67 g_40_68 4.993426e-04
Rgh_40_68 g_40_68 g_41_68 4.993426e-04
Rgv_40_68 g_40_68 g_40_69 4.993426e-04
Rgh_40_69 g_40_69 g_41_69 4.993426e-04
Rgv_40_69 g_40_69 g_40_70 4.993426e-04
Rgh_40_70 g_40_70 g_41_70 4.993426e-04
Rgv_40_70 g_40_70 g_40_71 4.993426e-04
Rgh_40_71 g_40_71 g_41_71 4.993426e-04
Rgh_41_0 g_41_0 g_42_0 4.993426e-04
Rgv_41_0 g_41_0 g_41_1 4.993426e-04
Rgh_41_1 g_41_1 g_42_1 4.993426e-04
Rgv_41_1 g_41_1 g_41_2 4.993426e-04
Rgh_41_2 g_41_2 g_42_2 4.993426e-04
Rgv_41_2 g_41_2 g_41_3 4.993426e-04
Rgh_41_3 g_41_3 g_42_3 4.993426e-04
Rgv_41_3 g_41_3 g_41_4 4.993426e-04
Rgh_41_4 g_41_4 g_42_4 4.993426e-04
Rgv_41_4 g_41_4 g_41_5 4.993426e-04
Rgh_41_5 g_41_5 g_42_5 4.993426e-04
Rgv_41_5 g_41_5 g_41_6 4.993426e-04
Rgh_41_6 g_41_6 g_42_6 4.993426e-04
Rgv_41_6 g_41_6 g_41_7 4.993426e-04
Rgh_41_7 g_41_7 g_42_7 4.993426e-04
Rgv_41_7 g_41_7 g_41_8 4.993426e-04
Rgh_41_8 g_41_8 g_42_8 4.993426e-04
Rgv_41_8 g_41_8 g_41_9 4.993426e-04
Rgh_41_9 g_41_9 g_42_9 4.993426e-04
Rgv_41_9 g_41_9 g_41_10 4.993426e-04
Rgh_41_10 g_41_10 g_42_10 4.993426e-04
Rgv_41_10 g_41_10 g_41_11 4.993426e-04
Rgh_41_11 g_41_11 g_42_11 4.993426e-04
Rgv_41_11 g_41_11 g_41_12 4.993426e-04
Rgh_41_12 g_41_12 g_42_12 4.993426e-04
Rgv_41_12 g_41_12 g_41_13 4.993426e-04
Rgh_41_13 g_41_13 g_42_13 4.993426e-04
Rgv_41_13 g_41_13 g_41_14 4.993426e-04
Rgh_41_14 g_41_14 g_42_14 4.993426e-04
Rgv_41_14 g_41_14 g_41_15 4.993426e-04
Rgh_41_15 g_41_15 g_42_15 4.993426e-04
Rgv_41_15 g_41_15 g_41_16 4.993426e-04
Rgh_41_16 g_41_16 g_42_16 4.993426e-04
Rgv_41_16 g_41_16 g_41_17 4.993426e-04
Rgh_41_17 g_41_17 g_42_17 4.993426e-04
Rgv_41_17 g_41_17 g_41_18 4.993426e-04
Rgh_41_18 g_41_18 g_42_18 4.993426e-04
Rgv_41_18 g_41_18 g_41_19 4.993426e-04
Rgh_41_19 g_41_19 g_42_19 4.993426e-04
Rgv_41_19 g_41_19 g_41_20 4.993426e-04
Rgh_41_20 g_41_20 g_42_20 4.993426e-04
Rgv_41_20 g_41_20 g_41_21 4.993426e-04
Rgh_41_21 g_41_21 g_42_21 4.993426e-04
Rgv_41_21 g_41_21 g_41_22 4.993426e-04
Rgh_41_22 g_41_22 g_42_22 4.993426e-04
Rgv_41_22 g_41_22 g_41_23 4.993426e-04
Rgh_41_23 g_41_23 g_42_23 4.993426e-04
Rgv_41_23 g_41_23 g_41_24 4.993426e-04
Rgh_41_24 g_41_24 g_42_24 4.993426e-04
Rgv_41_24 g_41_24 g_41_25 4.993426e-04
Rgh_41_25 g_41_25 g_42_25 4.993426e-04
Rgv_41_25 g_41_25 g_41_26 4.993426e-04
Rgh_41_26 g_41_26 g_42_26 4.993426e-04
Rgv_41_26 g_41_26 g_41_27 4.993426e-04
Rgh_41_27 g_41_27 g_42_27 4.993426e-04
Rgv_41_27 g_41_27 g_41_28 4.993426e-04
Rgh_41_28 g_41_28 g_42_28 4.993426e-04
Rgv_41_28 g_41_28 g_41_29 4.993426e-04
Rgh_41_29 g_41_29 g_42_29 4.993426e-04
Rgv_41_29 g_41_29 g_41_30 4.993426e-04
Rgh_41_30 g_41_30 g_42_30 4.993426e-04
Rgv_41_30 g_41_30 g_41_31 4.993426e-04
Rgh_41_31 g_41_31 g_42_31 4.993426e-04
Rgv_41_31 g_41_31 g_41_32 4.993426e-04
Rgh_41_32 g_41_32 g_42_32 4.993426e-04
Rgv_41_32 g_41_32 g_41_33 4.993426e-04
Rgh_41_33 g_41_33 g_42_33 4.993426e-04
Rgv_41_33 g_41_33 g_41_34 4.993426e-04
Rgh_41_34 g_41_34 g_42_34 4.993426e-04
Rgv_41_34 g_41_34 g_41_35 4.993426e-04
Rgh_41_35 g_41_35 g_42_35 4.993426e-04
Rgv_41_35 g_41_35 g_41_36 4.993426e-04
Rgh_41_36 g_41_36 g_42_36 4.993426e-04
Rgv_41_36 g_41_36 g_41_37 4.993426e-04
Rgh_41_37 g_41_37 g_42_37 4.993426e-04
Rgv_41_37 g_41_37 g_41_38 4.993426e-04
Rgh_41_38 g_41_38 g_42_38 4.993426e-04
Rgv_41_38 g_41_38 g_41_39 4.993426e-04
Rgh_41_39 g_41_39 g_42_39 4.993426e-04
Rgv_41_39 g_41_39 g_41_40 4.993426e-04
Rgh_41_40 g_41_40 g_42_40 4.993426e-04
Rgv_41_40 g_41_40 g_41_41 4.993426e-04
Rgh_41_41 g_41_41 g_42_41 4.993426e-04
Rgv_41_41 g_41_41 g_41_42 4.993426e-04
Rgh_41_42 g_41_42 g_42_42 4.993426e-04
Rgv_41_42 g_41_42 g_41_43 4.993426e-04
Rgh_41_43 g_41_43 g_42_43 4.993426e-04
Rgv_41_43 g_41_43 g_41_44 4.993426e-04
Rgh_41_44 g_41_44 g_42_44 4.993426e-04
Rgv_41_44 g_41_44 g_41_45 4.993426e-04
Rgh_41_45 g_41_45 g_42_45 4.993426e-04
Rgv_41_45 g_41_45 g_41_46 4.993426e-04
Rgh_41_46 g_41_46 g_42_46 4.993426e-04
Rgv_41_46 g_41_46 g_41_47 4.993426e-04
Rgh_41_47 g_41_47 g_42_47 4.993426e-04
Rgv_41_47 g_41_47 g_41_48 4.993426e-04
Rgh_41_48 g_41_48 g_42_48 4.993426e-04
Rgv_41_48 g_41_48 g_41_49 4.993426e-04
Rgh_41_49 g_41_49 g_42_49 4.993426e-04
Rgv_41_49 g_41_49 g_41_50 4.993426e-04
Rgh_41_50 g_41_50 g_42_50 4.993426e-04
Rgv_41_50 g_41_50 g_41_51 4.993426e-04
Rgh_41_51 g_41_51 g_42_51 4.993426e-04
Rgv_41_51 g_41_51 g_41_52 4.993426e-04
Rgh_41_52 g_41_52 g_42_52 4.993426e-04
Rgv_41_52 g_41_52 g_41_53 4.993426e-04
Rgh_41_53 g_41_53 g_42_53 4.993426e-04
Rgv_41_53 g_41_53 g_41_54 4.993426e-04
Rgh_41_54 g_41_54 g_42_54 4.993426e-04
Rgv_41_54 g_41_54 g_41_55 4.993426e-04
Rgh_41_55 g_41_55 g_42_55 4.993426e-04
Rgv_41_55 g_41_55 g_41_56 4.993426e-04
Rgh_41_56 g_41_56 g_42_56 4.993426e-04
Rgv_41_56 g_41_56 g_41_57 4.993426e-04
Rgh_41_57 g_41_57 g_42_57 4.993426e-04
Rgv_41_57 g_41_57 g_41_58 4.993426e-04
Rgh_41_58 g_41_58 g_42_58 4.993426e-04
Rgv_41_58 g_41_58 g_41_59 4.993426e-04
Rgh_41_59 g_41_59 g_42_59 4.993426e-04
Rgv_41_59 g_41_59 g_41_60 4.993426e-04
Rgh_41_60 g_41_60 g_42_60 4.993426e-04
Rgv_41_60 g_41_60 g_41_61 4.993426e-04
Rgh_41_61 g_41_61 g_42_61 4.993426e-04
Rgv_41_61 g_41_61 g_41_62 4.993426e-04
Rgh_41_62 g_41_62 g_42_62 4.993426e-04
Rgv_41_62 g_41_62 g_41_63 4.993426e-04
Rgh_41_63 g_41_63 g_42_63 4.993426e-04
Rgv_41_63 g_41_63 g_41_64 4.993426e-04
Rgh_41_64 g_41_64 g_42_64 4.993426e-04
Rgv_41_64 g_41_64 g_41_65 4.993426e-04
Rgh_41_65 g_41_65 g_42_65 4.993426e-04
Rgv_41_65 g_41_65 g_41_66 4.993426e-04
Rgh_41_66 g_41_66 g_42_66 4.993426e-04
Rgv_41_66 g_41_66 g_41_67 4.993426e-04
Rgh_41_67 g_41_67 g_42_67 4.993426e-04
Rgv_41_67 g_41_67 g_41_68 4.993426e-04
Rgh_41_68 g_41_68 g_42_68 4.993426e-04
Rgv_41_68 g_41_68 g_41_69 4.993426e-04
Rgh_41_69 g_41_69 g_42_69 4.993426e-04
Rgv_41_69 g_41_69 g_41_70 4.993426e-04
Rgh_41_70 g_41_70 g_42_70 4.993426e-04
Rgv_41_70 g_41_70 g_41_71 4.993426e-04
Rgh_41_71 g_41_71 g_42_71 4.993426e-04
Rgh_42_0 g_42_0 g_43_0 4.993426e-04
Rgv_42_0 g_42_0 g_42_1 4.993426e-04
Rgh_42_1 g_42_1 g_43_1 4.993426e-04
Rgv_42_1 g_42_1 g_42_2 4.993426e-04
Rgh_42_2 g_42_2 g_43_2 4.993426e-04
Rgv_42_2 g_42_2 g_42_3 4.993426e-04
Rgh_42_3 g_42_3 g_43_3 4.993426e-04
Rgv_42_3 g_42_3 g_42_4 4.993426e-04
Rgh_42_4 g_42_4 g_43_4 4.993426e-04
Rgv_42_4 g_42_4 g_42_5 4.993426e-04
Rgh_42_5 g_42_5 g_43_5 4.993426e-04
Rgv_42_5 g_42_5 g_42_6 4.993426e-04
Rgh_42_6 g_42_6 g_43_6 4.993426e-04
Rgv_42_6 g_42_6 g_42_7 4.993426e-04
Rgh_42_7 g_42_7 g_43_7 4.993426e-04
Rgv_42_7 g_42_7 g_42_8 4.993426e-04
Rgh_42_8 g_42_8 g_43_8 4.993426e-04
Rgv_42_8 g_42_8 g_42_9 4.993426e-04
Rgh_42_9 g_42_9 g_43_9 4.993426e-04
Rgv_42_9 g_42_9 g_42_10 4.993426e-04
Rgh_42_10 g_42_10 g_43_10 4.993426e-04
Rgv_42_10 g_42_10 g_42_11 4.993426e-04
Rgh_42_11 g_42_11 g_43_11 4.993426e-04
Rgv_42_11 g_42_11 g_42_12 4.993426e-04
Rgh_42_12 g_42_12 g_43_12 4.993426e-04
Rgv_42_12 g_42_12 g_42_13 4.993426e-04
Rgh_42_13 g_42_13 g_43_13 4.993426e-04
Rgv_42_13 g_42_13 g_42_14 4.993426e-04
Rgh_42_14 g_42_14 g_43_14 4.993426e-04
Rgv_42_14 g_42_14 g_42_15 4.993426e-04
Rgh_42_15 g_42_15 g_43_15 4.993426e-04
Rgv_42_15 g_42_15 g_42_16 4.993426e-04
Rgh_42_16 g_42_16 g_43_16 4.993426e-04
Rgv_42_16 g_42_16 g_42_17 4.993426e-04
Rgh_42_17 g_42_17 g_43_17 4.993426e-04
Rgv_42_17 g_42_17 g_42_18 4.993426e-04
Rgh_42_18 g_42_18 g_43_18 4.993426e-04
Rgv_42_18 g_42_18 g_42_19 4.993426e-04
Rgh_42_19 g_42_19 g_43_19 4.993426e-04
Rgv_42_19 g_42_19 g_42_20 4.993426e-04
Rgh_42_20 g_42_20 g_43_20 4.993426e-04
Rgv_42_20 g_42_20 g_42_21 4.993426e-04
Rgh_42_21 g_42_21 g_43_21 4.993426e-04
Rgv_42_21 g_42_21 g_42_22 4.993426e-04
Rgh_42_22 g_42_22 g_43_22 4.993426e-04
Rgv_42_22 g_42_22 g_42_23 4.993426e-04
Rgh_42_23 g_42_23 g_43_23 4.993426e-04
Rgv_42_23 g_42_23 g_42_24 4.993426e-04
Rgh_42_24 g_42_24 g_43_24 4.993426e-04
Rgv_42_24 g_42_24 g_42_25 4.993426e-04
Rgh_42_25 g_42_25 g_43_25 4.993426e-04
Rgv_42_25 g_42_25 g_42_26 4.993426e-04
Rgh_42_26 g_42_26 g_43_26 4.993426e-04
Rgv_42_26 g_42_26 g_42_27 4.993426e-04
Rgh_42_27 g_42_27 g_43_27 4.993426e-04
Rgv_42_27 g_42_27 g_42_28 4.993426e-04
Rgh_42_28 g_42_28 g_43_28 4.993426e-04
Rgv_42_28 g_42_28 g_42_29 4.993426e-04
Rgh_42_29 g_42_29 g_43_29 4.993426e-04
Rgv_42_29 g_42_29 g_42_30 4.993426e-04
Rgh_42_30 g_42_30 g_43_30 4.993426e-04
Rgv_42_30 g_42_30 g_42_31 4.993426e-04
Rgh_42_31 g_42_31 g_43_31 4.993426e-04
Rgv_42_31 g_42_31 g_42_32 4.993426e-04
Rgh_42_32 g_42_32 g_43_32 4.993426e-04
Rgv_42_32 g_42_32 g_42_33 4.993426e-04
Rgh_42_33 g_42_33 g_43_33 4.993426e-04
Rgv_42_33 g_42_33 g_42_34 4.993426e-04
Rgh_42_34 g_42_34 g_43_34 4.993426e-04
Rgv_42_34 g_42_34 g_42_35 4.993426e-04
Rgh_42_35 g_42_35 g_43_35 4.993426e-04
Rgv_42_35 g_42_35 g_42_36 4.993426e-04
Rgh_42_36 g_42_36 g_43_36 4.993426e-04
Rgv_42_36 g_42_36 g_42_37 4.993426e-04
Rgh_42_37 g_42_37 g_43_37 4.993426e-04
Rgv_42_37 g_42_37 g_42_38 4.993426e-04
Rgh_42_38 g_42_38 g_43_38 4.993426e-04
Rgv_42_38 g_42_38 g_42_39 4.993426e-04
Rgh_42_39 g_42_39 g_43_39 4.993426e-04
Rgv_42_39 g_42_39 g_42_40 4.993426e-04
Rgh_42_40 g_42_40 g_43_40 4.993426e-04
Rgv_42_40 g_42_40 g_42_41 4.993426e-04
Rgh_42_41 g_42_41 g_43_41 4.993426e-04
Rgv_42_41 g_42_41 g_42_42 4.993426e-04
Rgh_42_42 g_42_42 g_43_42 4.993426e-04
Rgv_42_42 g_42_42 g_42_43 4.993426e-04
Rgh_42_43 g_42_43 g_43_43 4.993426e-04
Rgv_42_43 g_42_43 g_42_44 4.993426e-04
Rgh_42_44 g_42_44 g_43_44 4.993426e-04
Rgv_42_44 g_42_44 g_42_45 4.993426e-04
Rgh_42_45 g_42_45 g_43_45 4.993426e-04
Rgv_42_45 g_42_45 g_42_46 4.993426e-04
Rgh_42_46 g_42_46 g_43_46 4.993426e-04
Rgv_42_46 g_42_46 g_42_47 4.993426e-04
Rgh_42_47 g_42_47 g_43_47 4.993426e-04
Rgv_42_47 g_42_47 g_42_48 4.993426e-04
Rgh_42_48 g_42_48 g_43_48 4.993426e-04
Rgv_42_48 g_42_48 g_42_49 4.993426e-04
Rgh_42_49 g_42_49 g_43_49 4.993426e-04
Rgv_42_49 g_42_49 g_42_50 4.993426e-04
Rgh_42_50 g_42_50 g_43_50 4.993426e-04
Rgv_42_50 g_42_50 g_42_51 4.993426e-04
Rgh_42_51 g_42_51 g_43_51 4.993426e-04
Rgv_42_51 g_42_51 g_42_52 4.993426e-04
Rgh_42_52 g_42_52 g_43_52 4.993426e-04
Rgv_42_52 g_42_52 g_42_53 4.993426e-04
Rgh_42_53 g_42_53 g_43_53 4.993426e-04
Rgv_42_53 g_42_53 g_42_54 4.993426e-04
Rgh_42_54 g_42_54 g_43_54 4.993426e-04
Rgv_42_54 g_42_54 g_42_55 4.993426e-04
Rgh_42_55 g_42_55 g_43_55 4.993426e-04
Rgv_42_55 g_42_55 g_42_56 4.993426e-04
Rgh_42_56 g_42_56 g_43_56 4.993426e-04
Rgv_42_56 g_42_56 g_42_57 4.993426e-04
Rgh_42_57 g_42_57 g_43_57 4.993426e-04
Rgv_42_57 g_42_57 g_42_58 4.993426e-04
Rgh_42_58 g_42_58 g_43_58 4.993426e-04
Rgv_42_58 g_42_58 g_42_59 4.993426e-04
Rgh_42_59 g_42_59 g_43_59 4.993426e-04
Rgv_42_59 g_42_59 g_42_60 4.993426e-04
Rgh_42_60 g_42_60 g_43_60 4.993426e-04
Rgv_42_60 g_42_60 g_42_61 4.993426e-04
Rgh_42_61 g_42_61 g_43_61 4.993426e-04
Rgv_42_61 g_42_61 g_42_62 4.993426e-04
Rgh_42_62 g_42_62 g_43_62 4.993426e-04
Rgv_42_62 g_42_62 g_42_63 4.993426e-04
Rgh_42_63 g_42_63 g_43_63 4.993426e-04
Rgv_42_63 g_42_63 g_42_64 4.993426e-04
Rgh_42_64 g_42_64 g_43_64 4.993426e-04
Rgv_42_64 g_42_64 g_42_65 4.993426e-04
Rgh_42_65 g_42_65 g_43_65 4.993426e-04
Rgv_42_65 g_42_65 g_42_66 4.993426e-04
Rgh_42_66 g_42_66 g_43_66 4.993426e-04
Rgv_42_66 g_42_66 g_42_67 4.993426e-04
Rgh_42_67 g_42_67 g_43_67 4.993426e-04
Rgv_42_67 g_42_67 g_42_68 4.993426e-04
Rgh_42_68 g_42_68 g_43_68 4.993426e-04
Rgv_42_68 g_42_68 g_42_69 4.993426e-04
Rgh_42_69 g_42_69 g_43_69 4.993426e-04
Rgv_42_69 g_42_69 g_42_70 4.993426e-04
Rgh_42_70 g_42_70 g_43_70 4.993426e-04
Rgv_42_70 g_42_70 g_42_71 4.993426e-04
Rgh_42_71 g_42_71 g_43_71 4.993426e-04
Rgh_43_0 g_43_0 g_44_0 4.993426e-04
Rgv_43_0 g_43_0 g_43_1 4.993426e-04
Rgh_43_1 g_43_1 g_44_1 4.993426e-04
Rgv_43_1 g_43_1 g_43_2 4.993426e-04
Rgh_43_2 g_43_2 g_44_2 4.993426e-04
Rgv_43_2 g_43_2 g_43_3 4.993426e-04
Rgh_43_3 g_43_3 g_44_3 4.993426e-04
Rgv_43_3 g_43_3 g_43_4 4.993426e-04
Rgh_43_4 g_43_4 g_44_4 4.993426e-04
Rgv_43_4 g_43_4 g_43_5 4.993426e-04
Rgh_43_5 g_43_5 g_44_5 4.993426e-04
Rgv_43_5 g_43_5 g_43_6 4.993426e-04
Rgh_43_6 g_43_6 g_44_6 4.993426e-04
Rgv_43_6 g_43_6 g_43_7 4.993426e-04
Rgh_43_7 g_43_7 g_44_7 4.993426e-04
Rgv_43_7 g_43_7 g_43_8 4.993426e-04
Rgh_43_8 g_43_8 g_44_8 4.993426e-04
Rgv_43_8 g_43_8 g_43_9 4.993426e-04
Rgh_43_9 g_43_9 g_44_9 4.993426e-04
Rgv_43_9 g_43_9 g_43_10 4.993426e-04
Rgh_43_10 g_43_10 g_44_10 4.993426e-04
Rgv_43_10 g_43_10 g_43_11 4.993426e-04
Rgh_43_11 g_43_11 g_44_11 4.993426e-04
Rgv_43_11 g_43_11 g_43_12 4.993426e-04
Rgh_43_12 g_43_12 g_44_12 4.993426e-04
Rgv_43_12 g_43_12 g_43_13 4.993426e-04
Rgh_43_13 g_43_13 g_44_13 4.993426e-04
Rgv_43_13 g_43_13 g_43_14 4.993426e-04
Rgh_43_14 g_43_14 g_44_14 4.993426e-04
Rgv_43_14 g_43_14 g_43_15 4.993426e-04
Rgh_43_15 g_43_15 g_44_15 4.993426e-04
Rgv_43_15 g_43_15 g_43_16 4.993426e-04
Rgh_43_16 g_43_16 g_44_16 4.993426e-04
Rgv_43_16 g_43_16 g_43_17 4.993426e-04
Rgh_43_17 g_43_17 g_44_17 4.993426e-04
Rgv_43_17 g_43_17 g_43_18 4.993426e-04
Rgh_43_18 g_43_18 g_44_18 4.993426e-04
Rgv_43_18 g_43_18 g_43_19 4.993426e-04
Rgh_43_19 g_43_19 g_44_19 4.993426e-04
Rgv_43_19 g_43_19 g_43_20 4.993426e-04
Rgh_43_20 g_43_20 g_44_20 4.993426e-04
Rgv_43_20 g_43_20 g_43_21 4.993426e-04
Rgh_43_21 g_43_21 g_44_21 4.993426e-04
Rgv_43_21 g_43_21 g_43_22 4.993426e-04
Rgh_43_22 g_43_22 g_44_22 4.993426e-04
Rgv_43_22 g_43_22 g_43_23 4.993426e-04
Rgh_43_23 g_43_23 g_44_23 4.993426e-04
Rgv_43_23 g_43_23 g_43_24 4.993426e-04
Rgh_43_24 g_43_24 g_44_24 4.993426e-04
Rgv_43_24 g_43_24 g_43_25 4.993426e-04
Rgh_43_25 g_43_25 g_44_25 4.993426e-04
Rgv_43_25 g_43_25 g_43_26 4.993426e-04
Rgh_43_26 g_43_26 g_44_26 4.993426e-04
Rgv_43_26 g_43_26 g_43_27 4.993426e-04
Rgh_43_27 g_43_27 g_44_27 4.993426e-04
Rgv_43_27 g_43_27 g_43_28 4.993426e-04
Rgh_43_28 g_43_28 g_44_28 4.993426e-04
Rgv_43_28 g_43_28 g_43_29 4.993426e-04
Rgh_43_29 g_43_29 g_44_29 4.993426e-04
Rgv_43_29 g_43_29 g_43_30 4.993426e-04
Rgh_43_30 g_43_30 g_44_30 4.993426e-04
Rgv_43_30 g_43_30 g_43_31 4.993426e-04
Rgh_43_31 g_43_31 g_44_31 4.993426e-04
Rgv_43_31 g_43_31 g_43_32 4.993426e-04
Rgh_43_32 g_43_32 g_44_32 4.993426e-04
Rgv_43_32 g_43_32 g_43_33 4.993426e-04
Rgh_43_33 g_43_33 g_44_33 4.993426e-04
Rgv_43_33 g_43_33 g_43_34 4.993426e-04
Rgh_43_34 g_43_34 g_44_34 4.993426e-04
Rgv_43_34 g_43_34 g_43_35 4.993426e-04
Rgh_43_35 g_43_35 g_44_35 4.993426e-04
Rgv_43_35 g_43_35 g_43_36 4.993426e-04
Rgh_43_36 g_43_36 g_44_36 4.993426e-04
Rgv_43_36 g_43_36 g_43_37 4.993426e-04
Rgh_43_37 g_43_37 g_44_37 4.993426e-04
Rgv_43_37 g_43_37 g_43_38 4.993426e-04
Rgh_43_38 g_43_38 g_44_38 4.993426e-04
Rgv_43_38 g_43_38 g_43_39 4.993426e-04
Rgh_43_39 g_43_39 g_44_39 4.993426e-04
Rgv_43_39 g_43_39 g_43_40 4.993426e-04
Rgh_43_40 g_43_40 g_44_40 4.993426e-04
Rgv_43_40 g_43_40 g_43_41 4.993426e-04
Rgh_43_41 g_43_41 g_44_41 4.993426e-04
Rgv_43_41 g_43_41 g_43_42 4.993426e-04
Rgh_43_42 g_43_42 g_44_42 4.993426e-04
Rgv_43_42 g_43_42 g_43_43 4.993426e-04
Rgh_43_43 g_43_43 g_44_43 4.993426e-04
Rgv_43_43 g_43_43 g_43_44 4.993426e-04
Rgh_43_44 g_43_44 g_44_44 4.993426e-04
Rgv_43_44 g_43_44 g_43_45 4.993426e-04
Rgh_43_45 g_43_45 g_44_45 4.993426e-04
Rgv_43_45 g_43_45 g_43_46 4.993426e-04
Rgh_43_46 g_43_46 g_44_46 4.993426e-04
Rgv_43_46 g_43_46 g_43_47 4.993426e-04
Rgh_43_47 g_43_47 g_44_47 4.993426e-04
Rgv_43_47 g_43_47 g_43_48 4.993426e-04
Rgh_43_48 g_43_48 g_44_48 4.993426e-04
Rgv_43_48 g_43_48 g_43_49 4.993426e-04
Rgh_43_49 g_43_49 g_44_49 4.993426e-04
Rgv_43_49 g_43_49 g_43_50 4.993426e-04
Rgh_43_50 g_43_50 g_44_50 4.993426e-04
Rgv_43_50 g_43_50 g_43_51 4.993426e-04
Rgh_43_51 g_43_51 g_44_51 4.993426e-04
Rgv_43_51 g_43_51 g_43_52 4.993426e-04
Rgh_43_52 g_43_52 g_44_52 4.993426e-04
Rgv_43_52 g_43_52 g_43_53 4.993426e-04
Rgh_43_53 g_43_53 g_44_53 4.993426e-04
Rgv_43_53 g_43_53 g_43_54 4.993426e-04
Rgh_43_54 g_43_54 g_44_54 4.993426e-04
Rgv_43_54 g_43_54 g_43_55 4.993426e-04
Rgh_43_55 g_43_55 g_44_55 4.993426e-04
Rgv_43_55 g_43_55 g_43_56 4.993426e-04
Rgh_43_56 g_43_56 g_44_56 4.993426e-04
Rgv_43_56 g_43_56 g_43_57 4.993426e-04
Rgh_43_57 g_43_57 g_44_57 4.993426e-04
Rgv_43_57 g_43_57 g_43_58 4.993426e-04
Rgh_43_58 g_43_58 g_44_58 4.993426e-04
Rgv_43_58 g_43_58 g_43_59 4.993426e-04
Rgh_43_59 g_43_59 g_44_59 4.993426e-04
Rgv_43_59 g_43_59 g_43_60 4.993426e-04
Rgh_43_60 g_43_60 g_44_60 4.993426e-04
Rgv_43_60 g_43_60 g_43_61 4.993426e-04
Rgh_43_61 g_43_61 g_44_61 4.993426e-04
Rgv_43_61 g_43_61 g_43_62 4.993426e-04
Rgh_43_62 g_43_62 g_44_62 4.993426e-04
Rgv_43_62 g_43_62 g_43_63 4.993426e-04
Rgh_43_63 g_43_63 g_44_63 4.993426e-04
Rgv_43_63 g_43_63 g_43_64 4.993426e-04
Rgh_43_64 g_43_64 g_44_64 4.993426e-04
Rgv_43_64 g_43_64 g_43_65 4.993426e-04
Rgh_43_65 g_43_65 g_44_65 4.993426e-04
Rgv_43_65 g_43_65 g_43_66 4.993426e-04
Rgh_43_66 g_43_66 g_44_66 4.993426e-04
Rgv_43_66 g_43_66 g_43_67 4.993426e-04
Rgh_43_67 g_43_67 g_44_67 4.993426e-04
Rgv_43_67 g_43_67 g_43_68 4.993426e-04
Rgh_43_68 g_43_68 g_44_68 4.993426e-04
Rgv_43_68 g_43_68 g_43_69 4.993426e-04
Rgh_43_69 g_43_69 g_44_69 4.993426e-04
Rgv_43_69 g_43_69 g_43_70 4.993426e-04
Rgh_43_70 g_43_70 g_44_70 4.993426e-04
Rgv_43_70 g_43_70 g_43_71 4.993426e-04
Rgh_43_71 g_43_71 g_44_71 4.993426e-04
Rgh_44_0 g_44_0 g_45_0 4.993426e-04
Rgv_44_0 g_44_0 g_44_1 4.993426e-04
Rgh_44_1 g_44_1 g_45_1 4.993426e-04
Rgv_44_1 g_44_1 g_44_2 4.993426e-04
Rgh_44_2 g_44_2 g_45_2 4.993426e-04
Rgv_44_2 g_44_2 g_44_3 4.993426e-04
Rgh_44_3 g_44_3 g_45_3 4.993426e-04
Rgv_44_3 g_44_3 g_44_4 4.993426e-04
Rgh_44_4 g_44_4 g_45_4 4.993426e-04
Rgv_44_4 g_44_4 g_44_5 4.993426e-04
Rgh_44_5 g_44_5 g_45_5 4.993426e-04
Rgv_44_5 g_44_5 g_44_6 4.993426e-04
Rgh_44_6 g_44_6 g_45_6 4.993426e-04
Rgv_44_6 g_44_6 g_44_7 4.993426e-04
Rgh_44_7 g_44_7 g_45_7 4.993426e-04
Rgv_44_7 g_44_7 g_44_8 4.993426e-04
Rgh_44_8 g_44_8 g_45_8 4.993426e-04
Rgv_44_8 g_44_8 g_44_9 4.993426e-04
Rgh_44_9 g_44_9 g_45_9 4.993426e-04
Rgv_44_9 g_44_9 g_44_10 4.993426e-04
Rgh_44_10 g_44_10 g_45_10 4.993426e-04
Rgv_44_10 g_44_10 g_44_11 4.993426e-04
Rgh_44_11 g_44_11 g_45_11 4.993426e-04
Rgv_44_11 g_44_11 g_44_12 4.993426e-04
Rgh_44_12 g_44_12 g_45_12 4.993426e-04
Rgv_44_12 g_44_12 g_44_13 4.993426e-04
Rgh_44_13 g_44_13 g_45_13 4.993426e-04
Rgv_44_13 g_44_13 g_44_14 4.993426e-04
Rgh_44_14 g_44_14 g_45_14 4.993426e-04
Rgv_44_14 g_44_14 g_44_15 4.993426e-04
Rgh_44_15 g_44_15 g_45_15 4.993426e-04
Rgv_44_15 g_44_15 g_44_16 4.993426e-04
Rgh_44_16 g_44_16 g_45_16 4.993426e-04
Rgv_44_16 g_44_16 g_44_17 4.993426e-04
Rgh_44_17 g_44_17 g_45_17 4.993426e-04
Rgv_44_17 g_44_17 g_44_18 4.993426e-04
Rgh_44_18 g_44_18 g_45_18 4.993426e-04
Rgv_44_18 g_44_18 g_44_19 4.993426e-04
Rgh_44_19 g_44_19 g_45_19 4.993426e-04
Rgv_44_19 g_44_19 g_44_20 4.993426e-04
Rgh_44_20 g_44_20 g_45_20 4.993426e-04
Rgv_44_20 g_44_20 g_44_21 4.993426e-04
Rgh_44_21 g_44_21 g_45_21 4.993426e-04
Rgv_44_21 g_44_21 g_44_22 4.993426e-04
Rgh_44_22 g_44_22 g_45_22 4.993426e-04
Rgv_44_22 g_44_22 g_44_23 4.993426e-04
Rgh_44_23 g_44_23 g_45_23 4.993426e-04
Rgv_44_23 g_44_23 g_44_24 4.993426e-04
Rgh_44_24 g_44_24 g_45_24 4.993426e-04
Rgv_44_24 g_44_24 g_44_25 4.993426e-04
Rgh_44_25 g_44_25 g_45_25 4.993426e-04
Rgv_44_25 g_44_25 g_44_26 4.993426e-04
Rgh_44_26 g_44_26 g_45_26 4.993426e-04
Rgv_44_26 g_44_26 g_44_27 4.993426e-04
Rgh_44_27 g_44_27 g_45_27 4.993426e-04
Rgv_44_27 g_44_27 g_44_28 4.993426e-04
Rgh_44_28 g_44_28 g_45_28 4.993426e-04
Rgv_44_28 g_44_28 g_44_29 4.993426e-04
Rgh_44_29 g_44_29 g_45_29 4.993426e-04
Rgv_44_29 g_44_29 g_44_30 4.993426e-04
Rgh_44_30 g_44_30 g_45_30 4.993426e-04
Rgv_44_30 g_44_30 g_44_31 4.993426e-04
Rgh_44_31 g_44_31 g_45_31 4.993426e-04
Rgv_44_31 g_44_31 g_44_32 4.993426e-04
Rgh_44_32 g_44_32 g_45_32 4.993426e-04
Rgv_44_32 g_44_32 g_44_33 4.993426e-04
Rgh_44_33 g_44_33 g_45_33 4.993426e-04
Rgv_44_33 g_44_33 g_44_34 4.993426e-04
Rgh_44_34 g_44_34 g_45_34 4.993426e-04
Rgv_44_34 g_44_34 g_44_35 4.993426e-04
Rgh_44_35 g_44_35 g_45_35 4.993426e-04
Rgv_44_35 g_44_35 g_44_36 4.993426e-04
Rgh_44_36 g_44_36 g_45_36 4.993426e-04
Rgv_44_36 g_44_36 g_44_37 4.993426e-04
Rgh_44_37 g_44_37 g_45_37 4.993426e-04
Rgv_44_37 g_44_37 g_44_38 4.993426e-04
Rgh_44_38 g_44_38 g_45_38 4.993426e-04
Rgv_44_38 g_44_38 g_44_39 4.993426e-04
Rgh_44_39 g_44_39 g_45_39 4.993426e-04
Rgv_44_39 g_44_39 g_44_40 4.993426e-04
Rgh_44_40 g_44_40 g_45_40 4.993426e-04
Rgv_44_40 g_44_40 g_44_41 4.993426e-04
Rgh_44_41 g_44_41 g_45_41 4.993426e-04
Rgv_44_41 g_44_41 g_44_42 4.993426e-04
Rgh_44_42 g_44_42 g_45_42 4.993426e-04
Rgv_44_42 g_44_42 g_44_43 4.993426e-04
Rgh_44_43 g_44_43 g_45_43 4.993426e-04
Rgv_44_43 g_44_43 g_44_44 4.993426e-04
Rgh_44_44 g_44_44 g_45_44 4.993426e-04
Rgv_44_44 g_44_44 g_44_45 4.993426e-04
Rgh_44_45 g_44_45 g_45_45 4.993426e-04
Rgv_44_45 g_44_45 g_44_46 4.993426e-04
Rgh_44_46 g_44_46 g_45_46 4.993426e-04
Rgv_44_46 g_44_46 g_44_47 4.993426e-04
Rgh_44_47 g_44_47 g_45_47 4.993426e-04
Rgv_44_47 g_44_47 g_44_48 4.993426e-04
Rgh_44_48 g_44_48 g_45_48 4.993426e-04
Rgv_44_48 g_44_48 g_44_49 4.993426e-04
Rgh_44_49 g_44_49 g_45_49 4.993426e-04
Rgv_44_49 g_44_49 g_44_50 4.993426e-04
Rgh_44_50 g_44_50 g_45_50 4.993426e-04
Rgv_44_50 g_44_50 g_44_51 4.993426e-04
Rgh_44_51 g_44_51 g_45_51 4.993426e-04
Rgv_44_51 g_44_51 g_44_52 4.993426e-04
Rgh_44_52 g_44_52 g_45_52 4.993426e-04
Rgv_44_52 g_44_52 g_44_53 4.993426e-04
Rgh_44_53 g_44_53 g_45_53 4.993426e-04
Rgv_44_53 g_44_53 g_44_54 4.993426e-04
Rgh_44_54 g_44_54 g_45_54 4.993426e-04
Rgv_44_54 g_44_54 g_44_55 4.993426e-04
Rgh_44_55 g_44_55 g_45_55 4.993426e-04
Rgv_44_55 g_44_55 g_44_56 4.993426e-04
Rgh_44_56 g_44_56 g_45_56 4.993426e-04
Rgv_44_56 g_44_56 g_44_57 4.993426e-04
Rgh_44_57 g_44_57 g_45_57 4.993426e-04
Rgv_44_57 g_44_57 g_44_58 4.993426e-04
Rgh_44_58 g_44_58 g_45_58 4.993426e-04
Rgv_44_58 g_44_58 g_44_59 4.993426e-04
Rgh_44_59 g_44_59 g_45_59 4.993426e-04
Rgv_44_59 g_44_59 g_44_60 4.993426e-04
Rgh_44_60 g_44_60 g_45_60 4.993426e-04
Rgv_44_60 g_44_60 g_44_61 4.993426e-04
Rgh_44_61 g_44_61 g_45_61 4.993426e-04
Rgv_44_61 g_44_61 g_44_62 4.993426e-04
Rgh_44_62 g_44_62 g_45_62 4.993426e-04
Rgv_44_62 g_44_62 g_44_63 4.993426e-04
Rgh_44_63 g_44_63 g_45_63 4.993426e-04
Rgv_44_63 g_44_63 g_44_64 4.993426e-04
Rgh_44_64 g_44_64 g_45_64 4.993426e-04
Rgv_44_64 g_44_64 g_44_65 4.993426e-04
Rgh_44_65 g_44_65 g_45_65 4.993426e-04
Rgv_44_65 g_44_65 g_44_66 4.993426e-04
Rgh_44_66 g_44_66 g_45_66 4.993426e-04
Rgv_44_66 g_44_66 g_44_67 4.993426e-04
Rgh_44_67 g_44_67 g_45_67 4.993426e-04
Rgv_44_67 g_44_67 g_44_68 4.993426e-04
Rgh_44_68 g_44_68 g_45_68 4.993426e-04
Rgv_44_68 g_44_68 g_44_69 4.993426e-04
Rgh_44_69 g_44_69 g_45_69 4.993426e-04
Rgv_44_69 g_44_69 g_44_70 4.993426e-04
Rgh_44_70 g_44_70 g_45_70 4.993426e-04
Rgv_44_70 g_44_70 g_44_71 4.993426e-04
Rgh_44_71 g_44_71 g_45_71 4.993426e-04
Rgh_45_0 g_45_0 g_46_0 4.993426e-04
Rgv_45_0 g_45_0 g_45_1 4.993426e-04
Rgh_45_1 g_45_1 g_46_1 4.993426e-04
Rgv_45_1 g_45_1 g_45_2 4.993426e-04
Rgh_45_2 g_45_2 g_46_2 4.993426e-04
Rgv_45_2 g_45_2 g_45_3 4.993426e-04
Rgh_45_3 g_45_3 g_46_3 4.993426e-04
Rgv_45_3 g_45_3 g_45_4 4.993426e-04
Rgh_45_4 g_45_4 g_46_4 4.993426e-04
Rgv_45_4 g_45_4 g_45_5 4.993426e-04
Rgh_45_5 g_45_5 g_46_5 4.993426e-04
Rgv_45_5 g_45_5 g_45_6 4.993426e-04
Rgh_45_6 g_45_6 g_46_6 4.993426e-04
Rgv_45_6 g_45_6 g_45_7 4.993426e-04
Rgh_45_7 g_45_7 g_46_7 4.993426e-04
Rgv_45_7 g_45_7 g_45_8 4.993426e-04
Rgh_45_8 g_45_8 g_46_8 4.993426e-04
Rgv_45_8 g_45_8 g_45_9 4.993426e-04
Rgh_45_9 g_45_9 g_46_9 4.993426e-04
Rgv_45_9 g_45_9 g_45_10 4.993426e-04
Rgh_45_10 g_45_10 g_46_10 4.993426e-04
Rgv_45_10 g_45_10 g_45_11 4.993426e-04
Rgh_45_11 g_45_11 g_46_11 4.993426e-04
Rgv_45_11 g_45_11 g_45_12 4.993426e-04
Rgh_45_12 g_45_12 g_46_12 4.993426e-04
Rgv_45_12 g_45_12 g_45_13 4.993426e-04
Rgh_45_13 g_45_13 g_46_13 4.993426e-04
Rgv_45_13 g_45_13 g_45_14 4.993426e-04
Rgh_45_14 g_45_14 g_46_14 4.993426e-04
Rgv_45_14 g_45_14 g_45_15 4.993426e-04
Rgh_45_15 g_45_15 g_46_15 4.993426e-04
Rgv_45_15 g_45_15 g_45_16 4.993426e-04
Rgh_45_16 g_45_16 g_46_16 4.993426e-04
Rgv_45_16 g_45_16 g_45_17 4.993426e-04
Rgh_45_17 g_45_17 g_46_17 4.993426e-04
Rgv_45_17 g_45_17 g_45_18 4.993426e-04
Rgh_45_18 g_45_18 g_46_18 4.993426e-04
Rgv_45_18 g_45_18 g_45_19 4.993426e-04
Rgh_45_19 g_45_19 g_46_19 4.993426e-04
Rgv_45_19 g_45_19 g_45_20 4.993426e-04
Rgh_45_20 g_45_20 g_46_20 4.993426e-04
Rgv_45_20 g_45_20 g_45_21 4.993426e-04
Rgh_45_21 g_45_21 g_46_21 4.993426e-04
Rgv_45_21 g_45_21 g_45_22 4.993426e-04
Rgh_45_22 g_45_22 g_46_22 4.993426e-04
Rgv_45_22 g_45_22 g_45_23 4.993426e-04
Rgh_45_23 g_45_23 g_46_23 4.993426e-04
Rgv_45_23 g_45_23 g_45_24 4.993426e-04
Rgh_45_24 g_45_24 g_46_24 4.993426e-04
Rgv_45_24 g_45_24 g_45_25 4.993426e-04
Rgh_45_25 g_45_25 g_46_25 4.993426e-04
Rgv_45_25 g_45_25 g_45_26 4.993426e-04
Rgh_45_26 g_45_26 g_46_26 4.993426e-04
Rgv_45_26 g_45_26 g_45_27 4.993426e-04
Rgh_45_27 g_45_27 g_46_27 4.993426e-04
Rgv_45_27 g_45_27 g_45_28 4.993426e-04
Rgh_45_28 g_45_28 g_46_28 4.993426e-04
Rgv_45_28 g_45_28 g_45_29 4.993426e-04
Rgh_45_29 g_45_29 g_46_29 4.993426e-04
Rgv_45_29 g_45_29 g_45_30 4.993426e-04
Rgh_45_30 g_45_30 g_46_30 4.993426e-04
Rgv_45_30 g_45_30 g_45_31 4.993426e-04
Rgh_45_31 g_45_31 g_46_31 4.993426e-04
Rgv_45_31 g_45_31 g_45_32 4.993426e-04
Rgh_45_32 g_45_32 g_46_32 4.993426e-04
Rgv_45_32 g_45_32 g_45_33 4.993426e-04
Rgh_45_33 g_45_33 g_46_33 4.993426e-04
Rgv_45_33 g_45_33 g_45_34 4.993426e-04
Rgh_45_34 g_45_34 g_46_34 4.993426e-04
Rgv_45_34 g_45_34 g_45_35 4.993426e-04
Rgh_45_35 g_45_35 g_46_35 4.993426e-04
Rgv_45_35 g_45_35 g_45_36 4.993426e-04
Rgh_45_36 g_45_36 g_46_36 4.993426e-04
Rgv_45_36 g_45_36 g_45_37 4.993426e-04
Rgh_45_37 g_45_37 g_46_37 4.993426e-04
Rgv_45_37 g_45_37 g_45_38 4.993426e-04
Rgh_45_38 g_45_38 g_46_38 4.993426e-04
Rgv_45_38 g_45_38 g_45_39 4.993426e-04
Rgh_45_39 g_45_39 g_46_39 4.993426e-04
Rgv_45_39 g_45_39 g_45_40 4.993426e-04
Rgh_45_40 g_45_40 g_46_40 4.993426e-04
Rgv_45_40 g_45_40 g_45_41 4.993426e-04
Rgh_45_41 g_45_41 g_46_41 4.993426e-04
Rgv_45_41 g_45_41 g_45_42 4.993426e-04
Rgh_45_42 g_45_42 g_46_42 4.993426e-04
Rgv_45_42 g_45_42 g_45_43 4.993426e-04
Rgh_45_43 g_45_43 g_46_43 4.993426e-04
Rgv_45_43 g_45_43 g_45_44 4.993426e-04
Rgh_45_44 g_45_44 g_46_44 4.993426e-04
Rgv_45_44 g_45_44 g_45_45 4.993426e-04
Rgh_45_45 g_45_45 g_46_45 4.993426e-04
Rgv_45_45 g_45_45 g_45_46 4.993426e-04
Rgh_45_46 g_45_46 g_46_46 4.993426e-04
Rgv_45_46 g_45_46 g_45_47 4.993426e-04
Rgh_45_47 g_45_47 g_46_47 4.993426e-04
Rgv_45_47 g_45_47 g_45_48 4.993426e-04
Rgh_45_48 g_45_48 g_46_48 4.993426e-04
Rgv_45_48 g_45_48 g_45_49 4.993426e-04
Rgh_45_49 g_45_49 g_46_49 4.993426e-04
Rgv_45_49 g_45_49 g_45_50 4.993426e-04
Rgh_45_50 g_45_50 g_46_50 4.993426e-04
Rgv_45_50 g_45_50 g_45_51 4.993426e-04
Rgh_45_51 g_45_51 g_46_51 4.993426e-04
Rgv_45_51 g_45_51 g_45_52 4.993426e-04
Rgh_45_52 g_45_52 g_46_52 4.993426e-04
Rgv_45_52 g_45_52 g_45_53 4.993426e-04
Rgh_45_53 g_45_53 g_46_53 4.993426e-04
Rgv_45_53 g_45_53 g_45_54 4.993426e-04
Rgh_45_54 g_45_54 g_46_54 4.993426e-04
Rgv_45_54 g_45_54 g_45_55 4.993426e-04
Rgh_45_55 g_45_55 g_46_55 4.993426e-04
Rgv_45_55 g_45_55 g_45_56 4.993426e-04
Rgh_45_56 g_45_56 g_46_56 4.993426e-04
Rgv_45_56 g_45_56 g_45_57 4.993426e-04
Rgh_45_57 g_45_57 g_46_57 4.993426e-04
Rgv_45_57 g_45_57 g_45_58 4.993426e-04
Rgh_45_58 g_45_58 g_46_58 4.993426e-04
Rgv_45_58 g_45_58 g_45_59 4.993426e-04
Rgh_45_59 g_45_59 g_46_59 4.993426e-04
Rgv_45_59 g_45_59 g_45_60 4.993426e-04
Rgh_45_60 g_45_60 g_46_60 4.993426e-04
Rgv_45_60 g_45_60 g_45_61 4.993426e-04
Rgh_45_61 g_45_61 g_46_61 4.993426e-04
Rgv_45_61 g_45_61 g_45_62 4.993426e-04
Rgh_45_62 g_45_62 g_46_62 4.993426e-04
Rgv_45_62 g_45_62 g_45_63 4.993426e-04
Rgh_45_63 g_45_63 g_46_63 4.993426e-04
Rgv_45_63 g_45_63 g_45_64 4.993426e-04
Rgh_45_64 g_45_64 g_46_64 4.993426e-04
Rgv_45_64 g_45_64 g_45_65 4.993426e-04
Rgh_45_65 g_45_65 g_46_65 4.993426e-04
Rgv_45_65 g_45_65 g_45_66 4.993426e-04
Rgh_45_66 g_45_66 g_46_66 4.993426e-04
Rgv_45_66 g_45_66 g_45_67 4.993426e-04
Rgh_45_67 g_45_67 g_46_67 4.993426e-04
Rgv_45_67 g_45_67 g_45_68 4.993426e-04
Rgh_45_68 g_45_68 g_46_68 4.993426e-04
Rgv_45_68 g_45_68 g_45_69 4.993426e-04
Rgh_45_69 g_45_69 g_46_69 4.993426e-04
Rgv_45_69 g_45_69 g_45_70 4.993426e-04
Rgh_45_70 g_45_70 g_46_70 4.993426e-04
Rgv_45_70 g_45_70 g_45_71 4.993426e-04
Rgh_45_71 g_45_71 g_46_71 4.993426e-04
Rgh_46_0 g_46_0 g_47_0 4.993426e-04
Rgv_46_0 g_46_0 g_46_1 4.993426e-04
Rgh_46_1 g_46_1 g_47_1 4.993426e-04
Rgv_46_1 g_46_1 g_46_2 4.993426e-04
Rgh_46_2 g_46_2 g_47_2 4.993426e-04
Rgv_46_2 g_46_2 g_46_3 4.993426e-04
Rgh_46_3 g_46_3 g_47_3 4.993426e-04
Rgv_46_3 g_46_3 g_46_4 4.993426e-04
Rgh_46_4 g_46_4 g_47_4 4.993426e-04
Rgv_46_4 g_46_4 g_46_5 4.993426e-04
Rgh_46_5 g_46_5 g_47_5 4.993426e-04
Rgv_46_5 g_46_5 g_46_6 4.993426e-04
Rgh_46_6 g_46_6 g_47_6 4.993426e-04
Rgv_46_6 g_46_6 g_46_7 4.993426e-04
Rgh_46_7 g_46_7 g_47_7 4.993426e-04
Rgv_46_7 g_46_7 g_46_8 4.993426e-04
Rgh_46_8 g_46_8 g_47_8 4.993426e-04
Rgv_46_8 g_46_8 g_46_9 4.993426e-04
Rgh_46_9 g_46_9 g_47_9 4.993426e-04
Rgv_46_9 g_46_9 g_46_10 4.993426e-04
Rgh_46_10 g_46_10 g_47_10 4.993426e-04
Rgv_46_10 g_46_10 g_46_11 4.993426e-04
Rgh_46_11 g_46_11 g_47_11 4.993426e-04
Rgv_46_11 g_46_11 g_46_12 4.993426e-04
Rgh_46_12 g_46_12 g_47_12 4.993426e-04
Rgv_46_12 g_46_12 g_46_13 4.993426e-04
Rgh_46_13 g_46_13 g_47_13 4.993426e-04
Rgv_46_13 g_46_13 g_46_14 4.993426e-04
Rgh_46_14 g_46_14 g_47_14 4.993426e-04
Rgv_46_14 g_46_14 g_46_15 4.993426e-04
Rgh_46_15 g_46_15 g_47_15 4.993426e-04
Rgv_46_15 g_46_15 g_46_16 4.993426e-04
Rgh_46_16 g_46_16 g_47_16 4.993426e-04
Rgv_46_16 g_46_16 g_46_17 4.993426e-04
Rgh_46_17 g_46_17 g_47_17 4.993426e-04
Rgv_46_17 g_46_17 g_46_18 4.993426e-04
Rgh_46_18 g_46_18 g_47_18 4.993426e-04
Rgv_46_18 g_46_18 g_46_19 4.993426e-04
Rgh_46_19 g_46_19 g_47_19 4.993426e-04
Rgv_46_19 g_46_19 g_46_20 4.993426e-04
Rgh_46_20 g_46_20 g_47_20 4.993426e-04
Rgv_46_20 g_46_20 g_46_21 4.993426e-04
Rgh_46_21 g_46_21 g_47_21 4.993426e-04
Rgv_46_21 g_46_21 g_46_22 4.993426e-04
Rgh_46_22 g_46_22 g_47_22 4.993426e-04
Rgv_46_22 g_46_22 g_46_23 4.993426e-04
Rgh_46_23 g_46_23 g_47_23 4.993426e-04
Rgv_46_23 g_46_23 g_46_24 4.993426e-04
Rgh_46_24 g_46_24 g_47_24 4.993426e-04
Rgv_46_24 g_46_24 g_46_25 4.993426e-04
Rgh_46_25 g_46_25 g_47_25 4.993426e-04
Rgv_46_25 g_46_25 g_46_26 4.993426e-04
Rgh_46_26 g_46_26 g_47_26 4.993426e-04
Rgv_46_26 g_46_26 g_46_27 4.993426e-04
Rgh_46_27 g_46_27 g_47_27 4.993426e-04
Rgv_46_27 g_46_27 g_46_28 4.993426e-04
Rgh_46_28 g_46_28 g_47_28 4.993426e-04
Rgv_46_28 g_46_28 g_46_29 4.993426e-04
Rgh_46_29 g_46_29 g_47_29 4.993426e-04
Rgv_46_29 g_46_29 g_46_30 4.993426e-04
Rgh_46_30 g_46_30 g_47_30 4.993426e-04
Rgv_46_30 g_46_30 g_46_31 4.993426e-04
Rgh_46_31 g_46_31 g_47_31 4.993426e-04
Rgv_46_31 g_46_31 g_46_32 4.993426e-04
Rgh_46_32 g_46_32 g_47_32 4.993426e-04
Rgv_46_32 g_46_32 g_46_33 4.993426e-04
Rgh_46_33 g_46_33 g_47_33 4.993426e-04
Rgv_46_33 g_46_33 g_46_34 4.993426e-04
Rgh_46_34 g_46_34 g_47_34 4.993426e-04
Rgv_46_34 g_46_34 g_46_35 4.993426e-04
Rgh_46_35 g_46_35 g_47_35 4.993426e-04
Rgv_46_35 g_46_35 g_46_36 4.993426e-04
Rgh_46_36 g_46_36 g_47_36 4.993426e-04
Rgv_46_36 g_46_36 g_46_37 4.993426e-04
Rgh_46_37 g_46_37 g_47_37 4.993426e-04
Rgv_46_37 g_46_37 g_46_38 4.993426e-04
Rgh_46_38 g_46_38 g_47_38 4.993426e-04
Rgv_46_38 g_46_38 g_46_39 4.993426e-04
Rgh_46_39 g_46_39 g_47_39 4.993426e-04
Rgv_46_39 g_46_39 g_46_40 4.993426e-04
Rgh_46_40 g_46_40 g_47_40 4.993426e-04
Rgv_46_40 g_46_40 g_46_41 4.993426e-04
Rgh_46_41 g_46_41 g_47_41 4.993426e-04
Rgv_46_41 g_46_41 g_46_42 4.993426e-04
Rgh_46_42 g_46_42 g_47_42 4.993426e-04
Rgv_46_42 g_46_42 g_46_43 4.993426e-04
Rgh_46_43 g_46_43 g_47_43 4.993426e-04
Rgv_46_43 g_46_43 g_46_44 4.993426e-04
Rgh_46_44 g_46_44 g_47_44 4.993426e-04
Rgv_46_44 g_46_44 g_46_45 4.993426e-04
Rgh_46_45 g_46_45 g_47_45 4.993426e-04
Rgv_46_45 g_46_45 g_46_46 4.993426e-04
Rgh_46_46 g_46_46 g_47_46 4.993426e-04
Rgv_46_46 g_46_46 g_46_47 4.993426e-04
Rgh_46_47 g_46_47 g_47_47 4.993426e-04
Rgv_46_47 g_46_47 g_46_48 4.993426e-04
Rgh_46_48 g_46_48 g_47_48 4.993426e-04
Rgv_46_48 g_46_48 g_46_49 4.993426e-04
Rgh_46_49 g_46_49 g_47_49 4.993426e-04
Rgv_46_49 g_46_49 g_46_50 4.993426e-04
Rgh_46_50 g_46_50 g_47_50 4.993426e-04
Rgv_46_50 g_46_50 g_46_51 4.993426e-04
Rgh_46_51 g_46_51 g_47_51 4.993426e-04
Rgv_46_51 g_46_51 g_46_52 4.993426e-04
Rgh_46_52 g_46_52 g_47_52 4.993426e-04
Rgv_46_52 g_46_52 g_46_53 4.993426e-04
Rgh_46_53 g_46_53 g_47_53 4.993426e-04
Rgv_46_53 g_46_53 g_46_54 4.993426e-04
Rgh_46_54 g_46_54 g_47_54 4.993426e-04
Rgv_46_54 g_46_54 g_46_55 4.993426e-04
Rgh_46_55 g_46_55 g_47_55 4.993426e-04
Rgv_46_55 g_46_55 g_46_56 4.993426e-04
Rgh_46_56 g_46_56 g_47_56 4.993426e-04
Rgv_46_56 g_46_56 g_46_57 4.993426e-04
Rgh_46_57 g_46_57 g_47_57 4.993426e-04
Rgv_46_57 g_46_57 g_46_58 4.993426e-04
Rgh_46_58 g_46_58 g_47_58 4.993426e-04
Rgv_46_58 g_46_58 g_46_59 4.993426e-04
Rgh_46_59 g_46_59 g_47_59 4.993426e-04
Rgv_46_59 g_46_59 g_46_60 4.993426e-04
Rgh_46_60 g_46_60 g_47_60 4.993426e-04
Rgv_46_60 g_46_60 g_46_61 4.993426e-04
Rgh_46_61 g_46_61 g_47_61 4.993426e-04
Rgv_46_61 g_46_61 g_46_62 4.993426e-04
Rgh_46_62 g_46_62 g_47_62 4.993426e-04
Rgv_46_62 g_46_62 g_46_63 4.993426e-04
Rgh_46_63 g_46_63 g_47_63 4.993426e-04
Rgv_46_63 g_46_63 g_46_64 4.993426e-04
Rgh_46_64 g_46_64 g_47_64 4.993426e-04
Rgv_46_64 g_46_64 g_46_65 4.993426e-04
Rgh_46_65 g_46_65 g_47_65 4.993426e-04
Rgv_46_65 g_46_65 g_46_66 4.993426e-04
Rgh_46_66 g_46_66 g_47_66 4.993426e-04
Rgv_46_66 g_46_66 g_46_67 4.993426e-04
Rgh_46_67 g_46_67 g_47_67 4.993426e-04
Rgv_46_67 g_46_67 g_46_68 4.993426e-04
Rgh_46_68 g_46_68 g_47_68 4.993426e-04
Rgv_46_68 g_46_68 g_46_69 4.993426e-04
Rgh_46_69 g_46_69 g_47_69 4.993426e-04
Rgv_46_69 g_46_69 g_46_70 4.993426e-04
Rgh_46_70 g_46_70 g_47_70 4.993426e-04
Rgv_46_70 g_46_70 g_46_71 4.993426e-04
Rgh_46_71 g_46_71 g_47_71 4.993426e-04
Rgh_47_0 g_47_0 g_48_0 4.993426e-04
Rgv_47_0 g_47_0 g_47_1 4.993426e-04
Rgh_47_1 g_47_1 g_48_1 4.993426e-04
Rgv_47_1 g_47_1 g_47_2 4.993426e-04
Rgh_47_2 g_47_2 g_48_2 4.993426e-04
Rgv_47_2 g_47_2 g_47_3 4.993426e-04
Rgh_47_3 g_47_3 g_48_3 4.993426e-04
Rgv_47_3 g_47_3 g_47_4 4.993426e-04
Rgh_47_4 g_47_4 g_48_4 4.993426e-04
Rgv_47_4 g_47_4 g_47_5 4.993426e-04
Rgh_47_5 g_47_5 g_48_5 4.993426e-04
Rgv_47_5 g_47_5 g_47_6 4.993426e-04
Rgh_47_6 g_47_6 g_48_6 4.993426e-04
Rgv_47_6 g_47_6 g_47_7 4.993426e-04
Rgh_47_7 g_47_7 g_48_7 4.993426e-04
Rgv_47_7 g_47_7 g_47_8 4.993426e-04
Rgh_47_8 g_47_8 g_48_8 4.993426e-04
Rgv_47_8 g_47_8 g_47_9 4.993426e-04
Rgh_47_9 g_47_9 g_48_9 4.993426e-04
Rgv_47_9 g_47_9 g_47_10 4.993426e-04
Rgh_47_10 g_47_10 g_48_10 4.993426e-04
Rgv_47_10 g_47_10 g_47_11 4.993426e-04
Rgh_47_11 g_47_11 g_48_11 4.993426e-04
Rgv_47_11 g_47_11 g_47_12 4.993426e-04
Rgh_47_12 g_47_12 g_48_12 4.993426e-04
Rgv_47_12 g_47_12 g_47_13 4.993426e-04
Rgh_47_13 g_47_13 g_48_13 4.993426e-04
Rgv_47_13 g_47_13 g_47_14 4.993426e-04
Rgh_47_14 g_47_14 g_48_14 4.993426e-04
Rgv_47_14 g_47_14 g_47_15 4.993426e-04
Rgh_47_15 g_47_15 g_48_15 4.993426e-04
Rgv_47_15 g_47_15 g_47_16 4.993426e-04
Rgh_47_16 g_47_16 g_48_16 4.993426e-04
Rgv_47_16 g_47_16 g_47_17 4.993426e-04
Rgh_47_17 g_47_17 g_48_17 4.993426e-04
Rgv_47_17 g_47_17 g_47_18 4.993426e-04
Rgh_47_18 g_47_18 g_48_18 4.993426e-04
Rgv_47_18 g_47_18 g_47_19 4.993426e-04
Rgh_47_19 g_47_19 g_48_19 4.993426e-04
Rgv_47_19 g_47_19 g_47_20 4.993426e-04
Rgh_47_20 g_47_20 g_48_20 4.993426e-04
Rgv_47_20 g_47_20 g_47_21 4.993426e-04
Rgh_47_21 g_47_21 g_48_21 4.993426e-04
Rgv_47_21 g_47_21 g_47_22 4.993426e-04
Rgh_47_22 g_47_22 g_48_22 4.993426e-04
Rgv_47_22 g_47_22 g_47_23 4.993426e-04
Rgh_47_23 g_47_23 g_48_23 4.993426e-04
Rgv_47_23 g_47_23 g_47_24 4.993426e-04
Rgh_47_24 g_47_24 g_48_24 4.993426e-04
Rgv_47_24 g_47_24 g_47_25 4.993426e-04
Rgh_47_25 g_47_25 g_48_25 4.993426e-04
Rgv_47_25 g_47_25 g_47_26 4.993426e-04
Rgh_47_26 g_47_26 g_48_26 4.993426e-04
Rgv_47_26 g_47_26 g_47_27 4.993426e-04
Rgh_47_27 g_47_27 g_48_27 4.993426e-04
Rgv_47_27 g_47_27 g_47_28 4.993426e-04
Rgh_47_28 g_47_28 g_48_28 4.993426e-04
Rgv_47_28 g_47_28 g_47_29 4.993426e-04
Rgh_47_29 g_47_29 g_48_29 4.993426e-04
Rgv_47_29 g_47_29 g_47_30 4.993426e-04
Rgh_47_30 g_47_30 g_48_30 4.993426e-04
Rgv_47_30 g_47_30 g_47_31 4.993426e-04
Rgh_47_31 g_47_31 g_48_31 4.993426e-04
Rgv_47_31 g_47_31 g_47_32 4.993426e-04
Rgh_47_32 g_47_32 g_48_32 4.993426e-04
Rgv_47_32 g_47_32 g_47_33 4.993426e-04
Rgh_47_33 g_47_33 g_48_33 4.993426e-04
Rgv_47_33 g_47_33 g_47_34 4.993426e-04
Rgh_47_34 g_47_34 g_48_34 4.993426e-04
Rgv_47_34 g_47_34 g_47_35 4.993426e-04
Rgh_47_35 g_47_35 g_48_35 4.993426e-04
Rgv_47_35 g_47_35 g_47_36 4.993426e-04
Rgh_47_36 g_47_36 g_48_36 4.993426e-04
Rgv_47_36 g_47_36 g_47_37 4.993426e-04
Rgh_47_37 g_47_37 g_48_37 4.993426e-04
Rgv_47_37 g_47_37 g_47_38 4.993426e-04
Rgh_47_38 g_47_38 g_48_38 4.993426e-04
Rgv_47_38 g_47_38 g_47_39 4.993426e-04
Rgh_47_39 g_47_39 g_48_39 4.993426e-04
Rgv_47_39 g_47_39 g_47_40 4.993426e-04
Rgh_47_40 g_47_40 g_48_40 4.993426e-04
Rgv_47_40 g_47_40 g_47_41 4.993426e-04
Rgh_47_41 g_47_41 g_48_41 4.993426e-04
Rgv_47_41 g_47_41 g_47_42 4.993426e-04
Rgh_47_42 g_47_42 g_48_42 4.993426e-04
Rgv_47_42 g_47_42 g_47_43 4.993426e-04
Rgh_47_43 g_47_43 g_48_43 4.993426e-04
Rgv_47_43 g_47_43 g_47_44 4.993426e-04
Rgh_47_44 g_47_44 g_48_44 4.993426e-04
Rgv_47_44 g_47_44 g_47_45 4.993426e-04
Rgh_47_45 g_47_45 g_48_45 4.993426e-04
Rgv_47_45 g_47_45 g_47_46 4.993426e-04
Rgh_47_46 g_47_46 g_48_46 4.993426e-04
Rgv_47_46 g_47_46 g_47_47 4.993426e-04
Rgh_47_47 g_47_47 g_48_47 4.993426e-04
Rgv_47_47 g_47_47 g_47_48 4.993426e-04
Rgh_47_48 g_47_48 g_48_48 4.993426e-04
Rgv_47_48 g_47_48 g_47_49 4.993426e-04
Rgh_47_49 g_47_49 g_48_49 4.993426e-04
Rgv_47_49 g_47_49 g_47_50 4.993426e-04
Rgh_47_50 g_47_50 g_48_50 4.993426e-04
Rgv_47_50 g_47_50 g_47_51 4.993426e-04
Rgh_47_51 g_47_51 g_48_51 4.993426e-04
Rgv_47_51 g_47_51 g_47_52 4.993426e-04
Rgh_47_52 g_47_52 g_48_52 4.993426e-04
Rgv_47_52 g_47_52 g_47_53 4.993426e-04
Rgh_47_53 g_47_53 g_48_53 4.993426e-04
Rgv_47_53 g_47_53 g_47_54 4.993426e-04
Rgh_47_54 g_47_54 g_48_54 4.993426e-04
Rgv_47_54 g_47_54 g_47_55 4.993426e-04
Rgh_47_55 g_47_55 g_48_55 4.993426e-04
Rgv_47_55 g_47_55 g_47_56 4.993426e-04
Rgh_47_56 g_47_56 g_48_56 4.993426e-04
Rgv_47_56 g_47_56 g_47_57 4.993426e-04
Rgh_47_57 g_47_57 g_48_57 4.993426e-04
Rgv_47_57 g_47_57 g_47_58 4.993426e-04
Rgh_47_58 g_47_58 g_48_58 4.993426e-04
Rgv_47_58 g_47_58 g_47_59 4.993426e-04
Rgh_47_59 g_47_59 g_48_59 4.993426e-04
Rgv_47_59 g_47_59 g_47_60 4.993426e-04
Rgh_47_60 g_47_60 g_48_60 4.993426e-04
Rgv_47_60 g_47_60 g_47_61 4.993426e-04
Rgh_47_61 g_47_61 g_48_61 4.993426e-04
Rgv_47_61 g_47_61 g_47_62 4.993426e-04
Rgh_47_62 g_47_62 g_48_62 4.993426e-04
Rgv_47_62 g_47_62 g_47_63 4.993426e-04
Rgh_47_63 g_47_63 g_48_63 4.993426e-04
Rgv_47_63 g_47_63 g_47_64 4.993426e-04
Rgh_47_64 g_47_64 g_48_64 4.993426e-04
Rgv_47_64 g_47_64 g_47_65 4.993426e-04
Rgh_47_65 g_47_65 g_48_65 4.993426e-04
Rgv_47_65 g_47_65 g_47_66 4.993426e-04
Rgh_47_66 g_47_66 g_48_66 4.993426e-04
Rgv_47_66 g_47_66 g_47_67 4.993426e-04
Rgh_47_67 g_47_67 g_48_67 4.993426e-04
Rgv_47_67 g_47_67 g_47_68 4.993426e-04
Rgh_47_68 g_47_68 g_48_68 4.993426e-04
Rgv_47_68 g_47_68 g_47_69 4.993426e-04
Rgh_47_69 g_47_69 g_48_69 4.993426e-04
Rgv_47_69 g_47_69 g_47_70 4.993426e-04
Rgh_47_70 g_47_70 g_48_70 4.993426e-04
Rgv_47_70 g_47_70 g_47_71 4.993426e-04
Rgh_47_71 g_47_71 g_48_71 4.993426e-04
Rgh_48_0 g_48_0 g_49_0 4.993426e-04
Rgv_48_0 g_48_0 g_48_1 4.993426e-04
Rgh_48_1 g_48_1 g_49_1 4.993426e-04
Rgv_48_1 g_48_1 g_48_2 4.993426e-04
Rgh_48_2 g_48_2 g_49_2 4.993426e-04
Rgv_48_2 g_48_2 g_48_3 4.993426e-04
Rgh_48_3 g_48_3 g_49_3 4.993426e-04
Rgv_48_3 g_48_3 g_48_4 4.993426e-04
Rgh_48_4 g_48_4 g_49_4 4.993426e-04
Rgv_48_4 g_48_4 g_48_5 4.993426e-04
Rgh_48_5 g_48_5 g_49_5 4.993426e-04
Rgv_48_5 g_48_5 g_48_6 4.993426e-04
Rgh_48_6 g_48_6 g_49_6 4.993426e-04
Rgv_48_6 g_48_6 g_48_7 4.993426e-04
Rgh_48_7 g_48_7 g_49_7 4.993426e-04
Rgv_48_7 g_48_7 g_48_8 4.993426e-04
Rgh_48_8 g_48_8 g_49_8 4.993426e-04
Rgv_48_8 g_48_8 g_48_9 4.993426e-04
Rgh_48_9 g_48_9 g_49_9 4.993426e-04
Rgv_48_9 g_48_9 g_48_10 4.993426e-04
Rgh_48_10 g_48_10 g_49_10 4.993426e-04
Rgv_48_10 g_48_10 g_48_11 4.993426e-04
Rgh_48_11 g_48_11 g_49_11 4.993426e-04
Rgv_48_11 g_48_11 g_48_12 4.993426e-04
Rgh_48_12 g_48_12 g_49_12 4.993426e-04
Rgv_48_12 g_48_12 g_48_13 4.993426e-04
Rgh_48_13 g_48_13 g_49_13 4.993426e-04
Rgv_48_13 g_48_13 g_48_14 4.993426e-04
Rgh_48_14 g_48_14 g_49_14 4.993426e-04
Rgv_48_14 g_48_14 g_48_15 4.993426e-04
Rgh_48_15 g_48_15 g_49_15 4.993426e-04
Rgv_48_15 g_48_15 g_48_16 4.993426e-04
Rgh_48_16 g_48_16 g_49_16 4.993426e-04
Rgv_48_16 g_48_16 g_48_17 4.993426e-04
Rgh_48_17 g_48_17 g_49_17 4.993426e-04
Rgv_48_17 g_48_17 g_48_18 4.993426e-04
Rgh_48_18 g_48_18 g_49_18 4.993426e-04
Rgv_48_18 g_48_18 g_48_19 4.993426e-04
Rgh_48_19 g_48_19 g_49_19 4.993426e-04
Rgv_48_19 g_48_19 g_48_20 4.993426e-04
Rgh_48_20 g_48_20 g_49_20 4.993426e-04
Rgv_48_20 g_48_20 g_48_21 4.993426e-04
Rgh_48_21 g_48_21 g_49_21 4.993426e-04
Rgv_48_21 g_48_21 g_48_22 4.993426e-04
Rgh_48_22 g_48_22 g_49_22 4.993426e-04
Rgv_48_22 g_48_22 g_48_23 4.993426e-04
Rgh_48_23 g_48_23 g_49_23 4.993426e-04
Rgv_48_23 g_48_23 g_48_24 4.993426e-04
Rgh_48_24 g_48_24 g_49_24 4.993426e-04
Rgv_48_24 g_48_24 g_48_25 4.993426e-04
Rgh_48_25 g_48_25 g_49_25 4.993426e-04
Rgv_48_25 g_48_25 g_48_26 4.993426e-04
Rgh_48_26 g_48_26 g_49_26 4.993426e-04
Rgv_48_26 g_48_26 g_48_27 4.993426e-04
Rgh_48_27 g_48_27 g_49_27 4.993426e-04
Rgv_48_27 g_48_27 g_48_28 4.993426e-04
Rgh_48_28 g_48_28 g_49_28 4.993426e-04
Rgv_48_28 g_48_28 g_48_29 4.993426e-04
Rgh_48_29 g_48_29 g_49_29 4.993426e-04
Rgv_48_29 g_48_29 g_48_30 4.993426e-04
Rgh_48_30 g_48_30 g_49_30 4.993426e-04
Rgv_48_30 g_48_30 g_48_31 4.993426e-04
Rgh_48_31 g_48_31 g_49_31 4.993426e-04
Rgv_48_31 g_48_31 g_48_32 4.993426e-04
Rgh_48_32 g_48_32 g_49_32 4.993426e-04
Rgv_48_32 g_48_32 g_48_33 4.993426e-04
Rgh_48_33 g_48_33 g_49_33 4.993426e-04
Rgv_48_33 g_48_33 g_48_34 4.993426e-04
Rgh_48_34 g_48_34 g_49_34 4.993426e-04
Rgv_48_34 g_48_34 g_48_35 4.993426e-04
Rgh_48_35 g_48_35 g_49_35 4.993426e-04
Rgv_48_35 g_48_35 g_48_36 4.993426e-04
Rgh_48_36 g_48_36 g_49_36 4.993426e-04
Rgv_48_36 g_48_36 g_48_37 4.993426e-04
Rgh_48_37 g_48_37 g_49_37 4.993426e-04
Rgv_48_37 g_48_37 g_48_38 4.993426e-04
Rgh_48_38 g_48_38 g_49_38 4.993426e-04
Rgv_48_38 g_48_38 g_48_39 4.993426e-04
Rgh_48_39 g_48_39 g_49_39 4.993426e-04
Rgv_48_39 g_48_39 g_48_40 4.993426e-04
Rgh_48_40 g_48_40 g_49_40 4.993426e-04
Rgv_48_40 g_48_40 g_48_41 4.993426e-04
Rgh_48_41 g_48_41 g_49_41 4.993426e-04
Rgv_48_41 g_48_41 g_48_42 4.993426e-04
Rgh_48_42 g_48_42 g_49_42 4.993426e-04
Rgv_48_42 g_48_42 g_48_43 4.993426e-04
Rgh_48_43 g_48_43 g_49_43 4.993426e-04
Rgv_48_43 g_48_43 g_48_44 4.993426e-04
Rgh_48_44 g_48_44 g_49_44 4.993426e-04
Rgv_48_44 g_48_44 g_48_45 4.993426e-04
Rgh_48_45 g_48_45 g_49_45 4.993426e-04
Rgv_48_45 g_48_45 g_48_46 4.993426e-04
Rgh_48_46 g_48_46 g_49_46 4.993426e-04
Rgv_48_46 g_48_46 g_48_47 4.993426e-04
Rgh_48_47 g_48_47 g_49_47 4.993426e-04
Rgv_48_47 g_48_47 g_48_48 4.993426e-04
Rgh_48_48 g_48_48 g_49_48 4.993426e-04
Rgv_48_48 g_48_48 g_48_49 4.993426e-04
Rgh_48_49 g_48_49 g_49_49 4.993426e-04
Rgv_48_49 g_48_49 g_48_50 4.993426e-04
Rgh_48_50 g_48_50 g_49_50 4.993426e-04
Rgv_48_50 g_48_50 g_48_51 4.993426e-04
Rgh_48_51 g_48_51 g_49_51 4.993426e-04
Rgv_48_51 g_48_51 g_48_52 4.993426e-04
Rgh_48_52 g_48_52 g_49_52 4.993426e-04
Rgv_48_52 g_48_52 g_48_53 4.993426e-04
Rgh_48_53 g_48_53 g_49_53 4.993426e-04
Rgv_48_53 g_48_53 g_48_54 4.993426e-04
Rgh_48_54 g_48_54 g_49_54 4.993426e-04
Rgv_48_54 g_48_54 g_48_55 4.993426e-04
Rgh_48_55 g_48_55 g_49_55 4.993426e-04
Rgv_48_55 g_48_55 g_48_56 4.993426e-04
Rgh_48_56 g_48_56 g_49_56 4.993426e-04
Rgv_48_56 g_48_56 g_48_57 4.993426e-04
Rgh_48_57 g_48_57 g_49_57 4.993426e-04
Rgv_48_57 g_48_57 g_48_58 4.993426e-04
Rgh_48_58 g_48_58 g_49_58 4.993426e-04
Rgv_48_58 g_48_58 g_48_59 4.993426e-04
Rgh_48_59 g_48_59 g_49_59 4.993426e-04
Rgv_48_59 g_48_59 g_48_60 4.993426e-04
Rgh_48_60 g_48_60 g_49_60 4.993426e-04
Rgv_48_60 g_48_60 g_48_61 4.993426e-04
Rgh_48_61 g_48_61 g_49_61 4.993426e-04
Rgv_48_61 g_48_61 g_48_62 4.993426e-04
Rgh_48_62 g_48_62 g_49_62 4.993426e-04
Rgv_48_62 g_48_62 g_48_63 4.993426e-04
Rgh_48_63 g_48_63 g_49_63 4.993426e-04
Rgv_48_63 g_48_63 g_48_64 4.993426e-04
Rgh_48_64 g_48_64 g_49_64 4.993426e-04
Rgv_48_64 g_48_64 g_48_65 4.993426e-04
Rgh_48_65 g_48_65 g_49_65 4.993426e-04
Rgv_48_65 g_48_65 g_48_66 4.993426e-04
Rgh_48_66 g_48_66 g_49_66 4.993426e-04
Rgv_48_66 g_48_66 g_48_67 4.993426e-04
Rgh_48_67 g_48_67 g_49_67 4.993426e-04
Rgv_48_67 g_48_67 g_48_68 4.993426e-04
Rgh_48_68 g_48_68 g_49_68 4.993426e-04
Rgv_48_68 g_48_68 g_48_69 4.993426e-04
Rgh_48_69 g_48_69 g_49_69 4.993426e-04
Rgv_48_69 g_48_69 g_48_70 4.993426e-04
Rgh_48_70 g_48_70 g_49_70 4.993426e-04
Rgv_48_70 g_48_70 g_48_71 4.993426e-04
Rgh_48_71 g_48_71 g_49_71 4.993426e-04
Rgh_49_0 g_49_0 g_50_0 4.993426e-04
Rgv_49_0 g_49_0 g_49_1 4.993426e-04
Rgh_49_1 g_49_1 g_50_1 4.993426e-04
Rgv_49_1 g_49_1 g_49_2 4.993426e-04
Rgh_49_2 g_49_2 g_50_2 4.993426e-04
Rgv_49_2 g_49_2 g_49_3 4.993426e-04
Rgh_49_3 g_49_3 g_50_3 4.993426e-04
Rgv_49_3 g_49_3 g_49_4 4.993426e-04
Rgh_49_4 g_49_4 g_50_4 4.993426e-04
Rgv_49_4 g_49_4 g_49_5 4.993426e-04
Rgh_49_5 g_49_5 g_50_5 4.993426e-04
Rgv_49_5 g_49_5 g_49_6 4.993426e-04
Rgh_49_6 g_49_6 g_50_6 4.993426e-04
Rgv_49_6 g_49_6 g_49_7 4.993426e-04
Rgh_49_7 g_49_7 g_50_7 4.993426e-04
Rgv_49_7 g_49_7 g_49_8 4.993426e-04
Rgh_49_8 g_49_8 g_50_8 4.993426e-04
Rgv_49_8 g_49_8 g_49_9 4.993426e-04
Rgh_49_9 g_49_9 g_50_9 4.993426e-04
Rgv_49_9 g_49_9 g_49_10 4.993426e-04
Rgh_49_10 g_49_10 g_50_10 4.993426e-04
Rgv_49_10 g_49_10 g_49_11 4.993426e-04
Rgh_49_11 g_49_11 g_50_11 4.993426e-04
Rgv_49_11 g_49_11 g_49_12 4.993426e-04
Rgh_49_12 g_49_12 g_50_12 4.993426e-04
Rgv_49_12 g_49_12 g_49_13 4.993426e-04
Rgh_49_13 g_49_13 g_50_13 4.993426e-04
Rgv_49_13 g_49_13 g_49_14 4.993426e-04
Rgh_49_14 g_49_14 g_50_14 4.993426e-04
Rgv_49_14 g_49_14 g_49_15 4.993426e-04
Rgh_49_15 g_49_15 g_50_15 4.993426e-04
Rgv_49_15 g_49_15 g_49_16 4.993426e-04
Rgh_49_16 g_49_16 g_50_16 4.993426e-04
Rgv_49_16 g_49_16 g_49_17 4.993426e-04
Rgh_49_17 g_49_17 g_50_17 4.993426e-04
Rgv_49_17 g_49_17 g_49_18 4.993426e-04
Rgh_49_18 g_49_18 g_50_18 4.993426e-04
Rgv_49_18 g_49_18 g_49_19 4.993426e-04
Rgh_49_19 g_49_19 g_50_19 4.993426e-04
Rgv_49_19 g_49_19 g_49_20 4.993426e-04
Rgh_49_20 g_49_20 g_50_20 4.993426e-04
Rgv_49_20 g_49_20 g_49_21 4.993426e-04
Rgh_49_21 g_49_21 g_50_21 4.993426e-04
Rgv_49_21 g_49_21 g_49_22 4.993426e-04
Rgh_49_22 g_49_22 g_50_22 4.993426e-04
Rgv_49_22 g_49_22 g_49_23 4.993426e-04
Rgh_49_23 g_49_23 g_50_23 4.993426e-04
Rgv_49_23 g_49_23 g_49_24 4.993426e-04
Rgh_49_24 g_49_24 g_50_24 4.993426e-04
Rgv_49_24 g_49_24 g_49_25 4.993426e-04
Rgh_49_25 g_49_25 g_50_25 4.993426e-04
Rgv_49_25 g_49_25 g_49_26 4.993426e-04
Rgh_49_26 g_49_26 g_50_26 4.993426e-04
Rgv_49_26 g_49_26 g_49_27 4.993426e-04
Rgh_49_27 g_49_27 g_50_27 4.993426e-04
Rgv_49_27 g_49_27 g_49_28 4.993426e-04
Rgh_49_28 g_49_28 g_50_28 4.993426e-04
Rgv_49_28 g_49_28 g_49_29 4.993426e-04
Rgh_49_29 g_49_29 g_50_29 4.993426e-04
Rgv_49_29 g_49_29 g_49_30 4.993426e-04
Rgh_49_30 g_49_30 g_50_30 4.993426e-04
Rgv_49_30 g_49_30 g_49_31 4.993426e-04
Rgh_49_31 g_49_31 g_50_31 4.993426e-04
Rgv_49_31 g_49_31 g_49_32 4.993426e-04
Rgh_49_32 g_49_32 g_50_32 4.993426e-04
Rgv_49_32 g_49_32 g_49_33 4.993426e-04
Rgh_49_33 g_49_33 g_50_33 4.993426e-04
Rgv_49_33 g_49_33 g_49_34 4.993426e-04
Rgh_49_34 g_49_34 g_50_34 4.993426e-04
Rgv_49_34 g_49_34 g_49_35 4.993426e-04
Rgh_49_35 g_49_35 g_50_35 4.993426e-04
Rgv_49_35 g_49_35 g_49_36 4.993426e-04
Rgh_49_36 g_49_36 g_50_36 4.993426e-04
Rgv_49_36 g_49_36 g_49_37 4.993426e-04
Rgh_49_37 g_49_37 g_50_37 4.993426e-04
Rgv_49_37 g_49_37 g_49_38 4.993426e-04
Rgh_49_38 g_49_38 g_50_38 4.993426e-04
Rgv_49_38 g_49_38 g_49_39 4.993426e-04
Rgh_49_39 g_49_39 g_50_39 4.993426e-04
Rgv_49_39 g_49_39 g_49_40 4.993426e-04
Rgh_49_40 g_49_40 g_50_40 4.993426e-04
Rgv_49_40 g_49_40 g_49_41 4.993426e-04
Rgh_49_41 g_49_41 g_50_41 4.993426e-04
Rgv_49_41 g_49_41 g_49_42 4.993426e-04
Rgh_49_42 g_49_42 g_50_42 4.993426e-04
Rgv_49_42 g_49_42 g_49_43 4.993426e-04
Rgh_49_43 g_49_43 g_50_43 4.993426e-04
Rgv_49_43 g_49_43 g_49_44 4.993426e-04
Rgh_49_44 g_49_44 g_50_44 4.993426e-04
Rgv_49_44 g_49_44 g_49_45 4.993426e-04
Rgh_49_45 g_49_45 g_50_45 4.993426e-04
Rgv_49_45 g_49_45 g_49_46 4.993426e-04
Rgh_49_46 g_49_46 g_50_46 4.993426e-04
Rgv_49_46 g_49_46 g_49_47 4.993426e-04
Rgh_49_47 g_49_47 g_50_47 4.993426e-04
Rgv_49_47 g_49_47 g_49_48 4.993426e-04
Rgh_49_48 g_49_48 g_50_48 4.993426e-04
Rgv_49_48 g_49_48 g_49_49 4.993426e-04
Rgh_49_49 g_49_49 g_50_49 4.993426e-04
Rgv_49_49 g_49_49 g_49_50 4.993426e-04
Rgh_49_50 g_49_50 g_50_50 4.993426e-04
Rgv_49_50 g_49_50 g_49_51 4.993426e-04
Rgh_49_51 g_49_51 g_50_51 4.993426e-04
Rgv_49_51 g_49_51 g_49_52 4.993426e-04
Rgh_49_52 g_49_52 g_50_52 4.993426e-04
Rgv_49_52 g_49_52 g_49_53 4.993426e-04
Rgh_49_53 g_49_53 g_50_53 4.993426e-04
Rgv_49_53 g_49_53 g_49_54 4.993426e-04
Rgh_49_54 g_49_54 g_50_54 4.993426e-04
Rgv_49_54 g_49_54 g_49_55 4.993426e-04
Rgh_49_55 g_49_55 g_50_55 4.993426e-04
Rgv_49_55 g_49_55 g_49_56 4.993426e-04
Rgh_49_56 g_49_56 g_50_56 4.993426e-04
Rgv_49_56 g_49_56 g_49_57 4.993426e-04
Rgh_49_57 g_49_57 g_50_57 4.993426e-04
Rgv_49_57 g_49_57 g_49_58 4.993426e-04
Rgh_49_58 g_49_58 g_50_58 4.993426e-04
Rgv_49_58 g_49_58 g_49_59 4.993426e-04
Rgh_49_59 g_49_59 g_50_59 4.993426e-04
Rgv_49_59 g_49_59 g_49_60 4.993426e-04
Rgh_49_60 g_49_60 g_50_60 4.993426e-04
Rgv_49_60 g_49_60 g_49_61 4.993426e-04
Rgh_49_61 g_49_61 g_50_61 4.993426e-04
Rgv_49_61 g_49_61 g_49_62 4.993426e-04
Rgh_49_62 g_49_62 g_50_62 4.993426e-04
Rgv_49_62 g_49_62 g_49_63 4.993426e-04
Rgh_49_63 g_49_63 g_50_63 4.993426e-04
Rgv_49_63 g_49_63 g_49_64 4.993426e-04
Rgh_49_64 g_49_64 g_50_64 4.993426e-04
Rgv_49_64 g_49_64 g_49_65 4.993426e-04
Rgh_49_65 g_49_65 g_50_65 4.993426e-04
Rgv_49_65 g_49_65 g_49_66 4.993426e-04
Rgh_49_66 g_49_66 g_50_66 4.993426e-04
Rgv_49_66 g_49_66 g_49_67 4.993426e-04
Rgh_49_67 g_49_67 g_50_67 4.993426e-04
Rgv_49_67 g_49_67 g_49_68 4.993426e-04
Rgh_49_68 g_49_68 g_50_68 4.993426e-04
Rgv_49_68 g_49_68 g_49_69 4.993426e-04
Rgh_49_69 g_49_69 g_50_69 4.993426e-04
Rgv_49_69 g_49_69 g_49_70 4.993426e-04
Rgh_49_70 g_49_70 g_50_70 4.993426e-04
Rgv_49_70 g_49_70 g_49_71 4.993426e-04
Rgh_49_71 g_49_71 g_50_71 4.993426e-04
Rgh_50_0 g_50_0 g_51_0 4.993426e-04
Rgv_50_0 g_50_0 g_50_1 4.993426e-04
Rgh_50_1 g_50_1 g_51_1 4.993426e-04
Rgv_50_1 g_50_1 g_50_2 4.993426e-04
Rgh_50_2 g_50_2 g_51_2 4.993426e-04
Rgv_50_2 g_50_2 g_50_3 4.993426e-04
Rgh_50_3 g_50_3 g_51_3 4.993426e-04
Rgv_50_3 g_50_3 g_50_4 4.993426e-04
Rgh_50_4 g_50_4 g_51_4 4.993426e-04
Rgv_50_4 g_50_4 g_50_5 4.993426e-04
Rgh_50_5 g_50_5 g_51_5 4.993426e-04
Rgv_50_5 g_50_5 g_50_6 4.993426e-04
Rgh_50_6 g_50_6 g_51_6 4.993426e-04
Rgv_50_6 g_50_6 g_50_7 4.993426e-04
Rgh_50_7 g_50_7 g_51_7 4.993426e-04
Rgv_50_7 g_50_7 g_50_8 4.993426e-04
Rgh_50_8 g_50_8 g_51_8 4.993426e-04
Rgv_50_8 g_50_8 g_50_9 4.993426e-04
Rgh_50_9 g_50_9 g_51_9 4.993426e-04
Rgv_50_9 g_50_9 g_50_10 4.993426e-04
Rgh_50_10 g_50_10 g_51_10 4.993426e-04
Rgv_50_10 g_50_10 g_50_11 4.993426e-04
Rgh_50_11 g_50_11 g_51_11 4.993426e-04
Rgv_50_11 g_50_11 g_50_12 4.993426e-04
Rgh_50_12 g_50_12 g_51_12 4.993426e-04
Rgv_50_12 g_50_12 g_50_13 4.993426e-04
Rgh_50_13 g_50_13 g_51_13 4.993426e-04
Rgv_50_13 g_50_13 g_50_14 4.993426e-04
Rgh_50_14 g_50_14 g_51_14 4.993426e-04
Rgv_50_14 g_50_14 g_50_15 4.993426e-04
Rgh_50_15 g_50_15 g_51_15 4.993426e-04
Rgv_50_15 g_50_15 g_50_16 4.993426e-04
Rgh_50_16 g_50_16 g_51_16 4.993426e-04
Rgv_50_16 g_50_16 g_50_17 4.993426e-04
Rgh_50_17 g_50_17 g_51_17 4.993426e-04
Rgv_50_17 g_50_17 g_50_18 4.993426e-04
Rgh_50_18 g_50_18 g_51_18 4.993426e-04
Rgv_50_18 g_50_18 g_50_19 4.993426e-04
Rgh_50_19 g_50_19 g_51_19 4.993426e-04
Rgv_50_19 g_50_19 g_50_20 4.993426e-04
Rgh_50_20 g_50_20 g_51_20 4.993426e-04
Rgv_50_20 g_50_20 g_50_21 4.993426e-04
Rgh_50_21 g_50_21 g_51_21 4.993426e-04
Rgv_50_21 g_50_21 g_50_22 4.993426e-04
Rgh_50_22 g_50_22 g_51_22 4.993426e-04
Rgv_50_22 g_50_22 g_50_23 4.993426e-04
Rgh_50_23 g_50_23 g_51_23 4.993426e-04
Rgv_50_23 g_50_23 g_50_24 4.993426e-04
Rgh_50_24 g_50_24 g_51_24 4.993426e-04
Rgv_50_24 g_50_24 g_50_25 4.993426e-04
Rgh_50_25 g_50_25 g_51_25 4.993426e-04
Rgv_50_25 g_50_25 g_50_26 4.993426e-04
Rgh_50_26 g_50_26 g_51_26 4.993426e-04
Rgv_50_26 g_50_26 g_50_27 4.993426e-04
Rgh_50_27 g_50_27 g_51_27 4.993426e-04
Rgv_50_27 g_50_27 g_50_28 4.993426e-04
Rgh_50_28 g_50_28 g_51_28 4.993426e-04
Rgv_50_28 g_50_28 g_50_29 4.993426e-04
Rgh_50_29 g_50_29 g_51_29 4.993426e-04
Rgv_50_29 g_50_29 g_50_30 4.993426e-04
Rgh_50_30 g_50_30 g_51_30 4.993426e-04
Rgv_50_30 g_50_30 g_50_31 4.993426e-04
Rgh_50_31 g_50_31 g_51_31 4.993426e-04
Rgv_50_31 g_50_31 g_50_32 4.993426e-04
Rgh_50_32 g_50_32 g_51_32 4.993426e-04
Rgv_50_32 g_50_32 g_50_33 4.993426e-04
Rgh_50_33 g_50_33 g_51_33 4.993426e-04
Rgv_50_33 g_50_33 g_50_34 4.993426e-04
Rgh_50_34 g_50_34 g_51_34 4.993426e-04
Rgv_50_34 g_50_34 g_50_35 4.993426e-04
Rgh_50_35 g_50_35 g_51_35 4.993426e-04
Rgv_50_35 g_50_35 g_50_36 4.993426e-04
Rgh_50_36 g_50_36 g_51_36 4.993426e-04
Rgv_50_36 g_50_36 g_50_37 4.993426e-04
Rgh_50_37 g_50_37 g_51_37 4.993426e-04
Rgv_50_37 g_50_37 g_50_38 4.993426e-04
Rgh_50_38 g_50_38 g_51_38 4.993426e-04
Rgv_50_38 g_50_38 g_50_39 4.993426e-04
Rgh_50_39 g_50_39 g_51_39 4.993426e-04
Rgv_50_39 g_50_39 g_50_40 4.993426e-04
Rgh_50_40 g_50_40 g_51_40 4.993426e-04
Rgv_50_40 g_50_40 g_50_41 4.993426e-04
Rgh_50_41 g_50_41 g_51_41 4.993426e-04
Rgv_50_41 g_50_41 g_50_42 4.993426e-04
Rgh_50_42 g_50_42 g_51_42 4.993426e-04
Rgv_50_42 g_50_42 g_50_43 4.993426e-04
Rgh_50_43 g_50_43 g_51_43 4.993426e-04
Rgv_50_43 g_50_43 g_50_44 4.993426e-04
Rgh_50_44 g_50_44 g_51_44 4.993426e-04
Rgv_50_44 g_50_44 g_50_45 4.993426e-04
Rgh_50_45 g_50_45 g_51_45 4.993426e-04
Rgv_50_45 g_50_45 g_50_46 4.993426e-04
Rgh_50_46 g_50_46 g_51_46 4.993426e-04
Rgv_50_46 g_50_46 g_50_47 4.993426e-04
Rgh_50_47 g_50_47 g_51_47 4.993426e-04
Rgv_50_47 g_50_47 g_50_48 4.993426e-04
Rgh_50_48 g_50_48 g_51_48 4.993426e-04
Rgv_50_48 g_50_48 g_50_49 4.993426e-04
Rgh_50_49 g_50_49 g_51_49 4.993426e-04
Rgv_50_49 g_50_49 g_50_50 4.993426e-04
Rgh_50_50 g_50_50 g_51_50 4.993426e-04
Rgv_50_50 g_50_50 g_50_51 4.993426e-04
Rgh_50_51 g_50_51 g_51_51 4.993426e-04
Rgv_50_51 g_50_51 g_50_52 4.993426e-04
Rgh_50_52 g_50_52 g_51_52 4.993426e-04
Rgv_50_52 g_50_52 g_50_53 4.993426e-04
Rgh_50_53 g_50_53 g_51_53 4.993426e-04
Rgv_50_53 g_50_53 g_50_54 4.993426e-04
Rgh_50_54 g_50_54 g_51_54 4.993426e-04
Rgv_50_54 g_50_54 g_50_55 4.993426e-04
Rgh_50_55 g_50_55 g_51_55 4.993426e-04
Rgv_50_55 g_50_55 g_50_56 4.993426e-04
Rgh_50_56 g_50_56 g_51_56 4.993426e-04
Rgv_50_56 g_50_56 g_50_57 4.993426e-04
Rgh_50_57 g_50_57 g_51_57 4.993426e-04
Rgv_50_57 g_50_57 g_50_58 4.993426e-04
Rgh_50_58 g_50_58 g_51_58 4.993426e-04
Rgv_50_58 g_50_58 g_50_59 4.993426e-04
Rgh_50_59 g_50_59 g_51_59 4.993426e-04
Rgv_50_59 g_50_59 g_50_60 4.993426e-04
Rgh_50_60 g_50_60 g_51_60 4.993426e-04
Rgv_50_60 g_50_60 g_50_61 4.993426e-04
Rgh_50_61 g_50_61 g_51_61 4.993426e-04
Rgv_50_61 g_50_61 g_50_62 4.993426e-04
Rgh_50_62 g_50_62 g_51_62 4.993426e-04
Rgv_50_62 g_50_62 g_50_63 4.993426e-04
Rgh_50_63 g_50_63 g_51_63 4.993426e-04
Rgv_50_63 g_50_63 g_50_64 4.993426e-04
Rgh_50_64 g_50_64 g_51_64 4.993426e-04
Rgv_50_64 g_50_64 g_50_65 4.993426e-04
Rgh_50_65 g_50_65 g_51_65 4.993426e-04
Rgv_50_65 g_50_65 g_50_66 4.993426e-04
Rgh_50_66 g_50_66 g_51_66 4.993426e-04
Rgv_50_66 g_50_66 g_50_67 4.993426e-04
Rgh_50_67 g_50_67 g_51_67 4.993426e-04
Rgv_50_67 g_50_67 g_50_68 4.993426e-04
Rgh_50_68 g_50_68 g_51_68 4.993426e-04
Rgv_50_68 g_50_68 g_50_69 4.993426e-04
Rgh_50_69 g_50_69 g_51_69 4.993426e-04
Rgv_50_69 g_50_69 g_50_70 4.993426e-04
Rgh_50_70 g_50_70 g_51_70 4.993426e-04
Rgv_50_70 g_50_70 g_50_71 4.993426e-04
Rgh_50_71 g_50_71 g_51_71 4.993426e-04
Rgh_51_0 g_51_0 g_52_0 4.993426e-04
Rgv_51_0 g_51_0 g_51_1 4.993426e-04
Rgh_51_1 g_51_1 g_52_1 4.993426e-04
Rgv_51_1 g_51_1 g_51_2 4.993426e-04
Rgh_51_2 g_51_2 g_52_2 4.993426e-04
Rgv_51_2 g_51_2 g_51_3 4.993426e-04
Rgh_51_3 g_51_3 g_52_3 4.993426e-04
Rgv_51_3 g_51_3 g_51_4 4.993426e-04
Rgh_51_4 g_51_4 g_52_4 4.993426e-04
Rgv_51_4 g_51_4 g_51_5 4.993426e-04
Rgh_51_5 g_51_5 g_52_5 4.993426e-04
Rgv_51_5 g_51_5 g_51_6 4.993426e-04
Rgh_51_6 g_51_6 g_52_6 4.993426e-04
Rgv_51_6 g_51_6 g_51_7 4.993426e-04
Rgh_51_7 g_51_7 g_52_7 4.993426e-04
Rgv_51_7 g_51_7 g_51_8 4.993426e-04
Rgh_51_8 g_51_8 g_52_8 4.993426e-04
Rgv_51_8 g_51_8 g_51_9 4.993426e-04
Rgh_51_9 g_51_9 g_52_9 4.993426e-04
Rgv_51_9 g_51_9 g_51_10 4.993426e-04
Rgh_51_10 g_51_10 g_52_10 4.993426e-04
Rgv_51_10 g_51_10 g_51_11 4.993426e-04
Rgh_51_11 g_51_11 g_52_11 4.993426e-04
Rgv_51_11 g_51_11 g_51_12 4.993426e-04
Rgh_51_12 g_51_12 g_52_12 4.993426e-04
Rgv_51_12 g_51_12 g_51_13 4.993426e-04
Rgh_51_13 g_51_13 g_52_13 4.993426e-04
Rgv_51_13 g_51_13 g_51_14 4.993426e-04
Rgh_51_14 g_51_14 g_52_14 4.993426e-04
Rgv_51_14 g_51_14 g_51_15 4.993426e-04
Rgh_51_15 g_51_15 g_52_15 4.993426e-04
Rgv_51_15 g_51_15 g_51_16 4.993426e-04
Rgh_51_16 g_51_16 g_52_16 4.993426e-04
Rgv_51_16 g_51_16 g_51_17 4.993426e-04
Rgh_51_17 g_51_17 g_52_17 4.993426e-04
Rgv_51_17 g_51_17 g_51_18 4.993426e-04
Rgh_51_18 g_51_18 g_52_18 4.993426e-04
Rgv_51_18 g_51_18 g_51_19 4.993426e-04
Rgh_51_19 g_51_19 g_52_19 4.993426e-04
Rgv_51_19 g_51_19 g_51_20 4.993426e-04
Rgh_51_20 g_51_20 g_52_20 4.993426e-04
Rgv_51_20 g_51_20 g_51_21 4.993426e-04
Rgh_51_21 g_51_21 g_52_21 4.993426e-04
Rgv_51_21 g_51_21 g_51_22 4.993426e-04
Rgh_51_22 g_51_22 g_52_22 4.993426e-04
Rgv_51_22 g_51_22 g_51_23 4.993426e-04
Rgh_51_23 g_51_23 g_52_23 4.993426e-04
Rgv_51_23 g_51_23 g_51_24 4.993426e-04
Rgh_51_24 g_51_24 g_52_24 4.993426e-04
Rgv_51_24 g_51_24 g_51_25 4.993426e-04
Rgh_51_25 g_51_25 g_52_25 4.993426e-04
Rgv_51_25 g_51_25 g_51_26 4.993426e-04
Rgh_51_26 g_51_26 g_52_26 4.993426e-04
Rgv_51_26 g_51_26 g_51_27 4.993426e-04
Rgh_51_27 g_51_27 g_52_27 4.993426e-04
Rgv_51_27 g_51_27 g_51_28 4.993426e-04
Rgh_51_28 g_51_28 g_52_28 4.993426e-04
Rgv_51_28 g_51_28 g_51_29 4.993426e-04
Rgh_51_29 g_51_29 g_52_29 4.993426e-04
Rgv_51_29 g_51_29 g_51_30 4.993426e-04
Rgh_51_30 g_51_30 g_52_30 4.993426e-04
Rgv_51_30 g_51_30 g_51_31 4.993426e-04
Rgh_51_31 g_51_31 g_52_31 4.993426e-04
Rgv_51_31 g_51_31 g_51_32 4.993426e-04
Rgh_51_32 g_51_32 g_52_32 4.993426e-04
Rgv_51_32 g_51_32 g_51_33 4.993426e-04
Rgh_51_33 g_51_33 g_52_33 4.993426e-04
Rgv_51_33 g_51_33 g_51_34 4.993426e-04
Rgh_51_34 g_51_34 g_52_34 4.993426e-04
Rgv_51_34 g_51_34 g_51_35 4.993426e-04
Rgh_51_35 g_51_35 g_52_35 4.993426e-04
Rgv_51_35 g_51_35 g_51_36 4.993426e-04
Rgh_51_36 g_51_36 g_52_36 4.993426e-04
Rgv_51_36 g_51_36 g_51_37 4.993426e-04
Rgh_51_37 g_51_37 g_52_37 4.993426e-04
Rgv_51_37 g_51_37 g_51_38 4.993426e-04
Rgh_51_38 g_51_38 g_52_38 4.993426e-04
Rgv_51_38 g_51_38 g_51_39 4.993426e-04
Rgh_51_39 g_51_39 g_52_39 4.993426e-04
Rgv_51_39 g_51_39 g_51_40 4.993426e-04
Rgh_51_40 g_51_40 g_52_40 4.993426e-04
Rgv_51_40 g_51_40 g_51_41 4.993426e-04
Rgh_51_41 g_51_41 g_52_41 4.993426e-04
Rgv_51_41 g_51_41 g_51_42 4.993426e-04
Rgh_51_42 g_51_42 g_52_42 4.993426e-04
Rgv_51_42 g_51_42 g_51_43 4.993426e-04
Rgh_51_43 g_51_43 g_52_43 4.993426e-04
Rgv_51_43 g_51_43 g_51_44 4.993426e-04
Rgh_51_44 g_51_44 g_52_44 4.993426e-04
Rgv_51_44 g_51_44 g_51_45 4.993426e-04
Rgh_51_45 g_51_45 g_52_45 4.993426e-04
Rgv_51_45 g_51_45 g_51_46 4.993426e-04
Rgh_51_46 g_51_46 g_52_46 4.993426e-04
Rgv_51_46 g_51_46 g_51_47 4.993426e-04
Rgh_51_47 g_51_47 g_52_47 4.993426e-04
Rgv_51_47 g_51_47 g_51_48 4.993426e-04
Rgh_51_48 g_51_48 g_52_48 4.993426e-04
Rgv_51_48 g_51_48 g_51_49 4.993426e-04
Rgh_51_49 g_51_49 g_52_49 4.993426e-04
Rgv_51_49 g_51_49 g_51_50 4.993426e-04
Rgh_51_50 g_51_50 g_52_50 4.993426e-04
Rgv_51_50 g_51_50 g_51_51 4.993426e-04
Rgh_51_51 g_51_51 g_52_51 4.993426e-04
Rgv_51_51 g_51_51 g_51_52 4.993426e-04
Rgh_51_52 g_51_52 g_52_52 4.993426e-04
Rgv_51_52 g_51_52 g_51_53 4.993426e-04
Rgh_51_53 g_51_53 g_52_53 4.993426e-04
Rgv_51_53 g_51_53 g_51_54 4.993426e-04
Rgh_51_54 g_51_54 g_52_54 4.993426e-04
Rgv_51_54 g_51_54 g_51_55 4.993426e-04
Rgh_51_55 g_51_55 g_52_55 4.993426e-04
Rgv_51_55 g_51_55 g_51_56 4.993426e-04
Rgh_51_56 g_51_56 g_52_56 4.993426e-04
Rgv_51_56 g_51_56 g_51_57 4.993426e-04
Rgh_51_57 g_51_57 g_52_57 4.993426e-04
Rgv_51_57 g_51_57 g_51_58 4.993426e-04
Rgh_51_58 g_51_58 g_52_58 4.993426e-04
Rgv_51_58 g_51_58 g_51_59 4.993426e-04
Rgh_51_59 g_51_59 g_52_59 4.993426e-04
Rgv_51_59 g_51_59 g_51_60 4.993426e-04
Rgh_51_60 g_51_60 g_52_60 4.993426e-04
Rgv_51_60 g_51_60 g_51_61 4.993426e-04
Rgh_51_61 g_51_61 g_52_61 4.993426e-04
Rgv_51_61 g_51_61 g_51_62 4.993426e-04
Rgh_51_62 g_51_62 g_52_62 4.993426e-04
Rgv_51_62 g_51_62 g_51_63 4.993426e-04
Rgh_51_63 g_51_63 g_52_63 4.993426e-04
Rgv_51_63 g_51_63 g_51_64 4.993426e-04
Rgh_51_64 g_51_64 g_52_64 4.993426e-04
Rgv_51_64 g_51_64 g_51_65 4.993426e-04
Rgh_51_65 g_51_65 g_52_65 4.993426e-04
Rgv_51_65 g_51_65 g_51_66 4.993426e-04
Rgh_51_66 g_51_66 g_52_66 4.993426e-04
Rgv_51_66 g_51_66 g_51_67 4.993426e-04
Rgh_51_67 g_51_67 g_52_67 4.993426e-04
Rgv_51_67 g_51_67 g_51_68 4.993426e-04
Rgh_51_68 g_51_68 g_52_68 4.993426e-04
Rgv_51_68 g_51_68 g_51_69 4.993426e-04
Rgh_51_69 g_51_69 g_52_69 4.993426e-04
Rgv_51_69 g_51_69 g_51_70 4.993426e-04
Rgh_51_70 g_51_70 g_52_70 4.993426e-04
Rgv_51_70 g_51_70 g_51_71 4.993426e-04
Rgh_51_71 g_51_71 g_52_71 4.993426e-04
Rgh_52_0 g_52_0 g_53_0 4.993426e-04
Rgv_52_0 g_52_0 g_52_1 4.993426e-04
Rgh_52_1 g_52_1 g_53_1 4.993426e-04
Rgv_52_1 g_52_1 g_52_2 4.993426e-04
Rgh_52_2 g_52_2 g_53_2 4.993426e-04
Rgv_52_2 g_52_2 g_52_3 4.993426e-04
Rgh_52_3 g_52_3 g_53_3 4.993426e-04
Rgv_52_3 g_52_3 g_52_4 4.993426e-04
Rgh_52_4 g_52_4 g_53_4 4.993426e-04
Rgv_52_4 g_52_4 g_52_5 4.993426e-04
Rgh_52_5 g_52_5 g_53_5 4.993426e-04
Rgv_52_5 g_52_5 g_52_6 4.993426e-04
Rgh_52_6 g_52_6 g_53_6 4.993426e-04
Rgv_52_6 g_52_6 g_52_7 4.993426e-04
Rgh_52_7 g_52_7 g_53_7 4.993426e-04
Rgv_52_7 g_52_7 g_52_8 4.993426e-04
Rgh_52_8 g_52_8 g_53_8 4.993426e-04
Rgv_52_8 g_52_8 g_52_9 4.993426e-04
Rgh_52_9 g_52_9 g_53_9 4.993426e-04
Rgv_52_9 g_52_9 g_52_10 4.993426e-04
Rgh_52_10 g_52_10 g_53_10 4.993426e-04
Rgv_52_10 g_52_10 g_52_11 4.993426e-04
Rgh_52_11 g_52_11 g_53_11 4.993426e-04
Rgv_52_11 g_52_11 g_52_12 4.993426e-04
Rgh_52_12 g_52_12 g_53_12 4.993426e-04
Rgv_52_12 g_52_12 g_52_13 4.993426e-04
Rgh_52_13 g_52_13 g_53_13 4.993426e-04
Rgv_52_13 g_52_13 g_52_14 4.993426e-04
Rgh_52_14 g_52_14 g_53_14 4.993426e-04
Rgv_52_14 g_52_14 g_52_15 4.993426e-04
Rgh_52_15 g_52_15 g_53_15 4.993426e-04
Rgv_52_15 g_52_15 g_52_16 4.993426e-04
Rgh_52_16 g_52_16 g_53_16 4.993426e-04
Rgv_52_16 g_52_16 g_52_17 4.993426e-04
Rgh_52_17 g_52_17 g_53_17 4.993426e-04
Rgv_52_17 g_52_17 g_52_18 4.993426e-04
Rgh_52_18 g_52_18 g_53_18 4.993426e-04
Rgv_52_18 g_52_18 g_52_19 4.993426e-04
Rgh_52_19 g_52_19 g_53_19 4.993426e-04
Rgv_52_19 g_52_19 g_52_20 4.993426e-04
Rgh_52_20 g_52_20 g_53_20 4.993426e-04
Rgv_52_20 g_52_20 g_52_21 4.993426e-04
Rgh_52_21 g_52_21 g_53_21 4.993426e-04
Rgv_52_21 g_52_21 g_52_22 4.993426e-04
Rgh_52_22 g_52_22 g_53_22 4.993426e-04
Rgv_52_22 g_52_22 g_52_23 4.993426e-04
Rgh_52_23 g_52_23 g_53_23 4.993426e-04
Rgv_52_23 g_52_23 g_52_24 4.993426e-04
Rgh_52_24 g_52_24 g_53_24 4.993426e-04
Rgv_52_24 g_52_24 g_52_25 4.993426e-04
Rgh_52_25 g_52_25 g_53_25 4.993426e-04
Rgv_52_25 g_52_25 g_52_26 4.993426e-04
Rgh_52_26 g_52_26 g_53_26 4.993426e-04
Rgv_52_26 g_52_26 g_52_27 4.993426e-04
Rgh_52_27 g_52_27 g_53_27 4.993426e-04
Rgv_52_27 g_52_27 g_52_28 4.993426e-04
Rgh_52_28 g_52_28 g_53_28 4.993426e-04
Rgv_52_28 g_52_28 g_52_29 4.993426e-04
Rgh_52_29 g_52_29 g_53_29 4.993426e-04
Rgv_52_29 g_52_29 g_52_30 4.993426e-04
Rgh_52_30 g_52_30 g_53_30 4.993426e-04
Rgv_52_30 g_52_30 g_52_31 4.993426e-04
Rgh_52_31 g_52_31 g_53_31 4.993426e-04
Rgv_52_31 g_52_31 g_52_32 4.993426e-04
Rgh_52_32 g_52_32 g_53_32 4.993426e-04
Rgv_52_32 g_52_32 g_52_33 4.993426e-04
Rgh_52_33 g_52_33 g_53_33 4.993426e-04
Rgv_52_33 g_52_33 g_52_34 4.993426e-04
Rgh_52_34 g_52_34 g_53_34 4.993426e-04
Rgv_52_34 g_52_34 g_52_35 4.993426e-04
Rgh_52_35 g_52_35 g_53_35 4.993426e-04
Rgv_52_35 g_52_35 g_52_36 4.993426e-04
Rgh_52_36 g_52_36 g_53_36 4.993426e-04
Rgv_52_36 g_52_36 g_52_37 4.993426e-04
Rgh_52_37 g_52_37 g_53_37 4.993426e-04
Rgv_52_37 g_52_37 g_52_38 4.993426e-04
Rgh_52_38 g_52_38 g_53_38 4.993426e-04
Rgv_52_38 g_52_38 g_52_39 4.993426e-04
Rgh_52_39 g_52_39 g_53_39 4.993426e-04
Rgv_52_39 g_52_39 g_52_40 4.993426e-04
Rgh_52_40 g_52_40 g_53_40 4.993426e-04
Rgv_52_40 g_52_40 g_52_41 4.993426e-04
Rgh_52_41 g_52_41 g_53_41 4.993426e-04
Rgv_52_41 g_52_41 g_52_42 4.993426e-04
Rgh_52_42 g_52_42 g_53_42 4.993426e-04
Rgv_52_42 g_52_42 g_52_43 4.993426e-04
Rgh_52_43 g_52_43 g_53_43 4.993426e-04
Rgv_52_43 g_52_43 g_52_44 4.993426e-04
Rgh_52_44 g_52_44 g_53_44 4.993426e-04
Rgv_52_44 g_52_44 g_52_45 4.993426e-04
Rgh_52_45 g_52_45 g_53_45 4.993426e-04
Rgv_52_45 g_52_45 g_52_46 4.993426e-04
Rgh_52_46 g_52_46 g_53_46 4.993426e-04
Rgv_52_46 g_52_46 g_52_47 4.993426e-04
Rgh_52_47 g_52_47 g_53_47 4.993426e-04
Rgv_52_47 g_52_47 g_52_48 4.993426e-04
Rgh_52_48 g_52_48 g_53_48 4.993426e-04
Rgv_52_48 g_52_48 g_52_49 4.993426e-04
Rgh_52_49 g_52_49 g_53_49 4.993426e-04
Rgv_52_49 g_52_49 g_52_50 4.993426e-04
Rgh_52_50 g_52_50 g_53_50 4.993426e-04
Rgv_52_50 g_52_50 g_52_51 4.993426e-04
Rgh_52_51 g_52_51 g_53_51 4.993426e-04
Rgv_52_51 g_52_51 g_52_52 4.993426e-04
Rgh_52_52 g_52_52 g_53_52 4.993426e-04
Rgv_52_52 g_52_52 g_52_53 4.993426e-04
Rgh_52_53 g_52_53 g_53_53 4.993426e-04
Rgv_52_53 g_52_53 g_52_54 4.993426e-04
Rgh_52_54 g_52_54 g_53_54 4.993426e-04
Rgv_52_54 g_52_54 g_52_55 4.993426e-04
Rgh_52_55 g_52_55 g_53_55 4.993426e-04
Rgv_52_55 g_52_55 g_52_56 4.993426e-04
Rgh_52_56 g_52_56 g_53_56 4.993426e-04
Rgv_52_56 g_52_56 g_52_57 4.993426e-04
Rgh_52_57 g_52_57 g_53_57 4.993426e-04
Rgv_52_57 g_52_57 g_52_58 4.993426e-04
Rgh_52_58 g_52_58 g_53_58 4.993426e-04
Rgv_52_58 g_52_58 g_52_59 4.993426e-04
Rgh_52_59 g_52_59 g_53_59 4.993426e-04
Rgv_52_59 g_52_59 g_52_60 4.993426e-04
Rgh_52_60 g_52_60 g_53_60 4.993426e-04
Rgv_52_60 g_52_60 g_52_61 4.993426e-04
Rgh_52_61 g_52_61 g_53_61 4.993426e-04
Rgv_52_61 g_52_61 g_52_62 4.993426e-04
Rgh_52_62 g_52_62 g_53_62 4.993426e-04
Rgv_52_62 g_52_62 g_52_63 4.993426e-04
Rgh_52_63 g_52_63 g_53_63 4.993426e-04
Rgv_52_63 g_52_63 g_52_64 4.993426e-04
Rgh_52_64 g_52_64 g_53_64 4.993426e-04
Rgv_52_64 g_52_64 g_52_65 4.993426e-04
Rgh_52_65 g_52_65 g_53_65 4.993426e-04
Rgv_52_65 g_52_65 g_52_66 4.993426e-04
Rgh_52_66 g_52_66 g_53_66 4.993426e-04
Rgv_52_66 g_52_66 g_52_67 4.993426e-04
Rgh_52_67 g_52_67 g_53_67 4.993426e-04
Rgv_52_67 g_52_67 g_52_68 4.993426e-04
Rgh_52_68 g_52_68 g_53_68 4.993426e-04
Rgv_52_68 g_52_68 g_52_69 4.993426e-04
Rgh_52_69 g_52_69 g_53_69 4.993426e-04
Rgv_52_69 g_52_69 g_52_70 4.993426e-04
Rgh_52_70 g_52_70 g_53_70 4.993426e-04
Rgv_52_70 g_52_70 g_52_71 4.993426e-04
Rgh_52_71 g_52_71 g_53_71 4.993426e-04
Rgh_53_0 g_53_0 g_54_0 4.993426e-04
Rgv_53_0 g_53_0 g_53_1 4.993426e-04
Rgh_53_1 g_53_1 g_54_1 4.993426e-04
Rgv_53_1 g_53_1 g_53_2 4.993426e-04
Rgh_53_2 g_53_2 g_54_2 4.993426e-04
Rgv_53_2 g_53_2 g_53_3 4.993426e-04
Rgh_53_3 g_53_3 g_54_3 4.993426e-04
Rgv_53_3 g_53_3 g_53_4 4.993426e-04
Rgh_53_4 g_53_4 g_54_4 4.993426e-04
Rgv_53_4 g_53_4 g_53_5 4.993426e-04
Rgh_53_5 g_53_5 g_54_5 4.993426e-04
Rgv_53_5 g_53_5 g_53_6 4.993426e-04
Rgh_53_6 g_53_6 g_54_6 4.993426e-04
Rgv_53_6 g_53_6 g_53_7 4.993426e-04
Rgh_53_7 g_53_7 g_54_7 4.993426e-04
Rgv_53_7 g_53_7 g_53_8 4.993426e-04
Rgh_53_8 g_53_8 g_54_8 4.993426e-04
Rgv_53_8 g_53_8 g_53_9 4.993426e-04
Rgh_53_9 g_53_9 g_54_9 4.993426e-04
Rgv_53_9 g_53_9 g_53_10 4.993426e-04
Rgh_53_10 g_53_10 g_54_10 4.993426e-04
Rgv_53_10 g_53_10 g_53_11 4.993426e-04
Rgh_53_11 g_53_11 g_54_11 4.993426e-04
Rgv_53_11 g_53_11 g_53_12 4.993426e-04
Rgh_53_12 g_53_12 g_54_12 4.993426e-04
Rgv_53_12 g_53_12 g_53_13 4.993426e-04
Rgh_53_13 g_53_13 g_54_13 4.993426e-04
Rgv_53_13 g_53_13 g_53_14 4.993426e-04
Rgh_53_14 g_53_14 g_54_14 4.993426e-04
Rgv_53_14 g_53_14 g_53_15 4.993426e-04
Rgh_53_15 g_53_15 g_54_15 4.993426e-04
Rgv_53_15 g_53_15 g_53_16 4.993426e-04
Rgh_53_16 g_53_16 g_54_16 4.993426e-04
Rgv_53_16 g_53_16 g_53_17 4.993426e-04
Rgh_53_17 g_53_17 g_54_17 4.993426e-04
Rgv_53_17 g_53_17 g_53_18 4.993426e-04
Rgh_53_18 g_53_18 g_54_18 4.993426e-04
Rgv_53_18 g_53_18 g_53_19 4.993426e-04
Rgh_53_19 g_53_19 g_54_19 4.993426e-04
Rgv_53_19 g_53_19 g_53_20 4.993426e-04
Rgh_53_20 g_53_20 g_54_20 4.993426e-04
Rgv_53_20 g_53_20 g_53_21 4.993426e-04
Rgh_53_21 g_53_21 g_54_21 4.993426e-04
Rgv_53_21 g_53_21 g_53_22 4.993426e-04
Rgh_53_22 g_53_22 g_54_22 4.993426e-04
Rgv_53_22 g_53_22 g_53_23 4.993426e-04
Rgh_53_23 g_53_23 g_54_23 4.993426e-04
Rgv_53_23 g_53_23 g_53_24 4.993426e-04
Rgh_53_24 g_53_24 g_54_24 4.993426e-04
Rgv_53_24 g_53_24 g_53_25 4.993426e-04
Rgh_53_25 g_53_25 g_54_25 4.993426e-04
Rgv_53_25 g_53_25 g_53_26 4.993426e-04
Rgh_53_26 g_53_26 g_54_26 4.993426e-04
Rgv_53_26 g_53_26 g_53_27 4.993426e-04
Rgh_53_27 g_53_27 g_54_27 4.993426e-04
Rgv_53_27 g_53_27 g_53_28 4.993426e-04
Rgh_53_28 g_53_28 g_54_28 4.993426e-04
Rgv_53_28 g_53_28 g_53_29 4.993426e-04
Rgh_53_29 g_53_29 g_54_29 4.993426e-04
Rgv_53_29 g_53_29 g_53_30 4.993426e-04
Rgh_53_30 g_53_30 g_54_30 4.993426e-04
Rgv_53_30 g_53_30 g_53_31 4.993426e-04
Rgh_53_31 g_53_31 g_54_31 4.993426e-04
Rgv_53_31 g_53_31 g_53_32 4.993426e-04
Rgh_53_32 g_53_32 g_54_32 4.993426e-04
Rgv_53_32 g_53_32 g_53_33 4.993426e-04
Rgh_53_33 g_53_33 g_54_33 4.993426e-04
Rgv_53_33 g_53_33 g_53_34 4.993426e-04
Rgh_53_34 g_53_34 g_54_34 4.993426e-04
Rgv_53_34 g_53_34 g_53_35 4.993426e-04
Rgh_53_35 g_53_35 g_54_35 4.993426e-04
Rgv_53_35 g_53_35 g_53_36 4.993426e-04
Rgh_53_36 g_53_36 g_54_36 4.993426e-04
Rgv_53_36 g_53_36 g_53_37 4.993426e-04
Rgh_53_37 g_53_37 g_54_37 4.993426e-04
Rgv_53_37 g_53_37 g_53_38 4.993426e-04
Rgh_53_38 g_53_38 g_54_38 4.993426e-04
Rgv_53_38 g_53_38 g_53_39 4.993426e-04
Rgh_53_39 g_53_39 g_54_39 4.993426e-04
Rgv_53_39 g_53_39 g_53_40 4.993426e-04
Rgh_53_40 g_53_40 g_54_40 4.993426e-04
Rgv_53_40 g_53_40 g_53_41 4.993426e-04
Rgh_53_41 g_53_41 g_54_41 4.993426e-04
Rgv_53_41 g_53_41 g_53_42 4.993426e-04
Rgh_53_42 g_53_42 g_54_42 4.993426e-04
Rgv_53_42 g_53_42 g_53_43 4.993426e-04
Rgh_53_43 g_53_43 g_54_43 4.993426e-04
Rgv_53_43 g_53_43 g_53_44 4.993426e-04
Rgh_53_44 g_53_44 g_54_44 4.993426e-04
Rgv_53_44 g_53_44 g_53_45 4.993426e-04
Rgh_53_45 g_53_45 g_54_45 4.993426e-04
Rgv_53_45 g_53_45 g_53_46 4.993426e-04
Rgh_53_46 g_53_46 g_54_46 4.993426e-04
Rgv_53_46 g_53_46 g_53_47 4.993426e-04
Rgh_53_47 g_53_47 g_54_47 4.993426e-04
Rgv_53_47 g_53_47 g_53_48 4.993426e-04
Rgh_53_48 g_53_48 g_54_48 4.993426e-04
Rgv_53_48 g_53_48 g_53_49 4.993426e-04
Rgh_53_49 g_53_49 g_54_49 4.993426e-04
Rgv_53_49 g_53_49 g_53_50 4.993426e-04
Rgh_53_50 g_53_50 g_54_50 4.993426e-04
Rgv_53_50 g_53_50 g_53_51 4.993426e-04
Rgh_53_51 g_53_51 g_54_51 4.993426e-04
Rgv_53_51 g_53_51 g_53_52 4.993426e-04
Rgh_53_52 g_53_52 g_54_52 4.993426e-04
Rgv_53_52 g_53_52 g_53_53 4.993426e-04
Rgh_53_53 g_53_53 g_54_53 4.993426e-04
Rgv_53_53 g_53_53 g_53_54 4.993426e-04
Rgh_53_54 g_53_54 g_54_54 4.993426e-04
Rgv_53_54 g_53_54 g_53_55 4.993426e-04
Rgh_53_55 g_53_55 g_54_55 4.993426e-04
Rgv_53_55 g_53_55 g_53_56 4.993426e-04
Rgh_53_56 g_53_56 g_54_56 4.993426e-04
Rgv_53_56 g_53_56 g_53_57 4.993426e-04
Rgh_53_57 g_53_57 g_54_57 4.993426e-04
Rgv_53_57 g_53_57 g_53_58 4.993426e-04
Rgh_53_58 g_53_58 g_54_58 4.993426e-04
Rgv_53_58 g_53_58 g_53_59 4.993426e-04
Rgh_53_59 g_53_59 g_54_59 4.993426e-04
Rgv_53_59 g_53_59 g_53_60 4.993426e-04
Rgh_53_60 g_53_60 g_54_60 4.993426e-04
Rgv_53_60 g_53_60 g_53_61 4.993426e-04
Rgh_53_61 g_53_61 g_54_61 4.993426e-04
Rgv_53_61 g_53_61 g_53_62 4.993426e-04
Rgh_53_62 g_53_62 g_54_62 4.993426e-04
Rgv_53_62 g_53_62 g_53_63 4.993426e-04
Rgh_53_63 g_53_63 g_54_63 4.993426e-04
Rgv_53_63 g_53_63 g_53_64 4.993426e-04
Rgh_53_64 g_53_64 g_54_64 4.993426e-04
Rgv_53_64 g_53_64 g_53_65 4.993426e-04
Rgh_53_65 g_53_65 g_54_65 4.993426e-04
Rgv_53_65 g_53_65 g_53_66 4.993426e-04
Rgh_53_66 g_53_66 g_54_66 4.993426e-04
Rgv_53_66 g_53_66 g_53_67 4.993426e-04
Rgh_53_67 g_53_67 g_54_67 4.993426e-04
Rgv_53_67 g_53_67 g_53_68 4.993426e-04
Rgh_53_68 g_53_68 g_54_68 4.993426e-04
Rgv_53_68 g_53_68 g_53_69 4.993426e-04
Rgh_53_69 g_53_69 g_54_69 4.993426e-04
Rgv_53_69 g_53_69 g_53_70 4.993426e-04
Rgh_53_70 g_53_70 g_54_70 4.993426e-04
Rgv_53_70 g_53_70 g_53_71 4.993426e-04
Rgh_53_71 g_53_71 g_54_71 4.993426e-04
Rgh_54_0 g_54_0 g_55_0 4.993426e-04
Rgv_54_0 g_54_0 g_54_1 4.993426e-04
Rgh_54_1 g_54_1 g_55_1 4.993426e-04
Rgv_54_1 g_54_1 g_54_2 4.993426e-04
Rgh_54_2 g_54_2 g_55_2 4.993426e-04
Rgv_54_2 g_54_2 g_54_3 4.993426e-04
Rgh_54_3 g_54_3 g_55_3 4.993426e-04
Rgv_54_3 g_54_3 g_54_4 4.993426e-04
Rgh_54_4 g_54_4 g_55_4 4.993426e-04
Rgv_54_4 g_54_4 g_54_5 4.993426e-04
Rgh_54_5 g_54_5 g_55_5 4.993426e-04
Rgv_54_5 g_54_5 g_54_6 4.993426e-04
Rgh_54_6 g_54_6 g_55_6 4.993426e-04
Rgv_54_6 g_54_6 g_54_7 4.993426e-04
Rgh_54_7 g_54_7 g_55_7 4.993426e-04
Rgv_54_7 g_54_7 g_54_8 4.993426e-04
Rgh_54_8 g_54_8 g_55_8 4.993426e-04
Rgv_54_8 g_54_8 g_54_9 4.993426e-04
Rgh_54_9 g_54_9 g_55_9 4.993426e-04
Rgv_54_9 g_54_9 g_54_10 4.993426e-04
Rgh_54_10 g_54_10 g_55_10 4.993426e-04
Rgv_54_10 g_54_10 g_54_11 4.993426e-04
Rgh_54_11 g_54_11 g_55_11 4.993426e-04
Rgv_54_11 g_54_11 g_54_12 4.993426e-04
Rgh_54_12 g_54_12 g_55_12 4.993426e-04
Rgv_54_12 g_54_12 g_54_13 4.993426e-04
Rgh_54_13 g_54_13 g_55_13 4.993426e-04
Rgv_54_13 g_54_13 g_54_14 4.993426e-04
Rgh_54_14 g_54_14 g_55_14 4.993426e-04
Rgv_54_14 g_54_14 g_54_15 4.993426e-04
Rgh_54_15 g_54_15 g_55_15 4.993426e-04
Rgv_54_15 g_54_15 g_54_16 4.993426e-04
Rgh_54_16 g_54_16 g_55_16 4.993426e-04
Rgv_54_16 g_54_16 g_54_17 4.993426e-04
Rgh_54_17 g_54_17 g_55_17 4.993426e-04
Rgv_54_17 g_54_17 g_54_18 4.993426e-04
Rgh_54_18 g_54_18 g_55_18 4.993426e-04
Rgv_54_18 g_54_18 g_54_19 4.993426e-04
Rgh_54_19 g_54_19 g_55_19 4.993426e-04
Rgv_54_19 g_54_19 g_54_20 4.993426e-04
Rgh_54_20 g_54_20 g_55_20 4.993426e-04
Rgv_54_20 g_54_20 g_54_21 4.993426e-04
Rgh_54_21 g_54_21 g_55_21 4.993426e-04
Rgv_54_21 g_54_21 g_54_22 4.993426e-04
Rgh_54_22 g_54_22 g_55_22 4.993426e-04
Rgv_54_22 g_54_22 g_54_23 4.993426e-04
Rgh_54_23 g_54_23 g_55_23 4.993426e-04
Rgv_54_23 g_54_23 g_54_24 4.993426e-04
Rgh_54_24 g_54_24 g_55_24 4.993426e-04
Rgv_54_24 g_54_24 g_54_25 4.993426e-04
Rgh_54_25 g_54_25 g_55_25 4.993426e-04
Rgv_54_25 g_54_25 g_54_26 4.993426e-04
Rgh_54_26 g_54_26 g_55_26 4.993426e-04
Rgv_54_26 g_54_26 g_54_27 4.993426e-04
Rgh_54_27 g_54_27 g_55_27 4.993426e-04
Rgv_54_27 g_54_27 g_54_28 4.993426e-04
Rgh_54_28 g_54_28 g_55_28 4.993426e-04
Rgv_54_28 g_54_28 g_54_29 4.993426e-04
Rgh_54_29 g_54_29 g_55_29 4.993426e-04
Rgv_54_29 g_54_29 g_54_30 4.993426e-04
Rgh_54_30 g_54_30 g_55_30 4.993426e-04
Rgv_54_30 g_54_30 g_54_31 4.993426e-04
Rgh_54_31 g_54_31 g_55_31 4.993426e-04
Rgv_54_31 g_54_31 g_54_32 4.993426e-04
Rgh_54_32 g_54_32 g_55_32 4.993426e-04
Rgv_54_32 g_54_32 g_54_33 4.993426e-04
Rgh_54_33 g_54_33 g_55_33 4.993426e-04
Rgv_54_33 g_54_33 g_54_34 4.993426e-04
Rgh_54_34 g_54_34 g_55_34 4.993426e-04
Rgv_54_34 g_54_34 g_54_35 4.993426e-04
Rgh_54_35 g_54_35 g_55_35 4.993426e-04
Rgv_54_35 g_54_35 g_54_36 4.993426e-04
Rgh_54_36 g_54_36 g_55_36 4.993426e-04
Rgv_54_36 g_54_36 g_54_37 4.993426e-04
Rgh_54_37 g_54_37 g_55_37 4.993426e-04
Rgv_54_37 g_54_37 g_54_38 4.993426e-04
Rgh_54_38 g_54_38 g_55_38 4.993426e-04
Rgv_54_38 g_54_38 g_54_39 4.993426e-04
Rgh_54_39 g_54_39 g_55_39 4.993426e-04
Rgv_54_39 g_54_39 g_54_40 4.993426e-04
Rgh_54_40 g_54_40 g_55_40 4.993426e-04
Rgv_54_40 g_54_40 g_54_41 4.993426e-04
Rgh_54_41 g_54_41 g_55_41 4.993426e-04
Rgv_54_41 g_54_41 g_54_42 4.993426e-04
Rgh_54_42 g_54_42 g_55_42 4.993426e-04
Rgv_54_42 g_54_42 g_54_43 4.993426e-04
Rgh_54_43 g_54_43 g_55_43 4.993426e-04
Rgv_54_43 g_54_43 g_54_44 4.993426e-04
Rgh_54_44 g_54_44 g_55_44 4.993426e-04
Rgv_54_44 g_54_44 g_54_45 4.993426e-04
Rgh_54_45 g_54_45 g_55_45 4.993426e-04
Rgv_54_45 g_54_45 g_54_46 4.993426e-04
Rgh_54_46 g_54_46 g_55_46 4.993426e-04
Rgv_54_46 g_54_46 g_54_47 4.993426e-04
Rgh_54_47 g_54_47 g_55_47 4.993426e-04
Rgv_54_47 g_54_47 g_54_48 4.993426e-04
Rgh_54_48 g_54_48 g_55_48 4.993426e-04
Rgv_54_48 g_54_48 g_54_49 4.993426e-04
Rgh_54_49 g_54_49 g_55_49 4.993426e-04
Rgv_54_49 g_54_49 g_54_50 4.993426e-04
Rgh_54_50 g_54_50 g_55_50 4.993426e-04
Rgv_54_50 g_54_50 g_54_51 4.993426e-04
Rgh_54_51 g_54_51 g_55_51 4.993426e-04
Rgv_54_51 g_54_51 g_54_52 4.993426e-04
Rgh_54_52 g_54_52 g_55_52 4.993426e-04
Rgv_54_52 g_54_52 g_54_53 4.993426e-04
Rgh_54_53 g_54_53 g_55_53 4.993426e-04
Rgv_54_53 g_54_53 g_54_54 4.993426e-04
Rgh_54_54 g_54_54 g_55_54 4.993426e-04
Rgv_54_54 g_54_54 g_54_55 4.993426e-04
Rgh_54_55 g_54_55 g_55_55 4.993426e-04
Rgv_54_55 g_54_55 g_54_56 4.993426e-04
Rgh_54_56 g_54_56 g_55_56 4.993426e-04
Rgv_54_56 g_54_56 g_54_57 4.993426e-04
Rgh_54_57 g_54_57 g_55_57 4.993426e-04
Rgv_54_57 g_54_57 g_54_58 4.993426e-04
Rgh_54_58 g_54_58 g_55_58 4.993426e-04
Rgv_54_58 g_54_58 g_54_59 4.993426e-04
Rgh_54_59 g_54_59 g_55_59 4.993426e-04
Rgv_54_59 g_54_59 g_54_60 4.993426e-04
Rgh_54_60 g_54_60 g_55_60 4.993426e-04
Rgv_54_60 g_54_60 g_54_61 4.993426e-04
Rgh_54_61 g_54_61 g_55_61 4.993426e-04
Rgv_54_61 g_54_61 g_54_62 4.993426e-04
Rgh_54_62 g_54_62 g_55_62 4.993426e-04
Rgv_54_62 g_54_62 g_54_63 4.993426e-04
Rgh_54_63 g_54_63 g_55_63 4.993426e-04
Rgv_54_63 g_54_63 g_54_64 4.993426e-04
Rgh_54_64 g_54_64 g_55_64 4.993426e-04
Rgv_54_64 g_54_64 g_54_65 4.993426e-04
Rgh_54_65 g_54_65 g_55_65 4.993426e-04
Rgv_54_65 g_54_65 g_54_66 4.993426e-04
Rgh_54_66 g_54_66 g_55_66 4.993426e-04
Rgv_54_66 g_54_66 g_54_67 4.993426e-04
Rgh_54_67 g_54_67 g_55_67 4.993426e-04
Rgv_54_67 g_54_67 g_54_68 4.993426e-04
Rgh_54_68 g_54_68 g_55_68 4.993426e-04
Rgv_54_68 g_54_68 g_54_69 4.993426e-04
Rgh_54_69 g_54_69 g_55_69 4.993426e-04
Rgv_54_69 g_54_69 g_54_70 4.993426e-04
Rgh_54_70 g_54_70 g_55_70 4.993426e-04
Rgv_54_70 g_54_70 g_54_71 4.993426e-04
Rgh_54_71 g_54_71 g_55_71 4.993426e-04
Rgh_55_0 g_55_0 g_56_0 4.993426e-04
Rgv_55_0 g_55_0 g_55_1 4.993426e-04
Rgh_55_1 g_55_1 g_56_1 4.993426e-04
Rgv_55_1 g_55_1 g_55_2 4.993426e-04
Rgh_55_2 g_55_2 g_56_2 4.993426e-04
Rgv_55_2 g_55_2 g_55_3 4.993426e-04
Rgh_55_3 g_55_3 g_56_3 4.993426e-04
Rgv_55_3 g_55_3 g_55_4 4.993426e-04
Rgh_55_4 g_55_4 g_56_4 4.993426e-04
Rgv_55_4 g_55_4 g_55_5 4.993426e-04
Rgh_55_5 g_55_5 g_56_5 4.993426e-04
Rgv_55_5 g_55_5 g_55_6 4.993426e-04
Rgh_55_6 g_55_6 g_56_6 4.993426e-04
Rgv_55_6 g_55_6 g_55_7 4.993426e-04
Rgh_55_7 g_55_7 g_56_7 4.993426e-04
Rgv_55_7 g_55_7 g_55_8 4.993426e-04
Rgh_55_8 g_55_8 g_56_8 4.993426e-04
Rgv_55_8 g_55_8 g_55_9 4.993426e-04
Rgh_55_9 g_55_9 g_56_9 4.993426e-04
Rgv_55_9 g_55_9 g_55_10 4.993426e-04
Rgh_55_10 g_55_10 g_56_10 4.993426e-04
Rgv_55_10 g_55_10 g_55_11 4.993426e-04
Rgh_55_11 g_55_11 g_56_11 4.993426e-04
Rgv_55_11 g_55_11 g_55_12 4.993426e-04
Rgh_55_12 g_55_12 g_56_12 4.993426e-04
Rgv_55_12 g_55_12 g_55_13 4.993426e-04
Rgh_55_13 g_55_13 g_56_13 4.993426e-04
Rgv_55_13 g_55_13 g_55_14 4.993426e-04
Rgh_55_14 g_55_14 g_56_14 4.993426e-04
Rgv_55_14 g_55_14 g_55_15 4.993426e-04
Rgh_55_15 g_55_15 g_56_15 4.993426e-04
Rgv_55_15 g_55_15 g_55_16 4.993426e-04
Rgh_55_16 g_55_16 g_56_16 4.993426e-04
Rgv_55_16 g_55_16 g_55_17 4.993426e-04
Rgh_55_17 g_55_17 g_56_17 4.993426e-04
Rgv_55_17 g_55_17 g_55_18 4.993426e-04
Rgh_55_18 g_55_18 g_56_18 4.993426e-04
Rgv_55_18 g_55_18 g_55_19 4.993426e-04
Rgh_55_19 g_55_19 g_56_19 4.993426e-04
Rgv_55_19 g_55_19 g_55_20 4.993426e-04
Rgh_55_20 g_55_20 g_56_20 4.993426e-04
Rgv_55_20 g_55_20 g_55_21 4.993426e-04
Rgh_55_21 g_55_21 g_56_21 4.993426e-04
Rgv_55_21 g_55_21 g_55_22 4.993426e-04
Rgh_55_22 g_55_22 g_56_22 4.993426e-04
Rgv_55_22 g_55_22 g_55_23 4.993426e-04
Rgh_55_23 g_55_23 g_56_23 4.993426e-04
Rgv_55_23 g_55_23 g_55_24 4.993426e-04
Rgh_55_24 g_55_24 g_56_24 4.993426e-04
Rgv_55_24 g_55_24 g_55_25 4.993426e-04
Rgh_55_25 g_55_25 g_56_25 4.993426e-04
Rgv_55_25 g_55_25 g_55_26 4.993426e-04
Rgh_55_26 g_55_26 g_56_26 4.993426e-04
Rgv_55_26 g_55_26 g_55_27 4.993426e-04
Rgh_55_27 g_55_27 g_56_27 4.993426e-04
Rgv_55_27 g_55_27 g_55_28 4.993426e-04
Rgh_55_28 g_55_28 g_56_28 4.993426e-04
Rgv_55_28 g_55_28 g_55_29 4.993426e-04
Rgh_55_29 g_55_29 g_56_29 4.993426e-04
Rgv_55_29 g_55_29 g_55_30 4.993426e-04
Rgh_55_30 g_55_30 g_56_30 4.993426e-04
Rgv_55_30 g_55_30 g_55_31 4.993426e-04
Rgh_55_31 g_55_31 g_56_31 4.993426e-04
Rgv_55_31 g_55_31 g_55_32 4.993426e-04
Rgh_55_32 g_55_32 g_56_32 4.993426e-04
Rgv_55_32 g_55_32 g_55_33 4.993426e-04
Rgh_55_33 g_55_33 g_56_33 4.993426e-04
Rgv_55_33 g_55_33 g_55_34 4.993426e-04
Rgh_55_34 g_55_34 g_56_34 4.993426e-04
Rgv_55_34 g_55_34 g_55_35 4.993426e-04
Rgh_55_35 g_55_35 g_56_35 4.993426e-04
Rgv_55_35 g_55_35 g_55_36 4.993426e-04
Rgh_55_36 g_55_36 g_56_36 4.993426e-04
Rgv_55_36 g_55_36 g_55_37 4.993426e-04
Rgh_55_37 g_55_37 g_56_37 4.993426e-04
Rgv_55_37 g_55_37 g_55_38 4.993426e-04
Rgh_55_38 g_55_38 g_56_38 4.993426e-04
Rgv_55_38 g_55_38 g_55_39 4.993426e-04
Rgh_55_39 g_55_39 g_56_39 4.993426e-04
Rgv_55_39 g_55_39 g_55_40 4.993426e-04
Rgh_55_40 g_55_40 g_56_40 4.993426e-04
Rgv_55_40 g_55_40 g_55_41 4.993426e-04
Rgh_55_41 g_55_41 g_56_41 4.993426e-04
Rgv_55_41 g_55_41 g_55_42 4.993426e-04
Rgh_55_42 g_55_42 g_56_42 4.993426e-04
Rgv_55_42 g_55_42 g_55_43 4.993426e-04
Rgh_55_43 g_55_43 g_56_43 4.993426e-04
Rgv_55_43 g_55_43 g_55_44 4.993426e-04
Rgh_55_44 g_55_44 g_56_44 4.993426e-04
Rgv_55_44 g_55_44 g_55_45 4.993426e-04
Rgh_55_45 g_55_45 g_56_45 4.993426e-04
Rgv_55_45 g_55_45 g_55_46 4.993426e-04
Rgh_55_46 g_55_46 g_56_46 4.993426e-04
Rgv_55_46 g_55_46 g_55_47 4.993426e-04
Rgh_55_47 g_55_47 g_56_47 4.993426e-04
Rgv_55_47 g_55_47 g_55_48 4.993426e-04
Rgh_55_48 g_55_48 g_56_48 4.993426e-04
Rgv_55_48 g_55_48 g_55_49 4.993426e-04
Rgh_55_49 g_55_49 g_56_49 4.993426e-04
Rgv_55_49 g_55_49 g_55_50 4.993426e-04
Rgh_55_50 g_55_50 g_56_50 4.993426e-04
Rgv_55_50 g_55_50 g_55_51 4.993426e-04
Rgh_55_51 g_55_51 g_56_51 4.993426e-04
Rgv_55_51 g_55_51 g_55_52 4.993426e-04
Rgh_55_52 g_55_52 g_56_52 4.993426e-04
Rgv_55_52 g_55_52 g_55_53 4.993426e-04
Rgh_55_53 g_55_53 g_56_53 4.993426e-04
Rgv_55_53 g_55_53 g_55_54 4.993426e-04
Rgh_55_54 g_55_54 g_56_54 4.993426e-04
Rgv_55_54 g_55_54 g_55_55 4.993426e-04
Rgh_55_55 g_55_55 g_56_55 4.993426e-04
Rgv_55_55 g_55_55 g_55_56 4.993426e-04
Rgh_55_56 g_55_56 g_56_56 4.993426e-04
Rgv_55_56 g_55_56 g_55_57 4.993426e-04
Rgh_55_57 g_55_57 g_56_57 4.993426e-04
Rgv_55_57 g_55_57 g_55_58 4.993426e-04
Rgh_55_58 g_55_58 g_56_58 4.993426e-04
Rgv_55_58 g_55_58 g_55_59 4.993426e-04
Rgh_55_59 g_55_59 g_56_59 4.993426e-04
Rgv_55_59 g_55_59 g_55_60 4.993426e-04
Rgh_55_60 g_55_60 g_56_60 4.993426e-04
Rgv_55_60 g_55_60 g_55_61 4.993426e-04
Rgh_55_61 g_55_61 g_56_61 4.993426e-04
Rgv_55_61 g_55_61 g_55_62 4.993426e-04
Rgh_55_62 g_55_62 g_56_62 4.993426e-04
Rgv_55_62 g_55_62 g_55_63 4.993426e-04
Rgh_55_63 g_55_63 g_56_63 4.993426e-04
Rgv_55_63 g_55_63 g_55_64 4.993426e-04
Rgh_55_64 g_55_64 g_56_64 4.993426e-04
Rgv_55_64 g_55_64 g_55_65 4.993426e-04
Rgh_55_65 g_55_65 g_56_65 4.993426e-04
Rgv_55_65 g_55_65 g_55_66 4.993426e-04
Rgh_55_66 g_55_66 g_56_66 4.993426e-04
Rgv_55_66 g_55_66 g_55_67 4.993426e-04
Rgh_55_67 g_55_67 g_56_67 4.993426e-04
Rgv_55_67 g_55_67 g_55_68 4.993426e-04
Rgh_55_68 g_55_68 g_56_68 4.993426e-04
Rgv_55_68 g_55_68 g_55_69 4.993426e-04
Rgh_55_69 g_55_69 g_56_69 4.993426e-04
Rgv_55_69 g_55_69 g_55_70 4.993426e-04
Rgh_55_70 g_55_70 g_56_70 4.993426e-04
Rgv_55_70 g_55_70 g_55_71 4.993426e-04
Rgh_55_71 g_55_71 g_56_71 4.993426e-04
Rgh_56_0 g_56_0 g_57_0 4.993426e-04
Rgv_56_0 g_56_0 g_56_1 4.993426e-04
Rgh_56_1 g_56_1 g_57_1 4.993426e-04
Rgv_56_1 g_56_1 g_56_2 4.993426e-04
Rgh_56_2 g_56_2 g_57_2 4.993426e-04
Rgv_56_2 g_56_2 g_56_3 4.993426e-04
Rgh_56_3 g_56_3 g_57_3 4.993426e-04
Rgv_56_3 g_56_3 g_56_4 4.993426e-04
Rgh_56_4 g_56_4 g_57_4 4.993426e-04
Rgv_56_4 g_56_4 g_56_5 4.993426e-04
Rgh_56_5 g_56_5 g_57_5 4.993426e-04
Rgv_56_5 g_56_5 g_56_6 4.993426e-04
Rgh_56_6 g_56_6 g_57_6 4.993426e-04
Rgv_56_6 g_56_6 g_56_7 4.993426e-04
Rgh_56_7 g_56_7 g_57_7 4.993426e-04
Rgv_56_7 g_56_7 g_56_8 4.993426e-04
Rgh_56_8 g_56_8 g_57_8 4.993426e-04
Rgv_56_8 g_56_8 g_56_9 4.993426e-04
Rgh_56_9 g_56_9 g_57_9 4.993426e-04
Rgv_56_9 g_56_9 g_56_10 4.993426e-04
Rgh_56_10 g_56_10 g_57_10 4.993426e-04
Rgv_56_10 g_56_10 g_56_11 4.993426e-04
Rgh_56_11 g_56_11 g_57_11 4.993426e-04
Rgv_56_11 g_56_11 g_56_12 4.993426e-04
Rgh_56_12 g_56_12 g_57_12 4.993426e-04
Rgv_56_12 g_56_12 g_56_13 4.993426e-04
Rgh_56_13 g_56_13 g_57_13 4.993426e-04
Rgv_56_13 g_56_13 g_56_14 4.993426e-04
Rgh_56_14 g_56_14 g_57_14 4.993426e-04
Rgv_56_14 g_56_14 g_56_15 4.993426e-04
Rgh_56_15 g_56_15 g_57_15 4.993426e-04
Rgv_56_15 g_56_15 g_56_16 4.993426e-04
Rgh_56_16 g_56_16 g_57_16 4.993426e-04
Rgv_56_16 g_56_16 g_56_17 4.993426e-04
Rgh_56_17 g_56_17 g_57_17 4.993426e-04
Rgv_56_17 g_56_17 g_56_18 4.993426e-04
Rgh_56_18 g_56_18 g_57_18 4.993426e-04
Rgv_56_18 g_56_18 g_56_19 4.993426e-04
Rgh_56_19 g_56_19 g_57_19 4.993426e-04
Rgv_56_19 g_56_19 g_56_20 4.993426e-04
Rgh_56_20 g_56_20 g_57_20 4.993426e-04
Rgv_56_20 g_56_20 g_56_21 4.993426e-04
Rgh_56_21 g_56_21 g_57_21 4.993426e-04
Rgv_56_21 g_56_21 g_56_22 4.993426e-04
Rgh_56_22 g_56_22 g_57_22 4.993426e-04
Rgv_56_22 g_56_22 g_56_23 4.993426e-04
Rgh_56_23 g_56_23 g_57_23 4.993426e-04
Rgv_56_23 g_56_23 g_56_24 4.993426e-04
Rgh_56_24 g_56_24 g_57_24 4.993426e-04
Rgv_56_24 g_56_24 g_56_25 4.993426e-04
Rgh_56_25 g_56_25 g_57_25 4.993426e-04
Rgv_56_25 g_56_25 g_56_26 4.993426e-04
Rgh_56_26 g_56_26 g_57_26 4.993426e-04
Rgv_56_26 g_56_26 g_56_27 4.993426e-04
Rgh_56_27 g_56_27 g_57_27 4.993426e-04
Rgv_56_27 g_56_27 g_56_28 4.993426e-04
Rgh_56_28 g_56_28 g_57_28 4.993426e-04
Rgv_56_28 g_56_28 g_56_29 4.993426e-04
Rgh_56_29 g_56_29 g_57_29 4.993426e-04
Rgv_56_29 g_56_29 g_56_30 4.993426e-04
Rgh_56_30 g_56_30 g_57_30 4.993426e-04
Rgv_56_30 g_56_30 g_56_31 4.993426e-04
Rgh_56_31 g_56_31 g_57_31 4.993426e-04
Rgv_56_31 g_56_31 g_56_32 4.993426e-04
Rgh_56_32 g_56_32 g_57_32 4.993426e-04
Rgv_56_32 g_56_32 g_56_33 4.993426e-04
Rgh_56_33 g_56_33 g_57_33 4.993426e-04
Rgv_56_33 g_56_33 g_56_34 4.993426e-04
Rgh_56_34 g_56_34 g_57_34 4.993426e-04
Rgv_56_34 g_56_34 g_56_35 4.993426e-04
Rgh_56_35 g_56_35 g_57_35 4.993426e-04
Rgv_56_35 g_56_35 g_56_36 4.993426e-04
Rgh_56_36 g_56_36 g_57_36 4.993426e-04
Rgv_56_36 g_56_36 g_56_37 4.993426e-04
Rgh_56_37 g_56_37 g_57_37 4.993426e-04
Rgv_56_37 g_56_37 g_56_38 4.993426e-04
Rgh_56_38 g_56_38 g_57_38 4.993426e-04
Rgv_56_38 g_56_38 g_56_39 4.993426e-04
Rgh_56_39 g_56_39 g_57_39 4.993426e-04
Rgv_56_39 g_56_39 g_56_40 4.993426e-04
Rgh_56_40 g_56_40 g_57_40 4.993426e-04
Rgv_56_40 g_56_40 g_56_41 4.993426e-04
Rgh_56_41 g_56_41 g_57_41 4.993426e-04
Rgv_56_41 g_56_41 g_56_42 4.993426e-04
Rgh_56_42 g_56_42 g_57_42 4.993426e-04
Rgv_56_42 g_56_42 g_56_43 4.993426e-04
Rgh_56_43 g_56_43 g_57_43 4.993426e-04
Rgv_56_43 g_56_43 g_56_44 4.993426e-04
Rgh_56_44 g_56_44 g_57_44 4.993426e-04
Rgv_56_44 g_56_44 g_56_45 4.993426e-04
Rgh_56_45 g_56_45 g_57_45 4.993426e-04
Rgv_56_45 g_56_45 g_56_46 4.993426e-04
Rgh_56_46 g_56_46 g_57_46 4.993426e-04
Rgv_56_46 g_56_46 g_56_47 4.993426e-04
Rgh_56_47 g_56_47 g_57_47 4.993426e-04
Rgv_56_47 g_56_47 g_56_48 4.993426e-04
Rgh_56_48 g_56_48 g_57_48 4.993426e-04
Rgv_56_48 g_56_48 g_56_49 4.993426e-04
Rgh_56_49 g_56_49 g_57_49 4.993426e-04
Rgv_56_49 g_56_49 g_56_50 4.993426e-04
Rgh_56_50 g_56_50 g_57_50 4.993426e-04
Rgv_56_50 g_56_50 g_56_51 4.993426e-04
Rgh_56_51 g_56_51 g_57_51 4.993426e-04
Rgv_56_51 g_56_51 g_56_52 4.993426e-04
Rgh_56_52 g_56_52 g_57_52 4.993426e-04
Rgv_56_52 g_56_52 g_56_53 4.993426e-04
Rgh_56_53 g_56_53 g_57_53 4.993426e-04
Rgv_56_53 g_56_53 g_56_54 4.993426e-04
Rgh_56_54 g_56_54 g_57_54 4.993426e-04
Rgv_56_54 g_56_54 g_56_55 4.993426e-04
Rgh_56_55 g_56_55 g_57_55 4.993426e-04
Rgv_56_55 g_56_55 g_56_56 4.993426e-04
Rgh_56_56 g_56_56 g_57_56 4.993426e-04
Rgv_56_56 g_56_56 g_56_57 4.993426e-04
Rgh_56_57 g_56_57 g_57_57 4.993426e-04
Rgv_56_57 g_56_57 g_56_58 4.993426e-04
Rgh_56_58 g_56_58 g_57_58 4.993426e-04
Rgv_56_58 g_56_58 g_56_59 4.993426e-04
Rgh_56_59 g_56_59 g_57_59 4.993426e-04
Rgv_56_59 g_56_59 g_56_60 4.993426e-04
Rgh_56_60 g_56_60 g_57_60 4.993426e-04
Rgv_56_60 g_56_60 g_56_61 4.993426e-04
Rgh_56_61 g_56_61 g_57_61 4.993426e-04
Rgv_56_61 g_56_61 g_56_62 4.993426e-04
Rgh_56_62 g_56_62 g_57_62 4.993426e-04
Rgv_56_62 g_56_62 g_56_63 4.993426e-04
Rgh_56_63 g_56_63 g_57_63 4.993426e-04
Rgv_56_63 g_56_63 g_56_64 4.993426e-04
Rgh_56_64 g_56_64 g_57_64 4.993426e-04
Rgv_56_64 g_56_64 g_56_65 4.993426e-04
Rgh_56_65 g_56_65 g_57_65 4.993426e-04
Rgv_56_65 g_56_65 g_56_66 4.993426e-04
Rgh_56_66 g_56_66 g_57_66 4.993426e-04
Rgv_56_66 g_56_66 g_56_67 4.993426e-04
Rgh_56_67 g_56_67 g_57_67 4.993426e-04
Rgv_56_67 g_56_67 g_56_68 4.993426e-04
Rgh_56_68 g_56_68 g_57_68 4.993426e-04
Rgv_56_68 g_56_68 g_56_69 4.993426e-04
Rgh_56_69 g_56_69 g_57_69 4.993426e-04
Rgv_56_69 g_56_69 g_56_70 4.993426e-04
Rgh_56_70 g_56_70 g_57_70 4.993426e-04
Rgv_56_70 g_56_70 g_56_71 4.993426e-04
Rgh_56_71 g_56_71 g_57_71 4.993426e-04
Rgh_57_0 g_57_0 g_58_0 4.993426e-04
Rgv_57_0 g_57_0 g_57_1 4.993426e-04
Rgh_57_1 g_57_1 g_58_1 4.993426e-04
Rgv_57_1 g_57_1 g_57_2 4.993426e-04
Rgh_57_2 g_57_2 g_58_2 4.993426e-04
Rgv_57_2 g_57_2 g_57_3 4.993426e-04
Rgh_57_3 g_57_3 g_58_3 4.993426e-04
Rgv_57_3 g_57_3 g_57_4 4.993426e-04
Rgh_57_4 g_57_4 g_58_4 4.993426e-04
Rgv_57_4 g_57_4 g_57_5 4.993426e-04
Rgh_57_5 g_57_5 g_58_5 4.993426e-04
Rgv_57_5 g_57_5 g_57_6 4.993426e-04
Rgh_57_6 g_57_6 g_58_6 4.993426e-04
Rgv_57_6 g_57_6 g_57_7 4.993426e-04
Rgh_57_7 g_57_7 g_58_7 4.993426e-04
Rgv_57_7 g_57_7 g_57_8 4.993426e-04
Rgh_57_8 g_57_8 g_58_8 4.993426e-04
Rgv_57_8 g_57_8 g_57_9 4.993426e-04
Rgh_57_9 g_57_9 g_58_9 4.993426e-04
Rgv_57_9 g_57_9 g_57_10 4.993426e-04
Rgh_57_10 g_57_10 g_58_10 4.993426e-04
Rgv_57_10 g_57_10 g_57_11 4.993426e-04
Rgh_57_11 g_57_11 g_58_11 4.993426e-04
Rgv_57_11 g_57_11 g_57_12 4.993426e-04
Rgh_57_12 g_57_12 g_58_12 4.993426e-04
Rgv_57_12 g_57_12 g_57_13 4.993426e-04
Rgh_57_13 g_57_13 g_58_13 4.993426e-04
Rgv_57_13 g_57_13 g_57_14 4.993426e-04
Rgh_57_14 g_57_14 g_58_14 4.993426e-04
Rgv_57_14 g_57_14 g_57_15 4.993426e-04
Rgh_57_15 g_57_15 g_58_15 4.993426e-04
Rgv_57_15 g_57_15 g_57_16 4.993426e-04
Rgh_57_16 g_57_16 g_58_16 4.993426e-04
Rgv_57_16 g_57_16 g_57_17 4.993426e-04
Rgh_57_17 g_57_17 g_58_17 4.993426e-04
Rgv_57_17 g_57_17 g_57_18 4.993426e-04
Rgh_57_18 g_57_18 g_58_18 4.993426e-04
Rgv_57_18 g_57_18 g_57_19 4.993426e-04
Rgh_57_19 g_57_19 g_58_19 4.993426e-04
Rgv_57_19 g_57_19 g_57_20 4.993426e-04
Rgh_57_20 g_57_20 g_58_20 4.993426e-04
Rgv_57_20 g_57_20 g_57_21 4.993426e-04
Rgh_57_21 g_57_21 g_58_21 4.993426e-04
Rgv_57_21 g_57_21 g_57_22 4.993426e-04
Rgh_57_22 g_57_22 g_58_22 4.993426e-04
Rgv_57_22 g_57_22 g_57_23 4.993426e-04
Rgh_57_23 g_57_23 g_58_23 4.993426e-04
Rgv_57_23 g_57_23 g_57_24 4.993426e-04
Rgh_57_24 g_57_24 g_58_24 4.993426e-04
Rgv_57_24 g_57_24 g_57_25 4.993426e-04
Rgh_57_25 g_57_25 g_58_25 4.993426e-04
Rgv_57_25 g_57_25 g_57_26 4.993426e-04
Rgh_57_26 g_57_26 g_58_26 4.993426e-04
Rgv_57_26 g_57_26 g_57_27 4.993426e-04
Rgh_57_27 g_57_27 g_58_27 4.993426e-04
Rgv_57_27 g_57_27 g_57_28 4.993426e-04
Rgh_57_28 g_57_28 g_58_28 4.993426e-04
Rgv_57_28 g_57_28 g_57_29 4.993426e-04
Rgh_57_29 g_57_29 g_58_29 4.993426e-04
Rgv_57_29 g_57_29 g_57_30 4.993426e-04
Rgh_57_30 g_57_30 g_58_30 4.993426e-04
Rgv_57_30 g_57_30 g_57_31 4.993426e-04
Rgh_57_31 g_57_31 g_58_31 4.993426e-04
Rgv_57_31 g_57_31 g_57_32 4.993426e-04
Rgh_57_32 g_57_32 g_58_32 4.993426e-04
Rgv_57_32 g_57_32 g_57_33 4.993426e-04
Rgh_57_33 g_57_33 g_58_33 4.993426e-04
Rgv_57_33 g_57_33 g_57_34 4.993426e-04
Rgh_57_34 g_57_34 g_58_34 4.993426e-04
Rgv_57_34 g_57_34 g_57_35 4.993426e-04
Rgh_57_35 g_57_35 g_58_35 4.993426e-04
Rgv_57_35 g_57_35 g_57_36 4.993426e-04
Rgh_57_36 g_57_36 g_58_36 4.993426e-04
Rgv_57_36 g_57_36 g_57_37 4.993426e-04
Rgh_57_37 g_57_37 g_58_37 4.993426e-04
Rgv_57_37 g_57_37 g_57_38 4.993426e-04
Rgh_57_38 g_57_38 g_58_38 4.993426e-04
Rgv_57_38 g_57_38 g_57_39 4.993426e-04
Rgh_57_39 g_57_39 g_58_39 4.993426e-04
Rgv_57_39 g_57_39 g_57_40 4.993426e-04
Rgh_57_40 g_57_40 g_58_40 4.993426e-04
Rgv_57_40 g_57_40 g_57_41 4.993426e-04
Rgh_57_41 g_57_41 g_58_41 4.993426e-04
Rgv_57_41 g_57_41 g_57_42 4.993426e-04
Rgh_57_42 g_57_42 g_58_42 4.993426e-04
Rgv_57_42 g_57_42 g_57_43 4.993426e-04
Rgh_57_43 g_57_43 g_58_43 4.993426e-04
Rgv_57_43 g_57_43 g_57_44 4.993426e-04
Rgh_57_44 g_57_44 g_58_44 4.993426e-04
Rgv_57_44 g_57_44 g_57_45 4.993426e-04
Rgh_57_45 g_57_45 g_58_45 4.993426e-04
Rgv_57_45 g_57_45 g_57_46 4.993426e-04
Rgh_57_46 g_57_46 g_58_46 4.993426e-04
Rgv_57_46 g_57_46 g_57_47 4.993426e-04
Rgh_57_47 g_57_47 g_58_47 4.993426e-04
Rgv_57_47 g_57_47 g_57_48 4.993426e-04
Rgh_57_48 g_57_48 g_58_48 4.993426e-04
Rgv_57_48 g_57_48 g_57_49 4.993426e-04
Rgh_57_49 g_57_49 g_58_49 4.993426e-04
Rgv_57_49 g_57_49 g_57_50 4.993426e-04
Rgh_57_50 g_57_50 g_58_50 4.993426e-04
Rgv_57_50 g_57_50 g_57_51 4.993426e-04
Rgh_57_51 g_57_51 g_58_51 4.993426e-04
Rgv_57_51 g_57_51 g_57_52 4.993426e-04
Rgh_57_52 g_57_52 g_58_52 4.993426e-04
Rgv_57_52 g_57_52 g_57_53 4.993426e-04
Rgh_57_53 g_57_53 g_58_53 4.993426e-04
Rgv_57_53 g_57_53 g_57_54 4.993426e-04
Rgh_57_54 g_57_54 g_58_54 4.993426e-04
Rgv_57_54 g_57_54 g_57_55 4.993426e-04
Rgh_57_55 g_57_55 g_58_55 4.993426e-04
Rgv_57_55 g_57_55 g_57_56 4.993426e-04
Rgh_57_56 g_57_56 g_58_56 4.993426e-04
Rgv_57_56 g_57_56 g_57_57 4.993426e-04
Rgh_57_57 g_57_57 g_58_57 4.993426e-04
Rgv_57_57 g_57_57 g_57_58 4.993426e-04
Rgh_57_58 g_57_58 g_58_58 4.993426e-04
Rgv_57_58 g_57_58 g_57_59 4.993426e-04
Rgh_57_59 g_57_59 g_58_59 4.993426e-04
Rgv_57_59 g_57_59 g_57_60 4.993426e-04
Rgh_57_60 g_57_60 g_58_60 4.993426e-04
Rgv_57_60 g_57_60 g_57_61 4.993426e-04
Rgh_57_61 g_57_61 g_58_61 4.993426e-04
Rgv_57_61 g_57_61 g_57_62 4.993426e-04
Rgh_57_62 g_57_62 g_58_62 4.993426e-04
Rgv_57_62 g_57_62 g_57_63 4.993426e-04
Rgh_57_63 g_57_63 g_58_63 4.993426e-04
Rgv_57_63 g_57_63 g_57_64 4.993426e-04
Rgh_57_64 g_57_64 g_58_64 4.993426e-04
Rgv_57_64 g_57_64 g_57_65 4.993426e-04
Rgh_57_65 g_57_65 g_58_65 4.993426e-04
Rgv_57_65 g_57_65 g_57_66 4.993426e-04
Rgh_57_66 g_57_66 g_58_66 4.993426e-04
Rgv_57_66 g_57_66 g_57_67 4.993426e-04
Rgh_57_67 g_57_67 g_58_67 4.993426e-04
Rgv_57_67 g_57_67 g_57_68 4.993426e-04
Rgh_57_68 g_57_68 g_58_68 4.993426e-04
Rgv_57_68 g_57_68 g_57_69 4.993426e-04
Rgh_57_69 g_57_69 g_58_69 4.993426e-04
Rgv_57_69 g_57_69 g_57_70 4.993426e-04
Rgh_57_70 g_57_70 g_58_70 4.993426e-04
Rgv_57_70 g_57_70 g_57_71 4.993426e-04
Rgh_57_71 g_57_71 g_58_71 4.993426e-04
Rgh_58_0 g_58_0 g_59_0 4.993426e-04
Rgv_58_0 g_58_0 g_58_1 4.993426e-04
Rgh_58_1 g_58_1 g_59_1 4.993426e-04
Rgv_58_1 g_58_1 g_58_2 4.993426e-04
Rgh_58_2 g_58_2 g_59_2 4.993426e-04
Rgv_58_2 g_58_2 g_58_3 4.993426e-04
Rgh_58_3 g_58_3 g_59_3 4.993426e-04
Rgv_58_3 g_58_3 g_58_4 4.993426e-04
Rgh_58_4 g_58_4 g_59_4 4.993426e-04
Rgv_58_4 g_58_4 g_58_5 4.993426e-04
Rgh_58_5 g_58_5 g_59_5 4.993426e-04
Rgv_58_5 g_58_5 g_58_6 4.993426e-04
Rgh_58_6 g_58_6 g_59_6 4.993426e-04
Rgv_58_6 g_58_6 g_58_7 4.993426e-04
Rgh_58_7 g_58_7 g_59_7 4.993426e-04
Rgv_58_7 g_58_7 g_58_8 4.993426e-04
Rgh_58_8 g_58_8 g_59_8 4.993426e-04
Rgv_58_8 g_58_8 g_58_9 4.993426e-04
Rgh_58_9 g_58_9 g_59_9 4.993426e-04
Rgv_58_9 g_58_9 g_58_10 4.993426e-04
Rgh_58_10 g_58_10 g_59_10 4.993426e-04
Rgv_58_10 g_58_10 g_58_11 4.993426e-04
Rgh_58_11 g_58_11 g_59_11 4.993426e-04
Rgv_58_11 g_58_11 g_58_12 4.993426e-04
Rgh_58_12 g_58_12 g_59_12 4.993426e-04
Rgv_58_12 g_58_12 g_58_13 4.993426e-04
Rgh_58_13 g_58_13 g_59_13 4.993426e-04
Rgv_58_13 g_58_13 g_58_14 4.993426e-04
Rgh_58_14 g_58_14 g_59_14 4.993426e-04
Rgv_58_14 g_58_14 g_58_15 4.993426e-04
Rgh_58_15 g_58_15 g_59_15 4.993426e-04
Rgv_58_15 g_58_15 g_58_16 4.993426e-04
Rgh_58_16 g_58_16 g_59_16 4.993426e-04
Rgv_58_16 g_58_16 g_58_17 4.993426e-04
Rgh_58_17 g_58_17 g_59_17 4.993426e-04
Rgv_58_17 g_58_17 g_58_18 4.993426e-04
Rgh_58_18 g_58_18 g_59_18 4.993426e-04
Rgv_58_18 g_58_18 g_58_19 4.993426e-04
Rgh_58_19 g_58_19 g_59_19 4.993426e-04
Rgv_58_19 g_58_19 g_58_20 4.993426e-04
Rgh_58_20 g_58_20 g_59_20 4.993426e-04
Rgv_58_20 g_58_20 g_58_21 4.993426e-04
Rgh_58_21 g_58_21 g_59_21 4.993426e-04
Rgv_58_21 g_58_21 g_58_22 4.993426e-04
Rgh_58_22 g_58_22 g_59_22 4.993426e-04
Rgv_58_22 g_58_22 g_58_23 4.993426e-04
Rgh_58_23 g_58_23 g_59_23 4.993426e-04
Rgv_58_23 g_58_23 g_58_24 4.993426e-04
Rgh_58_24 g_58_24 g_59_24 4.993426e-04
Rgv_58_24 g_58_24 g_58_25 4.993426e-04
Rgh_58_25 g_58_25 g_59_25 4.993426e-04
Rgv_58_25 g_58_25 g_58_26 4.993426e-04
Rgh_58_26 g_58_26 g_59_26 4.993426e-04
Rgv_58_26 g_58_26 g_58_27 4.993426e-04
Rgh_58_27 g_58_27 g_59_27 4.993426e-04
Rgv_58_27 g_58_27 g_58_28 4.993426e-04
Rgh_58_28 g_58_28 g_59_28 4.993426e-04
Rgv_58_28 g_58_28 g_58_29 4.993426e-04
Rgh_58_29 g_58_29 g_59_29 4.993426e-04
Rgv_58_29 g_58_29 g_58_30 4.993426e-04
Rgh_58_30 g_58_30 g_59_30 4.993426e-04
Rgv_58_30 g_58_30 g_58_31 4.993426e-04
Rgh_58_31 g_58_31 g_59_31 4.993426e-04
Rgv_58_31 g_58_31 g_58_32 4.993426e-04
Rgh_58_32 g_58_32 g_59_32 4.993426e-04
Rgv_58_32 g_58_32 g_58_33 4.993426e-04
Rgh_58_33 g_58_33 g_59_33 4.993426e-04
Rgv_58_33 g_58_33 g_58_34 4.993426e-04
Rgh_58_34 g_58_34 g_59_34 4.993426e-04
Rgv_58_34 g_58_34 g_58_35 4.993426e-04
Rgh_58_35 g_58_35 g_59_35 4.993426e-04
Rgv_58_35 g_58_35 g_58_36 4.993426e-04
Rgh_58_36 g_58_36 g_59_36 4.993426e-04
Rgv_58_36 g_58_36 g_58_37 4.993426e-04
Rgh_58_37 g_58_37 g_59_37 4.993426e-04
Rgv_58_37 g_58_37 g_58_38 4.993426e-04
Rgh_58_38 g_58_38 g_59_38 4.993426e-04
Rgv_58_38 g_58_38 g_58_39 4.993426e-04
Rgh_58_39 g_58_39 g_59_39 4.993426e-04
Rgv_58_39 g_58_39 g_58_40 4.993426e-04
Rgh_58_40 g_58_40 g_59_40 4.993426e-04
Rgv_58_40 g_58_40 g_58_41 4.993426e-04
Rgh_58_41 g_58_41 g_59_41 4.993426e-04
Rgv_58_41 g_58_41 g_58_42 4.993426e-04
Rgh_58_42 g_58_42 g_59_42 4.993426e-04
Rgv_58_42 g_58_42 g_58_43 4.993426e-04
Rgh_58_43 g_58_43 g_59_43 4.993426e-04
Rgv_58_43 g_58_43 g_58_44 4.993426e-04
Rgh_58_44 g_58_44 g_59_44 4.993426e-04
Rgv_58_44 g_58_44 g_58_45 4.993426e-04
Rgh_58_45 g_58_45 g_59_45 4.993426e-04
Rgv_58_45 g_58_45 g_58_46 4.993426e-04
Rgh_58_46 g_58_46 g_59_46 4.993426e-04
Rgv_58_46 g_58_46 g_58_47 4.993426e-04
Rgh_58_47 g_58_47 g_59_47 4.993426e-04
Rgv_58_47 g_58_47 g_58_48 4.993426e-04
Rgh_58_48 g_58_48 g_59_48 4.993426e-04
Rgv_58_48 g_58_48 g_58_49 4.993426e-04
Rgh_58_49 g_58_49 g_59_49 4.993426e-04
Rgv_58_49 g_58_49 g_58_50 4.993426e-04
Rgh_58_50 g_58_50 g_59_50 4.993426e-04
Rgv_58_50 g_58_50 g_58_51 4.993426e-04
Rgh_58_51 g_58_51 g_59_51 4.993426e-04
Rgv_58_51 g_58_51 g_58_52 4.993426e-04
Rgh_58_52 g_58_52 g_59_52 4.993426e-04
Rgv_58_52 g_58_52 g_58_53 4.993426e-04
Rgh_58_53 g_58_53 g_59_53 4.993426e-04
Rgv_58_53 g_58_53 g_58_54 4.993426e-04
Rgh_58_54 g_58_54 g_59_54 4.993426e-04
Rgv_58_54 g_58_54 g_58_55 4.993426e-04
Rgh_58_55 g_58_55 g_59_55 4.993426e-04
Rgv_58_55 g_58_55 g_58_56 4.993426e-04
Rgh_58_56 g_58_56 g_59_56 4.993426e-04
Rgv_58_56 g_58_56 g_58_57 4.993426e-04
Rgh_58_57 g_58_57 g_59_57 4.993426e-04
Rgv_58_57 g_58_57 g_58_58 4.993426e-04
Rgh_58_58 g_58_58 g_59_58 4.993426e-04
Rgv_58_58 g_58_58 g_58_59 4.993426e-04
Rgh_58_59 g_58_59 g_59_59 4.993426e-04
Rgv_58_59 g_58_59 g_58_60 4.993426e-04
Rgh_58_60 g_58_60 g_59_60 4.993426e-04
Rgv_58_60 g_58_60 g_58_61 4.993426e-04
Rgh_58_61 g_58_61 g_59_61 4.993426e-04
Rgv_58_61 g_58_61 g_58_62 4.993426e-04
Rgh_58_62 g_58_62 g_59_62 4.993426e-04
Rgv_58_62 g_58_62 g_58_63 4.993426e-04
Rgh_58_63 g_58_63 g_59_63 4.993426e-04
Rgv_58_63 g_58_63 g_58_64 4.993426e-04
Rgh_58_64 g_58_64 g_59_64 4.993426e-04
Rgv_58_64 g_58_64 g_58_65 4.993426e-04
Rgh_58_65 g_58_65 g_59_65 4.993426e-04
Rgv_58_65 g_58_65 g_58_66 4.993426e-04
Rgh_58_66 g_58_66 g_59_66 4.993426e-04
Rgv_58_66 g_58_66 g_58_67 4.993426e-04
Rgh_58_67 g_58_67 g_59_67 4.993426e-04
Rgv_58_67 g_58_67 g_58_68 4.993426e-04
Rgh_58_68 g_58_68 g_59_68 4.993426e-04
Rgv_58_68 g_58_68 g_58_69 4.993426e-04
Rgh_58_69 g_58_69 g_59_69 4.993426e-04
Rgv_58_69 g_58_69 g_58_70 4.993426e-04
Rgh_58_70 g_58_70 g_59_70 4.993426e-04
Rgv_58_70 g_58_70 g_58_71 4.993426e-04
Rgh_58_71 g_58_71 g_59_71 4.993426e-04
Rgh_59_0 g_59_0 g_60_0 4.993426e-04
Rgv_59_0 g_59_0 g_59_1 4.993426e-04
Rgh_59_1 g_59_1 g_60_1 4.993426e-04
Rgv_59_1 g_59_1 g_59_2 4.993426e-04
Rgh_59_2 g_59_2 g_60_2 4.993426e-04
Rgv_59_2 g_59_2 g_59_3 4.993426e-04
Rgh_59_3 g_59_3 g_60_3 4.993426e-04
Rgv_59_3 g_59_3 g_59_4 4.993426e-04
Rgh_59_4 g_59_4 g_60_4 4.993426e-04
Rgv_59_4 g_59_4 g_59_5 4.993426e-04
Rgh_59_5 g_59_5 g_60_5 4.993426e-04
Rgv_59_5 g_59_5 g_59_6 4.993426e-04
Rgh_59_6 g_59_6 g_60_6 4.993426e-04
Rgv_59_6 g_59_6 g_59_7 4.993426e-04
Rgh_59_7 g_59_7 g_60_7 4.993426e-04
Rgv_59_7 g_59_7 g_59_8 4.993426e-04
Rgh_59_8 g_59_8 g_60_8 4.993426e-04
Rgv_59_8 g_59_8 g_59_9 4.993426e-04
Rgh_59_9 g_59_9 g_60_9 4.993426e-04
Rgv_59_9 g_59_9 g_59_10 4.993426e-04
Rgh_59_10 g_59_10 g_60_10 4.993426e-04
Rgv_59_10 g_59_10 g_59_11 4.993426e-04
Rgh_59_11 g_59_11 g_60_11 4.993426e-04
Rgv_59_11 g_59_11 g_59_12 4.993426e-04
Rgh_59_12 g_59_12 g_60_12 4.993426e-04
Rgv_59_12 g_59_12 g_59_13 4.993426e-04
Rgh_59_13 g_59_13 g_60_13 4.993426e-04
Rgv_59_13 g_59_13 g_59_14 4.993426e-04
Rgh_59_14 g_59_14 g_60_14 4.993426e-04
Rgv_59_14 g_59_14 g_59_15 4.993426e-04
Rgh_59_15 g_59_15 g_60_15 4.993426e-04
Rgv_59_15 g_59_15 g_59_16 4.993426e-04
Rgh_59_16 g_59_16 g_60_16 4.993426e-04
Rgv_59_16 g_59_16 g_59_17 4.993426e-04
Rgh_59_17 g_59_17 g_60_17 4.993426e-04
Rgv_59_17 g_59_17 g_59_18 4.993426e-04
Rgh_59_18 g_59_18 g_60_18 4.993426e-04
Rgv_59_18 g_59_18 g_59_19 4.993426e-04
Rgh_59_19 g_59_19 g_60_19 4.993426e-04
Rgv_59_19 g_59_19 g_59_20 4.993426e-04
Rgh_59_20 g_59_20 g_60_20 4.993426e-04
Rgv_59_20 g_59_20 g_59_21 4.993426e-04
Rgh_59_21 g_59_21 g_60_21 4.993426e-04
Rgv_59_21 g_59_21 g_59_22 4.993426e-04
Rgh_59_22 g_59_22 g_60_22 4.993426e-04
Rgv_59_22 g_59_22 g_59_23 4.993426e-04
Rgh_59_23 g_59_23 g_60_23 4.993426e-04
Rgv_59_23 g_59_23 g_59_24 4.993426e-04
Rgh_59_24 g_59_24 g_60_24 4.993426e-04
Rgv_59_24 g_59_24 g_59_25 4.993426e-04
Rgh_59_25 g_59_25 g_60_25 4.993426e-04
Rgv_59_25 g_59_25 g_59_26 4.993426e-04
Rgh_59_26 g_59_26 g_60_26 4.993426e-04
Rgv_59_26 g_59_26 g_59_27 4.993426e-04
Rgh_59_27 g_59_27 g_60_27 4.993426e-04
Rgv_59_27 g_59_27 g_59_28 4.993426e-04
Rgh_59_28 g_59_28 g_60_28 4.993426e-04
Rgv_59_28 g_59_28 g_59_29 4.993426e-04
Rgh_59_29 g_59_29 g_60_29 4.993426e-04
Rgv_59_29 g_59_29 g_59_30 4.993426e-04
Rgh_59_30 g_59_30 g_60_30 4.993426e-04
Rgv_59_30 g_59_30 g_59_31 4.993426e-04
Rgh_59_31 g_59_31 g_60_31 4.993426e-04
Rgv_59_31 g_59_31 g_59_32 4.993426e-04
Rgh_59_32 g_59_32 g_60_32 4.993426e-04
Rgv_59_32 g_59_32 g_59_33 4.993426e-04
Rgh_59_33 g_59_33 g_60_33 4.993426e-04
Rgv_59_33 g_59_33 g_59_34 4.993426e-04
Rgh_59_34 g_59_34 g_60_34 4.993426e-04
Rgv_59_34 g_59_34 g_59_35 4.993426e-04
Rgh_59_35 g_59_35 g_60_35 4.993426e-04
Rgv_59_35 g_59_35 g_59_36 4.993426e-04
Rgh_59_36 g_59_36 g_60_36 4.993426e-04
Rgv_59_36 g_59_36 g_59_37 4.993426e-04
Rgh_59_37 g_59_37 g_60_37 4.993426e-04
Rgv_59_37 g_59_37 g_59_38 4.993426e-04
Rgh_59_38 g_59_38 g_60_38 4.993426e-04
Rgv_59_38 g_59_38 g_59_39 4.993426e-04
Rgh_59_39 g_59_39 g_60_39 4.993426e-04
Rgv_59_39 g_59_39 g_59_40 4.993426e-04
Rgh_59_40 g_59_40 g_60_40 4.993426e-04
Rgv_59_40 g_59_40 g_59_41 4.993426e-04
Rgh_59_41 g_59_41 g_60_41 4.993426e-04
Rgv_59_41 g_59_41 g_59_42 4.993426e-04
Rgh_59_42 g_59_42 g_60_42 4.993426e-04
Rgv_59_42 g_59_42 g_59_43 4.993426e-04
Rgh_59_43 g_59_43 g_60_43 4.993426e-04
Rgv_59_43 g_59_43 g_59_44 4.993426e-04
Rgh_59_44 g_59_44 g_60_44 4.993426e-04
Rgv_59_44 g_59_44 g_59_45 4.993426e-04
Rgh_59_45 g_59_45 g_60_45 4.993426e-04
Rgv_59_45 g_59_45 g_59_46 4.993426e-04
Rgh_59_46 g_59_46 g_60_46 4.993426e-04
Rgv_59_46 g_59_46 g_59_47 4.993426e-04
Rgh_59_47 g_59_47 g_60_47 4.993426e-04
Rgv_59_47 g_59_47 g_59_48 4.993426e-04
Rgh_59_48 g_59_48 g_60_48 4.993426e-04
Rgv_59_48 g_59_48 g_59_49 4.993426e-04
Rgh_59_49 g_59_49 g_60_49 4.993426e-04
Rgv_59_49 g_59_49 g_59_50 4.993426e-04
Rgh_59_50 g_59_50 g_60_50 4.993426e-04
Rgv_59_50 g_59_50 g_59_51 4.993426e-04
Rgh_59_51 g_59_51 g_60_51 4.993426e-04
Rgv_59_51 g_59_51 g_59_52 4.993426e-04
Rgh_59_52 g_59_52 g_60_52 4.993426e-04
Rgv_59_52 g_59_52 g_59_53 4.993426e-04
Rgh_59_53 g_59_53 g_60_53 4.993426e-04
Rgv_59_53 g_59_53 g_59_54 4.993426e-04
Rgh_59_54 g_59_54 g_60_54 4.993426e-04
Rgv_59_54 g_59_54 g_59_55 4.993426e-04
Rgh_59_55 g_59_55 g_60_55 4.993426e-04
Rgv_59_55 g_59_55 g_59_56 4.993426e-04
Rgh_59_56 g_59_56 g_60_56 4.993426e-04
Rgv_59_56 g_59_56 g_59_57 4.993426e-04
Rgh_59_57 g_59_57 g_60_57 4.993426e-04
Rgv_59_57 g_59_57 g_59_58 4.993426e-04
Rgh_59_58 g_59_58 g_60_58 4.993426e-04
Rgv_59_58 g_59_58 g_59_59 4.993426e-04
Rgh_59_59 g_59_59 g_60_59 4.993426e-04
Rgv_59_59 g_59_59 g_59_60 4.993426e-04
Rgh_59_60 g_59_60 g_60_60 4.993426e-04
Rgv_59_60 g_59_60 g_59_61 4.993426e-04
Rgh_59_61 g_59_61 g_60_61 4.993426e-04
Rgv_59_61 g_59_61 g_59_62 4.993426e-04
Rgh_59_62 g_59_62 g_60_62 4.993426e-04
Rgv_59_62 g_59_62 g_59_63 4.993426e-04
Rgh_59_63 g_59_63 g_60_63 4.993426e-04
Rgv_59_63 g_59_63 g_59_64 4.993426e-04
Rgh_59_64 g_59_64 g_60_64 4.993426e-04
Rgv_59_64 g_59_64 g_59_65 4.993426e-04
Rgh_59_65 g_59_65 g_60_65 4.993426e-04
Rgv_59_65 g_59_65 g_59_66 4.993426e-04
Rgh_59_66 g_59_66 g_60_66 4.993426e-04
Rgv_59_66 g_59_66 g_59_67 4.993426e-04
Rgh_59_67 g_59_67 g_60_67 4.993426e-04
Rgv_59_67 g_59_67 g_59_68 4.993426e-04
Rgh_59_68 g_59_68 g_60_68 4.993426e-04
Rgv_59_68 g_59_68 g_59_69 4.993426e-04
Rgh_59_69 g_59_69 g_60_69 4.993426e-04
Rgv_59_69 g_59_69 g_59_70 4.993426e-04
Rgh_59_70 g_59_70 g_60_70 4.993426e-04
Rgv_59_70 g_59_70 g_59_71 4.993426e-04
Rgh_59_71 g_59_71 g_60_71 4.993426e-04
Rgh_60_0 g_60_0 g_61_0 4.993426e-04
Rgv_60_0 g_60_0 g_60_1 4.993426e-04
Rgh_60_1 g_60_1 g_61_1 4.993426e-04
Rgv_60_1 g_60_1 g_60_2 4.993426e-04
Rgh_60_2 g_60_2 g_61_2 4.993426e-04
Rgv_60_2 g_60_2 g_60_3 4.993426e-04
Rgh_60_3 g_60_3 g_61_3 4.993426e-04
Rgv_60_3 g_60_3 g_60_4 4.993426e-04
Rgh_60_4 g_60_4 g_61_4 4.993426e-04
Rgv_60_4 g_60_4 g_60_5 4.993426e-04
Rgh_60_5 g_60_5 g_61_5 4.993426e-04
Rgv_60_5 g_60_5 g_60_6 4.993426e-04
Rgh_60_6 g_60_6 g_61_6 4.993426e-04
Rgv_60_6 g_60_6 g_60_7 4.993426e-04
Rgh_60_7 g_60_7 g_61_7 4.993426e-04
Rgv_60_7 g_60_7 g_60_8 4.993426e-04
Rgh_60_8 g_60_8 g_61_8 4.993426e-04
Rgv_60_8 g_60_8 g_60_9 4.993426e-04
Rgh_60_9 g_60_9 g_61_9 4.993426e-04
Rgv_60_9 g_60_9 g_60_10 4.993426e-04
Rgh_60_10 g_60_10 g_61_10 4.993426e-04
Rgv_60_10 g_60_10 g_60_11 4.993426e-04
Rgh_60_11 g_60_11 g_61_11 4.993426e-04
Rgv_60_11 g_60_11 g_60_12 4.993426e-04
Rgh_60_12 g_60_12 g_61_12 4.993426e-04
Rgv_60_12 g_60_12 g_60_13 4.993426e-04
Rgh_60_13 g_60_13 g_61_13 4.993426e-04
Rgv_60_13 g_60_13 g_60_14 4.993426e-04
Rgh_60_14 g_60_14 g_61_14 4.993426e-04
Rgv_60_14 g_60_14 g_60_15 4.993426e-04
Rgh_60_15 g_60_15 g_61_15 4.993426e-04
Rgv_60_15 g_60_15 g_60_16 4.993426e-04
Rgh_60_16 g_60_16 g_61_16 4.993426e-04
Rgv_60_16 g_60_16 g_60_17 4.993426e-04
Rgh_60_17 g_60_17 g_61_17 4.993426e-04
Rgv_60_17 g_60_17 g_60_18 4.993426e-04
Rgh_60_18 g_60_18 g_61_18 4.993426e-04
Rgv_60_18 g_60_18 g_60_19 4.993426e-04
Rgh_60_19 g_60_19 g_61_19 4.993426e-04
Rgv_60_19 g_60_19 g_60_20 4.993426e-04
Rgh_60_20 g_60_20 g_61_20 4.993426e-04
Rgv_60_20 g_60_20 g_60_21 4.993426e-04
Rgh_60_21 g_60_21 g_61_21 4.993426e-04
Rgv_60_21 g_60_21 g_60_22 4.993426e-04
Rgh_60_22 g_60_22 g_61_22 4.993426e-04
Rgv_60_22 g_60_22 g_60_23 4.993426e-04
Rgh_60_23 g_60_23 g_61_23 4.993426e-04
Rgv_60_23 g_60_23 g_60_24 4.993426e-04
Rgh_60_24 g_60_24 g_61_24 4.993426e-04
Rgv_60_24 g_60_24 g_60_25 4.993426e-04
Rgh_60_25 g_60_25 g_61_25 4.993426e-04
Rgv_60_25 g_60_25 g_60_26 4.993426e-04
Rgh_60_26 g_60_26 g_61_26 4.993426e-04
Rgv_60_26 g_60_26 g_60_27 4.993426e-04
Rgh_60_27 g_60_27 g_61_27 4.993426e-04
Rgv_60_27 g_60_27 g_60_28 4.993426e-04
Rgh_60_28 g_60_28 g_61_28 4.993426e-04
Rgv_60_28 g_60_28 g_60_29 4.993426e-04
Rgh_60_29 g_60_29 g_61_29 4.993426e-04
Rgv_60_29 g_60_29 g_60_30 4.993426e-04
Rgh_60_30 g_60_30 g_61_30 4.993426e-04
Rgv_60_30 g_60_30 g_60_31 4.993426e-04
Rgh_60_31 g_60_31 g_61_31 4.993426e-04
Rgv_60_31 g_60_31 g_60_32 4.993426e-04
Rgh_60_32 g_60_32 g_61_32 4.993426e-04
Rgv_60_32 g_60_32 g_60_33 4.993426e-04
Rgh_60_33 g_60_33 g_61_33 4.993426e-04
Rgv_60_33 g_60_33 g_60_34 4.993426e-04
Rgh_60_34 g_60_34 g_61_34 4.993426e-04
Rgv_60_34 g_60_34 g_60_35 4.993426e-04
Rgh_60_35 g_60_35 g_61_35 4.993426e-04
Rgv_60_35 g_60_35 g_60_36 4.993426e-04
Rgh_60_36 g_60_36 g_61_36 4.993426e-04
Rgv_60_36 g_60_36 g_60_37 4.993426e-04
Rgh_60_37 g_60_37 g_61_37 4.993426e-04
Rgv_60_37 g_60_37 g_60_38 4.993426e-04
Rgh_60_38 g_60_38 g_61_38 4.993426e-04
Rgv_60_38 g_60_38 g_60_39 4.993426e-04
Rgh_60_39 g_60_39 g_61_39 4.993426e-04
Rgv_60_39 g_60_39 g_60_40 4.993426e-04
Rgh_60_40 g_60_40 g_61_40 4.993426e-04
Rgv_60_40 g_60_40 g_60_41 4.993426e-04
Rgh_60_41 g_60_41 g_61_41 4.993426e-04
Rgv_60_41 g_60_41 g_60_42 4.993426e-04
Rgh_60_42 g_60_42 g_61_42 4.993426e-04
Rgv_60_42 g_60_42 g_60_43 4.993426e-04
Rgh_60_43 g_60_43 g_61_43 4.993426e-04
Rgv_60_43 g_60_43 g_60_44 4.993426e-04
Rgh_60_44 g_60_44 g_61_44 4.993426e-04
Rgv_60_44 g_60_44 g_60_45 4.993426e-04
Rgh_60_45 g_60_45 g_61_45 4.993426e-04
Rgv_60_45 g_60_45 g_60_46 4.993426e-04
Rgh_60_46 g_60_46 g_61_46 4.993426e-04
Rgv_60_46 g_60_46 g_60_47 4.993426e-04
Rgh_60_47 g_60_47 g_61_47 4.993426e-04
Rgv_60_47 g_60_47 g_60_48 4.993426e-04
Rgh_60_48 g_60_48 g_61_48 4.993426e-04
Rgv_60_48 g_60_48 g_60_49 4.993426e-04
Rgh_60_49 g_60_49 g_61_49 4.993426e-04
Rgv_60_49 g_60_49 g_60_50 4.993426e-04
Rgh_60_50 g_60_50 g_61_50 4.993426e-04
Rgv_60_50 g_60_50 g_60_51 4.993426e-04
Rgh_60_51 g_60_51 g_61_51 4.993426e-04
Rgv_60_51 g_60_51 g_60_52 4.993426e-04
Rgh_60_52 g_60_52 g_61_52 4.993426e-04
Rgv_60_52 g_60_52 g_60_53 4.993426e-04
Rgh_60_53 g_60_53 g_61_53 4.993426e-04
Rgv_60_53 g_60_53 g_60_54 4.993426e-04
Rgh_60_54 g_60_54 g_61_54 4.993426e-04
Rgv_60_54 g_60_54 g_60_55 4.993426e-04
Rgh_60_55 g_60_55 g_61_55 4.993426e-04
Rgv_60_55 g_60_55 g_60_56 4.993426e-04
Rgh_60_56 g_60_56 g_61_56 4.993426e-04
Rgv_60_56 g_60_56 g_60_57 4.993426e-04
Rgh_60_57 g_60_57 g_61_57 4.993426e-04
Rgv_60_57 g_60_57 g_60_58 4.993426e-04
Rgh_60_58 g_60_58 g_61_58 4.993426e-04
Rgv_60_58 g_60_58 g_60_59 4.993426e-04
Rgh_60_59 g_60_59 g_61_59 4.993426e-04
Rgv_60_59 g_60_59 g_60_60 4.993426e-04
Rgh_60_60 g_60_60 g_61_60 4.993426e-04
Rgv_60_60 g_60_60 g_60_61 4.993426e-04
Rgh_60_61 g_60_61 g_61_61 4.993426e-04
Rgv_60_61 g_60_61 g_60_62 4.993426e-04
Rgh_60_62 g_60_62 g_61_62 4.993426e-04
Rgv_60_62 g_60_62 g_60_63 4.993426e-04
Rgh_60_63 g_60_63 g_61_63 4.993426e-04
Rgv_60_63 g_60_63 g_60_64 4.993426e-04
Rgh_60_64 g_60_64 g_61_64 4.993426e-04
Rgv_60_64 g_60_64 g_60_65 4.993426e-04
Rgh_60_65 g_60_65 g_61_65 4.993426e-04
Rgv_60_65 g_60_65 g_60_66 4.993426e-04
Rgh_60_66 g_60_66 g_61_66 4.993426e-04
Rgv_60_66 g_60_66 g_60_67 4.993426e-04
Rgh_60_67 g_60_67 g_61_67 4.993426e-04
Rgv_60_67 g_60_67 g_60_68 4.993426e-04
Rgh_60_68 g_60_68 g_61_68 4.993426e-04
Rgv_60_68 g_60_68 g_60_69 4.993426e-04
Rgh_60_69 g_60_69 g_61_69 4.993426e-04
Rgv_60_69 g_60_69 g_60_70 4.993426e-04
Rgh_60_70 g_60_70 g_61_70 4.993426e-04
Rgv_60_70 g_60_70 g_60_71 4.993426e-04
Rgh_60_71 g_60_71 g_61_71 4.993426e-04
Rgh_61_0 g_61_0 g_62_0 4.993426e-04
Rgv_61_0 g_61_0 g_61_1 4.993426e-04
Rgh_61_1 g_61_1 g_62_1 4.993426e-04
Rgv_61_1 g_61_1 g_61_2 4.993426e-04
Rgh_61_2 g_61_2 g_62_2 4.993426e-04
Rgv_61_2 g_61_2 g_61_3 4.993426e-04
Rgh_61_3 g_61_3 g_62_3 4.993426e-04
Rgv_61_3 g_61_3 g_61_4 4.993426e-04
Rgh_61_4 g_61_4 g_62_4 4.993426e-04
Rgv_61_4 g_61_4 g_61_5 4.993426e-04
Rgh_61_5 g_61_5 g_62_5 4.993426e-04
Rgv_61_5 g_61_5 g_61_6 4.993426e-04
Rgh_61_6 g_61_6 g_62_6 4.993426e-04
Rgv_61_6 g_61_6 g_61_7 4.993426e-04
Rgh_61_7 g_61_7 g_62_7 4.993426e-04
Rgv_61_7 g_61_7 g_61_8 4.993426e-04
Rgh_61_8 g_61_8 g_62_8 4.993426e-04
Rgv_61_8 g_61_8 g_61_9 4.993426e-04
Rgh_61_9 g_61_9 g_62_9 4.993426e-04
Rgv_61_9 g_61_9 g_61_10 4.993426e-04
Rgh_61_10 g_61_10 g_62_10 4.993426e-04
Rgv_61_10 g_61_10 g_61_11 4.993426e-04
Rgh_61_11 g_61_11 g_62_11 4.993426e-04
Rgv_61_11 g_61_11 g_61_12 4.993426e-04
Rgh_61_12 g_61_12 g_62_12 4.993426e-04
Rgv_61_12 g_61_12 g_61_13 4.993426e-04
Rgh_61_13 g_61_13 g_62_13 4.993426e-04
Rgv_61_13 g_61_13 g_61_14 4.993426e-04
Rgh_61_14 g_61_14 g_62_14 4.993426e-04
Rgv_61_14 g_61_14 g_61_15 4.993426e-04
Rgh_61_15 g_61_15 g_62_15 4.993426e-04
Rgv_61_15 g_61_15 g_61_16 4.993426e-04
Rgh_61_16 g_61_16 g_62_16 4.993426e-04
Rgv_61_16 g_61_16 g_61_17 4.993426e-04
Rgh_61_17 g_61_17 g_62_17 4.993426e-04
Rgv_61_17 g_61_17 g_61_18 4.993426e-04
Rgh_61_18 g_61_18 g_62_18 4.993426e-04
Rgv_61_18 g_61_18 g_61_19 4.993426e-04
Rgh_61_19 g_61_19 g_62_19 4.993426e-04
Rgv_61_19 g_61_19 g_61_20 4.993426e-04
Rgh_61_20 g_61_20 g_62_20 4.993426e-04
Rgv_61_20 g_61_20 g_61_21 4.993426e-04
Rgh_61_21 g_61_21 g_62_21 4.993426e-04
Rgv_61_21 g_61_21 g_61_22 4.993426e-04
Rgh_61_22 g_61_22 g_62_22 4.993426e-04
Rgv_61_22 g_61_22 g_61_23 4.993426e-04
Rgh_61_23 g_61_23 g_62_23 4.993426e-04
Rgv_61_23 g_61_23 g_61_24 4.993426e-04
Rgh_61_24 g_61_24 g_62_24 4.993426e-04
Rgv_61_24 g_61_24 g_61_25 4.993426e-04
Rgh_61_25 g_61_25 g_62_25 4.993426e-04
Rgv_61_25 g_61_25 g_61_26 4.993426e-04
Rgh_61_26 g_61_26 g_62_26 4.993426e-04
Rgv_61_26 g_61_26 g_61_27 4.993426e-04
Rgh_61_27 g_61_27 g_62_27 4.993426e-04
Rgv_61_27 g_61_27 g_61_28 4.993426e-04
Rgh_61_28 g_61_28 g_62_28 4.993426e-04
Rgv_61_28 g_61_28 g_61_29 4.993426e-04
Rgh_61_29 g_61_29 g_62_29 4.993426e-04
Rgv_61_29 g_61_29 g_61_30 4.993426e-04
Rgh_61_30 g_61_30 g_62_30 4.993426e-04
Rgv_61_30 g_61_30 g_61_31 4.993426e-04
Rgh_61_31 g_61_31 g_62_31 4.993426e-04
Rgv_61_31 g_61_31 g_61_32 4.993426e-04
Rgh_61_32 g_61_32 g_62_32 4.993426e-04
Rgv_61_32 g_61_32 g_61_33 4.993426e-04
Rgh_61_33 g_61_33 g_62_33 4.993426e-04
Rgv_61_33 g_61_33 g_61_34 4.993426e-04
Rgh_61_34 g_61_34 g_62_34 4.993426e-04
Rgv_61_34 g_61_34 g_61_35 4.993426e-04
Rgh_61_35 g_61_35 g_62_35 4.993426e-04
Rgv_61_35 g_61_35 g_61_36 4.993426e-04
Rgh_61_36 g_61_36 g_62_36 4.993426e-04
Rgv_61_36 g_61_36 g_61_37 4.993426e-04
Rgh_61_37 g_61_37 g_62_37 4.993426e-04
Rgv_61_37 g_61_37 g_61_38 4.993426e-04
Rgh_61_38 g_61_38 g_62_38 4.993426e-04
Rgv_61_38 g_61_38 g_61_39 4.993426e-04
Rgh_61_39 g_61_39 g_62_39 4.993426e-04
Rgv_61_39 g_61_39 g_61_40 4.993426e-04
Rgh_61_40 g_61_40 g_62_40 4.993426e-04
Rgv_61_40 g_61_40 g_61_41 4.993426e-04
Rgh_61_41 g_61_41 g_62_41 4.993426e-04
Rgv_61_41 g_61_41 g_61_42 4.993426e-04
Rgh_61_42 g_61_42 g_62_42 4.993426e-04
Rgv_61_42 g_61_42 g_61_43 4.993426e-04
Rgh_61_43 g_61_43 g_62_43 4.993426e-04
Rgv_61_43 g_61_43 g_61_44 4.993426e-04
Rgh_61_44 g_61_44 g_62_44 4.993426e-04
Rgv_61_44 g_61_44 g_61_45 4.993426e-04
Rgh_61_45 g_61_45 g_62_45 4.993426e-04
Rgv_61_45 g_61_45 g_61_46 4.993426e-04
Rgh_61_46 g_61_46 g_62_46 4.993426e-04
Rgv_61_46 g_61_46 g_61_47 4.993426e-04
Rgh_61_47 g_61_47 g_62_47 4.993426e-04
Rgv_61_47 g_61_47 g_61_48 4.993426e-04
Rgh_61_48 g_61_48 g_62_48 4.993426e-04
Rgv_61_48 g_61_48 g_61_49 4.993426e-04
Rgh_61_49 g_61_49 g_62_49 4.993426e-04
Rgv_61_49 g_61_49 g_61_50 4.993426e-04
Rgh_61_50 g_61_50 g_62_50 4.993426e-04
Rgv_61_50 g_61_50 g_61_51 4.993426e-04
Rgh_61_51 g_61_51 g_62_51 4.993426e-04
Rgv_61_51 g_61_51 g_61_52 4.993426e-04
Rgh_61_52 g_61_52 g_62_52 4.993426e-04
Rgv_61_52 g_61_52 g_61_53 4.993426e-04
Rgh_61_53 g_61_53 g_62_53 4.993426e-04
Rgv_61_53 g_61_53 g_61_54 4.993426e-04
Rgh_61_54 g_61_54 g_62_54 4.993426e-04
Rgv_61_54 g_61_54 g_61_55 4.993426e-04
Rgh_61_55 g_61_55 g_62_55 4.993426e-04
Rgv_61_55 g_61_55 g_61_56 4.993426e-04
Rgh_61_56 g_61_56 g_62_56 4.993426e-04
Rgv_61_56 g_61_56 g_61_57 4.993426e-04
Rgh_61_57 g_61_57 g_62_57 4.993426e-04
Rgv_61_57 g_61_57 g_61_58 4.993426e-04
Rgh_61_58 g_61_58 g_62_58 4.993426e-04
Rgv_61_58 g_61_58 g_61_59 4.993426e-04
Rgh_61_59 g_61_59 g_62_59 4.993426e-04
Rgv_61_59 g_61_59 g_61_60 4.993426e-04
Rgh_61_60 g_61_60 g_62_60 4.993426e-04
Rgv_61_60 g_61_60 g_61_61 4.993426e-04
Rgh_61_61 g_61_61 g_62_61 4.993426e-04
Rgv_61_61 g_61_61 g_61_62 4.993426e-04
Rgh_61_62 g_61_62 g_62_62 4.993426e-04
Rgv_61_62 g_61_62 g_61_63 4.993426e-04
Rgh_61_63 g_61_63 g_62_63 4.993426e-04
Rgv_61_63 g_61_63 g_61_64 4.993426e-04
Rgh_61_64 g_61_64 g_62_64 4.993426e-04
Rgv_61_64 g_61_64 g_61_65 4.993426e-04
Rgh_61_65 g_61_65 g_62_65 4.993426e-04
Rgv_61_65 g_61_65 g_61_66 4.993426e-04
Rgh_61_66 g_61_66 g_62_66 4.993426e-04
Rgv_61_66 g_61_66 g_61_67 4.993426e-04
Rgh_61_67 g_61_67 g_62_67 4.993426e-04
Rgv_61_67 g_61_67 g_61_68 4.993426e-04
Rgh_61_68 g_61_68 g_62_68 4.993426e-04
Rgv_61_68 g_61_68 g_61_69 4.993426e-04
Rgh_61_69 g_61_69 g_62_69 4.993426e-04
Rgv_61_69 g_61_69 g_61_70 4.993426e-04
Rgh_61_70 g_61_70 g_62_70 4.993426e-04
Rgv_61_70 g_61_70 g_61_71 4.993426e-04
Rgh_61_71 g_61_71 g_62_71 4.993426e-04
Rgh_62_0 g_62_0 g_63_0 4.993426e-04
Rgv_62_0 g_62_0 g_62_1 4.993426e-04
Rgh_62_1 g_62_1 g_63_1 4.993426e-04
Rgv_62_1 g_62_1 g_62_2 4.993426e-04
Rgh_62_2 g_62_2 g_63_2 4.993426e-04
Rgv_62_2 g_62_2 g_62_3 4.993426e-04
Rgh_62_3 g_62_3 g_63_3 4.993426e-04
Rgv_62_3 g_62_3 g_62_4 4.993426e-04
Rgh_62_4 g_62_4 g_63_4 4.993426e-04
Rgv_62_4 g_62_4 g_62_5 4.993426e-04
Rgh_62_5 g_62_5 g_63_5 4.993426e-04
Rgv_62_5 g_62_5 g_62_6 4.993426e-04
Rgh_62_6 g_62_6 g_63_6 4.993426e-04
Rgv_62_6 g_62_6 g_62_7 4.993426e-04
Rgh_62_7 g_62_7 g_63_7 4.993426e-04
Rgv_62_7 g_62_7 g_62_8 4.993426e-04
Rgh_62_8 g_62_8 g_63_8 4.993426e-04
Rgv_62_8 g_62_8 g_62_9 4.993426e-04
Rgh_62_9 g_62_9 g_63_9 4.993426e-04
Rgv_62_9 g_62_9 g_62_10 4.993426e-04
Rgh_62_10 g_62_10 g_63_10 4.993426e-04
Rgv_62_10 g_62_10 g_62_11 4.993426e-04
Rgh_62_11 g_62_11 g_63_11 4.993426e-04
Rgv_62_11 g_62_11 g_62_12 4.993426e-04
Rgh_62_12 g_62_12 g_63_12 4.993426e-04
Rgv_62_12 g_62_12 g_62_13 4.993426e-04
Rgh_62_13 g_62_13 g_63_13 4.993426e-04
Rgv_62_13 g_62_13 g_62_14 4.993426e-04
Rgh_62_14 g_62_14 g_63_14 4.993426e-04
Rgv_62_14 g_62_14 g_62_15 4.993426e-04
Rgh_62_15 g_62_15 g_63_15 4.993426e-04
Rgv_62_15 g_62_15 g_62_16 4.993426e-04
Rgh_62_16 g_62_16 g_63_16 4.993426e-04
Rgv_62_16 g_62_16 g_62_17 4.993426e-04
Rgh_62_17 g_62_17 g_63_17 4.993426e-04
Rgv_62_17 g_62_17 g_62_18 4.993426e-04
Rgh_62_18 g_62_18 g_63_18 4.993426e-04
Rgv_62_18 g_62_18 g_62_19 4.993426e-04
Rgh_62_19 g_62_19 g_63_19 4.993426e-04
Rgv_62_19 g_62_19 g_62_20 4.993426e-04
Rgh_62_20 g_62_20 g_63_20 4.993426e-04
Rgv_62_20 g_62_20 g_62_21 4.993426e-04
Rgh_62_21 g_62_21 g_63_21 4.993426e-04
Rgv_62_21 g_62_21 g_62_22 4.993426e-04
Rgh_62_22 g_62_22 g_63_22 4.993426e-04
Rgv_62_22 g_62_22 g_62_23 4.993426e-04
Rgh_62_23 g_62_23 g_63_23 4.993426e-04
Rgv_62_23 g_62_23 g_62_24 4.993426e-04
Rgh_62_24 g_62_24 g_63_24 4.993426e-04
Rgv_62_24 g_62_24 g_62_25 4.993426e-04
Rgh_62_25 g_62_25 g_63_25 4.993426e-04
Rgv_62_25 g_62_25 g_62_26 4.993426e-04
Rgh_62_26 g_62_26 g_63_26 4.993426e-04
Rgv_62_26 g_62_26 g_62_27 4.993426e-04
Rgh_62_27 g_62_27 g_63_27 4.993426e-04
Rgv_62_27 g_62_27 g_62_28 4.993426e-04
Rgh_62_28 g_62_28 g_63_28 4.993426e-04
Rgv_62_28 g_62_28 g_62_29 4.993426e-04
Rgh_62_29 g_62_29 g_63_29 4.993426e-04
Rgv_62_29 g_62_29 g_62_30 4.993426e-04
Rgh_62_30 g_62_30 g_63_30 4.993426e-04
Rgv_62_30 g_62_30 g_62_31 4.993426e-04
Rgh_62_31 g_62_31 g_63_31 4.993426e-04
Rgv_62_31 g_62_31 g_62_32 4.993426e-04
Rgh_62_32 g_62_32 g_63_32 4.993426e-04
Rgv_62_32 g_62_32 g_62_33 4.993426e-04
Rgh_62_33 g_62_33 g_63_33 4.993426e-04
Rgv_62_33 g_62_33 g_62_34 4.993426e-04
Rgh_62_34 g_62_34 g_63_34 4.993426e-04
Rgv_62_34 g_62_34 g_62_35 4.993426e-04
Rgh_62_35 g_62_35 g_63_35 4.993426e-04
Rgv_62_35 g_62_35 g_62_36 4.993426e-04
Rgh_62_36 g_62_36 g_63_36 4.993426e-04
Rgv_62_36 g_62_36 g_62_37 4.993426e-04
Rgh_62_37 g_62_37 g_63_37 4.993426e-04
Rgv_62_37 g_62_37 g_62_38 4.993426e-04
Rgh_62_38 g_62_38 g_63_38 4.993426e-04
Rgv_62_38 g_62_38 g_62_39 4.993426e-04
Rgh_62_39 g_62_39 g_63_39 4.993426e-04
Rgv_62_39 g_62_39 g_62_40 4.993426e-04
Rgh_62_40 g_62_40 g_63_40 4.993426e-04
Rgv_62_40 g_62_40 g_62_41 4.993426e-04
Rgh_62_41 g_62_41 g_63_41 4.993426e-04
Rgv_62_41 g_62_41 g_62_42 4.993426e-04
Rgh_62_42 g_62_42 g_63_42 4.993426e-04
Rgv_62_42 g_62_42 g_62_43 4.993426e-04
Rgh_62_43 g_62_43 g_63_43 4.993426e-04
Rgv_62_43 g_62_43 g_62_44 4.993426e-04
Rgh_62_44 g_62_44 g_63_44 4.993426e-04
Rgv_62_44 g_62_44 g_62_45 4.993426e-04
Rgh_62_45 g_62_45 g_63_45 4.993426e-04
Rgv_62_45 g_62_45 g_62_46 4.993426e-04
Rgh_62_46 g_62_46 g_63_46 4.993426e-04
Rgv_62_46 g_62_46 g_62_47 4.993426e-04
Rgh_62_47 g_62_47 g_63_47 4.993426e-04
Rgv_62_47 g_62_47 g_62_48 4.993426e-04
Rgh_62_48 g_62_48 g_63_48 4.993426e-04
Rgv_62_48 g_62_48 g_62_49 4.993426e-04
Rgh_62_49 g_62_49 g_63_49 4.993426e-04
Rgv_62_49 g_62_49 g_62_50 4.993426e-04
Rgh_62_50 g_62_50 g_63_50 4.993426e-04
Rgv_62_50 g_62_50 g_62_51 4.993426e-04
Rgh_62_51 g_62_51 g_63_51 4.993426e-04
Rgv_62_51 g_62_51 g_62_52 4.993426e-04
Rgh_62_52 g_62_52 g_63_52 4.993426e-04
Rgv_62_52 g_62_52 g_62_53 4.993426e-04
Rgh_62_53 g_62_53 g_63_53 4.993426e-04
Rgv_62_53 g_62_53 g_62_54 4.993426e-04
Rgh_62_54 g_62_54 g_63_54 4.993426e-04
Rgv_62_54 g_62_54 g_62_55 4.993426e-04
Rgh_62_55 g_62_55 g_63_55 4.993426e-04
Rgv_62_55 g_62_55 g_62_56 4.993426e-04
Rgh_62_56 g_62_56 g_63_56 4.993426e-04
Rgv_62_56 g_62_56 g_62_57 4.993426e-04
Rgh_62_57 g_62_57 g_63_57 4.993426e-04
Rgv_62_57 g_62_57 g_62_58 4.993426e-04
Rgh_62_58 g_62_58 g_63_58 4.993426e-04
Rgv_62_58 g_62_58 g_62_59 4.993426e-04
Rgh_62_59 g_62_59 g_63_59 4.993426e-04
Rgv_62_59 g_62_59 g_62_60 4.993426e-04
Rgh_62_60 g_62_60 g_63_60 4.993426e-04
Rgv_62_60 g_62_60 g_62_61 4.993426e-04
Rgh_62_61 g_62_61 g_63_61 4.993426e-04
Rgv_62_61 g_62_61 g_62_62 4.993426e-04
Rgh_62_62 g_62_62 g_63_62 4.993426e-04
Rgv_62_62 g_62_62 g_62_63 4.993426e-04
Rgh_62_63 g_62_63 g_63_63 4.993426e-04
Rgv_62_63 g_62_63 g_62_64 4.993426e-04
Rgh_62_64 g_62_64 g_63_64 4.993426e-04
Rgv_62_64 g_62_64 g_62_65 4.993426e-04
Rgh_62_65 g_62_65 g_63_65 4.993426e-04
Rgv_62_65 g_62_65 g_62_66 4.993426e-04
Rgh_62_66 g_62_66 g_63_66 4.993426e-04
Rgv_62_66 g_62_66 g_62_67 4.993426e-04
Rgh_62_67 g_62_67 g_63_67 4.993426e-04
Rgv_62_67 g_62_67 g_62_68 4.993426e-04
Rgh_62_68 g_62_68 g_63_68 4.993426e-04
Rgv_62_68 g_62_68 g_62_69 4.993426e-04
Rgh_62_69 g_62_69 g_63_69 4.993426e-04
Rgv_62_69 g_62_69 g_62_70 4.993426e-04
Rgh_62_70 g_62_70 g_63_70 4.993426e-04
Rgv_62_70 g_62_70 g_62_71 4.993426e-04
Rgh_62_71 g_62_71 g_63_71 4.993426e-04
Rgv_63_0 g_63_0 g_63_1 4.993426e-04
Rgv_63_1 g_63_1 g_63_2 4.993426e-04
Rgv_63_2 g_63_2 g_63_3 4.993426e-04
Rgv_63_3 g_63_3 g_63_4 4.993426e-04
Rgv_63_4 g_63_4 g_63_5 4.993426e-04
Rgv_63_5 g_63_5 g_63_6 4.993426e-04
Rgv_63_6 g_63_6 g_63_7 4.993426e-04
Rgv_63_7 g_63_7 g_63_8 4.993426e-04
Rgv_63_8 g_63_8 g_63_9 4.993426e-04
Rgv_63_9 g_63_9 g_63_10 4.993426e-04
Rgv_63_10 g_63_10 g_63_11 4.993426e-04
Rgv_63_11 g_63_11 g_63_12 4.993426e-04
Rgv_63_12 g_63_12 g_63_13 4.993426e-04
Rgv_63_13 g_63_13 g_63_14 4.993426e-04
Rgv_63_14 g_63_14 g_63_15 4.993426e-04
Rgv_63_15 g_63_15 g_63_16 4.993426e-04
Rgv_63_16 g_63_16 g_63_17 4.993426e-04
Rgv_63_17 g_63_17 g_63_18 4.993426e-04
Rgv_63_18 g_63_18 g_63_19 4.993426e-04
Rgv_63_19 g_63_19 g_63_20 4.993426e-04
Rgv_63_20 g_63_20 g_63_21 4.993426e-04
Rgv_63_21 g_63_21 g_63_22 4.993426e-04
Rgv_63_22 g_63_22 g_63_23 4.993426e-04
Rgv_63_23 g_63_23 g_63_24 4.993426e-04
Rgv_63_24 g_63_24 g_63_25 4.993426e-04
Rgv_63_25 g_63_25 g_63_26 4.993426e-04
Rgv_63_26 g_63_26 g_63_27 4.993426e-04
Rgv_63_27 g_63_27 g_63_28 4.993426e-04
Rgv_63_28 g_63_28 g_63_29 4.993426e-04
Rgv_63_29 g_63_29 g_63_30 4.993426e-04
Rgv_63_30 g_63_30 g_63_31 4.993426e-04
Rgv_63_31 g_63_31 g_63_32 4.993426e-04
Rgv_63_32 g_63_32 g_63_33 4.993426e-04
Rgv_63_33 g_63_33 g_63_34 4.993426e-04
Rgv_63_34 g_63_34 g_63_35 4.993426e-04
Rgv_63_35 g_63_35 g_63_36 4.993426e-04
Rgv_63_36 g_63_36 g_63_37 4.993426e-04
Rgv_63_37 g_63_37 g_63_38 4.993426e-04
Rgv_63_38 g_63_38 g_63_39 4.993426e-04
Rgv_63_39 g_63_39 g_63_40 4.993426e-04
Rgv_63_40 g_63_40 g_63_41 4.993426e-04
Rgv_63_41 g_63_41 g_63_42 4.993426e-04
Rgv_63_42 g_63_42 g_63_43 4.993426e-04
Rgv_63_43 g_63_43 g_63_44 4.993426e-04
Rgv_63_44 g_63_44 g_63_45 4.993426e-04
Rgv_63_45 g_63_45 g_63_46 4.993426e-04
Rgv_63_46 g_63_46 g_63_47 4.993426e-04
Rgv_63_47 g_63_47 g_63_48 4.993426e-04
Rgv_63_48 g_63_48 g_63_49 4.993426e-04
Rgv_63_49 g_63_49 g_63_50 4.993426e-04
Rgv_63_50 g_63_50 g_63_51 4.993426e-04
Rgv_63_51 g_63_51 g_63_52 4.993426e-04
Rgv_63_52 g_63_52 g_63_53 4.993426e-04
Rgv_63_53 g_63_53 g_63_54 4.993426e-04
Rgv_63_54 g_63_54 g_63_55 4.993426e-04
Rgv_63_55 g_63_55 g_63_56 4.993426e-04
Rgv_63_56 g_63_56 g_63_57 4.993426e-04
Rgv_63_57 g_63_57 g_63_58 4.993426e-04
Rgv_63_58 g_63_58 g_63_59 4.993426e-04
Rgv_63_59 g_63_59 g_63_60 4.993426e-04
Rgv_63_60 g_63_60 g_63_61 4.993426e-04
Rgv_63_61 g_63_61 g_63_62 4.993426e-04
Rgv_63_62 g_63_62 g_63_63 4.993426e-04
Rgv_63_63 g_63_63 g_63_64 4.993426e-04
Rgv_63_64 g_63_64 g_63_65 4.993426e-04
Rgv_63_65 g_63_65 g_63_66 4.993426e-04
Rgv_63_66 g_63_66 g_63_67 4.993426e-04
Rgv_63_67 g_63_67 g_63_68 4.993426e-04
Rgv_63_68 g_63_68 g_63_69 4.993426e-04
Rgv_63_69 g_63_69 g_63_70 4.993426e-04
Rgv_63_70 g_63_70 g_63_71 4.993426e-04
Rlh_0_0 l_0_0 l_1_0 5.008854e-04
Rlv_0_0 l_0_0 l_0_1 5.008854e-04
Rlh_0_1 l_0_1 l_1_1 5.008854e-04
Rlv_0_1 l_0_1 l_0_2 5.008854e-04
Rlh_0_2 l_0_2 l_1_2 5.008854e-04
Rlv_0_2 l_0_2 l_0_3 5.008854e-04
Rlh_0_3 l_0_3 l_1_3 5.008854e-04
Rlv_0_3 l_0_3 l_0_4 5.008854e-04
Rlh_0_4 l_0_4 l_1_4 5.008854e-04
Rlv_0_4 l_0_4 l_0_5 5.008854e-04
Rlh_0_5 l_0_5 l_1_5 5.008854e-04
Rlv_0_5 l_0_5 l_0_6 5.008854e-04
Rlh_0_6 l_0_6 l_1_6 5.008854e-04
Rlv_0_6 l_0_6 l_0_7 5.008854e-04
Rlh_0_7 l_0_7 l_1_7 5.008854e-04
Rlv_0_7 l_0_7 l_0_8 5.008854e-04
Rlh_0_8 l_0_8 l_1_8 5.008854e-04
Rlv_0_8 l_0_8 l_0_9 5.008854e-04
Rlh_0_9 l_0_9 l_1_9 5.008854e-04
Rlv_0_9 l_0_9 l_0_10 5.008854e-04
Rlh_0_10 l_0_10 l_1_10 5.008854e-04
Rlv_0_10 l_0_10 l_0_11 5.008854e-04
Rlh_0_11 l_0_11 l_1_11 5.008854e-04
Rlv_0_11 l_0_11 l_0_12 5.008854e-04
Rlh_0_12 l_0_12 l_1_12 5.008854e-04
Rlv_0_12 l_0_12 l_0_13 5.008854e-04
Rlh_0_13 l_0_13 l_1_13 5.008854e-04
Rlv_0_13 l_0_13 l_0_14 5.008854e-04
Rlh_0_14 l_0_14 l_1_14 5.008854e-04
Rlv_0_14 l_0_14 l_0_15 5.008854e-04
Rlh_0_15 l_0_15 l_1_15 5.008854e-04
Rlv_0_15 l_0_15 l_0_16 5.008854e-04
Rlh_0_16 l_0_16 l_1_16 5.008854e-04
Rlv_0_16 l_0_16 l_0_17 5.008854e-04
Rlh_0_17 l_0_17 l_1_17 5.008854e-04
Rlv_0_17 l_0_17 l_0_18 5.008854e-04
Rlh_0_18 l_0_18 l_1_18 5.008854e-04
Rlv_0_18 l_0_18 l_0_19 5.008854e-04
Rlh_0_19 l_0_19 l_1_19 5.008854e-04
Rlv_0_19 l_0_19 l_0_20 5.008854e-04
Rlh_0_20 l_0_20 l_1_20 5.008854e-04
Rlv_0_20 l_0_20 l_0_21 5.008854e-04
Rlh_0_21 l_0_21 l_1_21 5.008854e-04
Rlv_0_21 l_0_21 l_0_22 5.008854e-04
Rlh_0_22 l_0_22 l_1_22 5.008854e-04
Rlv_0_22 l_0_22 l_0_23 5.008854e-04
Rlh_0_23 l_0_23 l_1_23 5.008854e-04
Rlv_0_23 l_0_23 l_0_24 5.008854e-04
Rlh_0_24 l_0_24 l_1_24 5.008854e-04
Rlv_0_24 l_0_24 l_0_25 5.008854e-04
Rlh_0_25 l_0_25 l_1_25 5.008854e-04
Rlv_0_25 l_0_25 l_0_26 5.008854e-04
Rlh_0_26 l_0_26 l_1_26 5.008854e-04
Rlv_0_26 l_0_26 l_0_27 5.008854e-04
Rlh_0_27 l_0_27 l_1_27 5.008854e-04
Rlv_0_27 l_0_27 l_0_28 5.008854e-04
Rlh_0_28 l_0_28 l_1_28 5.008854e-04
Rlv_0_28 l_0_28 l_0_29 5.008854e-04
Rlh_0_29 l_0_29 l_1_29 5.008854e-04
Rlv_0_29 l_0_29 l_0_30 5.008854e-04
Rlh_0_30 l_0_30 l_1_30 5.008854e-04
Rlv_0_30 l_0_30 l_0_31 5.008854e-04
Rlh_0_31 l_0_31 l_1_31 5.008854e-04
Rlv_0_31 l_0_31 l_0_32 5.008854e-04
Rlh_0_32 l_0_32 l_1_32 5.008854e-04
Rlv_0_32 l_0_32 l_0_33 5.008854e-04
Rlh_0_33 l_0_33 l_1_33 5.008854e-04
Rlv_0_33 l_0_33 l_0_34 5.008854e-04
Rlh_0_34 l_0_34 l_1_34 5.008854e-04
Rlv_0_34 l_0_34 l_0_35 5.008854e-04
Rlh_0_35 l_0_35 l_1_35 5.008854e-04
Rlv_0_35 l_0_35 l_0_36 5.008854e-04
Rlh_0_36 l_0_36 l_1_36 5.008854e-04
Rlv_0_36 l_0_36 l_0_37 5.008854e-04
Rlh_0_37 l_0_37 l_1_37 5.008854e-04
Rlv_0_37 l_0_37 l_0_38 5.008854e-04
Rlh_0_38 l_0_38 l_1_38 5.008854e-04
Rlv_0_38 l_0_38 l_0_39 5.008854e-04
Rlh_0_39 l_0_39 l_1_39 5.008854e-04
Rlv_0_39 l_0_39 l_0_40 5.008854e-04
Rlh_0_40 l_0_40 l_1_40 5.008854e-04
Rlv_0_40 l_0_40 l_0_41 5.008854e-04
Rlh_0_41 l_0_41 l_1_41 5.008854e-04
Rlv_0_41 l_0_41 l_0_42 5.008854e-04
Rlh_0_42 l_0_42 l_1_42 5.008854e-04
Rlv_0_42 l_0_42 l_0_43 5.008854e-04
Rlh_0_43 l_0_43 l_1_43 5.008854e-04
Rlv_0_43 l_0_43 l_0_44 5.008854e-04
Rlh_0_44 l_0_44 l_1_44 5.008854e-04
Rlv_0_44 l_0_44 l_0_45 5.008854e-04
Rlh_0_45 l_0_45 l_1_45 5.008854e-04
Rlv_0_45 l_0_45 l_0_46 5.008854e-04
Rlh_0_46 l_0_46 l_1_46 5.008854e-04
Rlv_0_46 l_0_46 l_0_47 5.008854e-04
Rlh_0_47 l_0_47 l_1_47 5.008854e-04
Rlv_0_47 l_0_47 l_0_48 5.008854e-04
Rlh_0_48 l_0_48 l_1_48 5.008854e-04
Rlv_0_48 l_0_48 l_0_49 5.008854e-04
Rlh_0_49 l_0_49 l_1_49 5.008854e-04
Rlv_0_49 l_0_49 l_0_50 5.008854e-04
Rlh_0_50 l_0_50 l_1_50 5.008854e-04
Rlv_0_50 l_0_50 l_0_51 5.008854e-04
Rlh_0_51 l_0_51 l_1_51 5.008854e-04
Rlv_0_51 l_0_51 l_0_52 5.008854e-04
Rlh_0_52 l_0_52 l_1_52 5.008854e-04
Rlv_0_52 l_0_52 l_0_53 5.008854e-04
Rlh_0_53 l_0_53 l_1_53 5.008854e-04
Rlv_0_53 l_0_53 l_0_54 5.008854e-04
Rlh_0_54 l_0_54 l_1_54 5.008854e-04
Rlv_0_54 l_0_54 l_0_55 5.008854e-04
Rlh_0_55 l_0_55 l_1_55 5.008854e-04
Rlv_0_55 l_0_55 l_0_56 5.008854e-04
Rlh_0_56 l_0_56 l_1_56 5.008854e-04
Rlv_0_56 l_0_56 l_0_57 5.008854e-04
Rlh_0_57 l_0_57 l_1_57 5.008854e-04
Rlv_0_57 l_0_57 l_0_58 5.008854e-04
Rlh_0_58 l_0_58 l_1_58 5.008854e-04
Rlv_0_58 l_0_58 l_0_59 5.008854e-04
Rlh_0_59 l_0_59 l_1_59 5.008854e-04
Rlv_0_59 l_0_59 l_0_60 5.008854e-04
Rlh_0_60 l_0_60 l_1_60 5.008854e-04
Rlv_0_60 l_0_60 l_0_61 5.008854e-04
Rlh_0_61 l_0_61 l_1_61 5.008854e-04
Rlv_0_61 l_0_61 l_0_62 5.008854e-04
Rlh_0_62 l_0_62 l_1_62 5.008854e-04
Rlv_0_62 l_0_62 l_0_63 5.008854e-04
Rlh_0_63 l_0_63 l_1_63 5.008854e-04
Rlv_0_63 l_0_63 l_0_64 5.008854e-04
Rlh_0_64 l_0_64 l_1_64 5.008854e-04
Rlv_0_64 l_0_64 l_0_65 5.008854e-04
Rlh_0_65 l_0_65 l_1_65 5.008854e-04
Rlv_0_65 l_0_65 l_0_66 5.008854e-04
Rlh_0_66 l_0_66 l_1_66 5.008854e-04
Rlv_0_66 l_0_66 l_0_67 5.008854e-04
Rlh_0_67 l_0_67 l_1_67 5.008854e-04
Rlv_0_67 l_0_67 l_0_68 5.008854e-04
Rlh_0_68 l_0_68 l_1_68 5.008854e-04
Rlv_0_68 l_0_68 l_0_69 5.008854e-04
Rlh_0_69 l_0_69 l_1_69 5.008854e-04
Rlv_0_69 l_0_69 l_0_70 5.008854e-04
Rlh_0_70 l_0_70 l_1_70 5.008854e-04
Rlv_0_70 l_0_70 l_0_71 5.008854e-04
Rlh_0_71 l_0_71 l_1_71 5.008854e-04
Rlh_1_0 l_1_0 l_2_0 5.008854e-04
Rlv_1_0 l_1_0 l_1_1 5.008854e-04
Rlh_1_1 l_1_1 l_2_1 5.008854e-04
Rlv_1_1 l_1_1 l_1_2 5.008854e-04
Rlh_1_2 l_1_2 l_2_2 5.008854e-04
Rlv_1_2 l_1_2 l_1_3 5.008854e-04
Rlh_1_3 l_1_3 l_2_3 5.008854e-04
Rlv_1_3 l_1_3 l_1_4 5.008854e-04
Rlh_1_4 l_1_4 l_2_4 5.008854e-04
Rlv_1_4 l_1_4 l_1_5 5.008854e-04
Rlh_1_5 l_1_5 l_2_5 5.008854e-04
Rlv_1_5 l_1_5 l_1_6 5.008854e-04
Rlh_1_6 l_1_6 l_2_6 5.008854e-04
Rlv_1_6 l_1_6 l_1_7 5.008854e-04
Rlh_1_7 l_1_7 l_2_7 5.008854e-04
Rlv_1_7 l_1_7 l_1_8 5.008854e-04
Rlh_1_8 l_1_8 l_2_8 5.008854e-04
Rlv_1_8 l_1_8 l_1_9 5.008854e-04
Rlh_1_9 l_1_9 l_2_9 5.008854e-04
Rlv_1_9 l_1_9 l_1_10 5.008854e-04
Rlh_1_10 l_1_10 l_2_10 5.008854e-04
Rlv_1_10 l_1_10 l_1_11 5.008854e-04
Rlh_1_11 l_1_11 l_2_11 5.008854e-04
Rlv_1_11 l_1_11 l_1_12 5.008854e-04
Rlh_1_12 l_1_12 l_2_12 5.008854e-04
Rlv_1_12 l_1_12 l_1_13 5.008854e-04
Rlh_1_13 l_1_13 l_2_13 5.008854e-04
Rlv_1_13 l_1_13 l_1_14 5.008854e-04
Rlh_1_14 l_1_14 l_2_14 5.008854e-04
Rlv_1_14 l_1_14 l_1_15 5.008854e-04
Rlh_1_15 l_1_15 l_2_15 5.008854e-04
Rlv_1_15 l_1_15 l_1_16 5.008854e-04
Rlh_1_16 l_1_16 l_2_16 5.008854e-04
Rlv_1_16 l_1_16 l_1_17 5.008854e-04
Rlh_1_17 l_1_17 l_2_17 5.008854e-04
Rlv_1_17 l_1_17 l_1_18 5.008854e-04
Rlh_1_18 l_1_18 l_2_18 5.008854e-04
Rlv_1_18 l_1_18 l_1_19 5.008854e-04
Rlh_1_19 l_1_19 l_2_19 5.008854e-04
Rlv_1_19 l_1_19 l_1_20 5.008854e-04
Rlh_1_20 l_1_20 l_2_20 5.008854e-04
Rlv_1_20 l_1_20 l_1_21 5.008854e-04
Rlh_1_21 l_1_21 l_2_21 5.008854e-04
Rlv_1_21 l_1_21 l_1_22 5.008854e-04
Rlh_1_22 l_1_22 l_2_22 5.008854e-04
Rlv_1_22 l_1_22 l_1_23 5.008854e-04
Rlh_1_23 l_1_23 l_2_23 5.008854e-04
Rlv_1_23 l_1_23 l_1_24 5.008854e-04
Rlh_1_24 l_1_24 l_2_24 5.008854e-04
Rlv_1_24 l_1_24 l_1_25 5.008854e-04
Rlh_1_25 l_1_25 l_2_25 5.008854e-04
Rlv_1_25 l_1_25 l_1_26 5.008854e-04
Rlh_1_26 l_1_26 l_2_26 5.008854e-04
Rlv_1_26 l_1_26 l_1_27 5.008854e-04
Rlh_1_27 l_1_27 l_2_27 5.008854e-04
Rlv_1_27 l_1_27 l_1_28 5.008854e-04
Rlh_1_28 l_1_28 l_2_28 5.008854e-04
Rlv_1_28 l_1_28 l_1_29 5.008854e-04
Rlh_1_29 l_1_29 l_2_29 5.008854e-04
Rlv_1_29 l_1_29 l_1_30 5.008854e-04
Rlh_1_30 l_1_30 l_2_30 5.008854e-04
Rlv_1_30 l_1_30 l_1_31 5.008854e-04
Rlh_1_31 l_1_31 l_2_31 5.008854e-04
Rlv_1_31 l_1_31 l_1_32 5.008854e-04
Rlh_1_32 l_1_32 l_2_32 5.008854e-04
Rlv_1_32 l_1_32 l_1_33 5.008854e-04
Rlh_1_33 l_1_33 l_2_33 5.008854e-04
Rlv_1_33 l_1_33 l_1_34 5.008854e-04
Rlh_1_34 l_1_34 l_2_34 5.008854e-04
Rlv_1_34 l_1_34 l_1_35 5.008854e-04
Rlh_1_35 l_1_35 l_2_35 5.008854e-04
Rlv_1_35 l_1_35 l_1_36 5.008854e-04
Rlh_1_36 l_1_36 l_2_36 5.008854e-04
Rlv_1_36 l_1_36 l_1_37 5.008854e-04
Rlh_1_37 l_1_37 l_2_37 5.008854e-04
Rlv_1_37 l_1_37 l_1_38 5.008854e-04
Rlh_1_38 l_1_38 l_2_38 5.008854e-04
Rlv_1_38 l_1_38 l_1_39 5.008854e-04
Rlh_1_39 l_1_39 l_2_39 5.008854e-04
Rlv_1_39 l_1_39 l_1_40 5.008854e-04
Rlh_1_40 l_1_40 l_2_40 5.008854e-04
Rlv_1_40 l_1_40 l_1_41 5.008854e-04
Rlh_1_41 l_1_41 l_2_41 5.008854e-04
Rlv_1_41 l_1_41 l_1_42 5.008854e-04
Rlh_1_42 l_1_42 l_2_42 5.008854e-04
Rlv_1_42 l_1_42 l_1_43 5.008854e-04
Rlh_1_43 l_1_43 l_2_43 5.008854e-04
Rlv_1_43 l_1_43 l_1_44 5.008854e-04
Rlh_1_44 l_1_44 l_2_44 5.008854e-04
Rlv_1_44 l_1_44 l_1_45 5.008854e-04
Rlh_1_45 l_1_45 l_2_45 5.008854e-04
Rlv_1_45 l_1_45 l_1_46 5.008854e-04
Rlh_1_46 l_1_46 l_2_46 5.008854e-04
Rlv_1_46 l_1_46 l_1_47 5.008854e-04
Rlh_1_47 l_1_47 l_2_47 5.008854e-04
Rlv_1_47 l_1_47 l_1_48 5.008854e-04
Rlh_1_48 l_1_48 l_2_48 5.008854e-04
Rlv_1_48 l_1_48 l_1_49 5.008854e-04
Rlh_1_49 l_1_49 l_2_49 5.008854e-04
Rlv_1_49 l_1_49 l_1_50 5.008854e-04
Rlh_1_50 l_1_50 l_2_50 5.008854e-04
Rlv_1_50 l_1_50 l_1_51 5.008854e-04
Rlh_1_51 l_1_51 l_2_51 5.008854e-04
Rlv_1_51 l_1_51 l_1_52 5.008854e-04
Rlh_1_52 l_1_52 l_2_52 5.008854e-04
Rlv_1_52 l_1_52 l_1_53 5.008854e-04
Rlh_1_53 l_1_53 l_2_53 5.008854e-04
Rlv_1_53 l_1_53 l_1_54 5.008854e-04
Rlh_1_54 l_1_54 l_2_54 5.008854e-04
Rlv_1_54 l_1_54 l_1_55 5.008854e-04
Rlh_1_55 l_1_55 l_2_55 5.008854e-04
Rlv_1_55 l_1_55 l_1_56 5.008854e-04
Rlh_1_56 l_1_56 l_2_56 5.008854e-04
Rlv_1_56 l_1_56 l_1_57 5.008854e-04
Rlh_1_57 l_1_57 l_2_57 5.008854e-04
Rlv_1_57 l_1_57 l_1_58 5.008854e-04
Rlh_1_58 l_1_58 l_2_58 5.008854e-04
Rlv_1_58 l_1_58 l_1_59 5.008854e-04
Rlh_1_59 l_1_59 l_2_59 5.008854e-04
Rlv_1_59 l_1_59 l_1_60 5.008854e-04
Rlh_1_60 l_1_60 l_2_60 5.008854e-04
Rlv_1_60 l_1_60 l_1_61 5.008854e-04
Rlh_1_61 l_1_61 l_2_61 5.008854e-04
Rlv_1_61 l_1_61 l_1_62 5.008854e-04
Rlh_1_62 l_1_62 l_2_62 5.008854e-04
Rlv_1_62 l_1_62 l_1_63 5.008854e-04
Rlh_1_63 l_1_63 l_2_63 5.008854e-04
Rlv_1_63 l_1_63 l_1_64 5.008854e-04
Rlh_1_64 l_1_64 l_2_64 5.008854e-04
Rlv_1_64 l_1_64 l_1_65 5.008854e-04
Rlh_1_65 l_1_65 l_2_65 5.008854e-04
Rlv_1_65 l_1_65 l_1_66 5.008854e-04
Rlh_1_66 l_1_66 l_2_66 5.008854e-04
Rlv_1_66 l_1_66 l_1_67 5.008854e-04
Rlh_1_67 l_1_67 l_2_67 5.008854e-04
Rlv_1_67 l_1_67 l_1_68 5.008854e-04
Rlh_1_68 l_1_68 l_2_68 5.008854e-04
Rlv_1_68 l_1_68 l_1_69 5.008854e-04
Rlh_1_69 l_1_69 l_2_69 5.008854e-04
Rlv_1_69 l_1_69 l_1_70 5.008854e-04
Rlh_1_70 l_1_70 l_2_70 5.008854e-04
Rlv_1_70 l_1_70 l_1_71 5.008854e-04
Rlh_1_71 l_1_71 l_2_71 5.008854e-04
Rlh_2_0 l_2_0 l_3_0 5.008854e-04
Rlv_2_0 l_2_0 l_2_1 5.008854e-04
Rlh_2_1 l_2_1 l_3_1 5.008854e-04
Rlv_2_1 l_2_1 l_2_2 5.008854e-04
Rlh_2_2 l_2_2 l_3_2 5.008854e-04
Rlv_2_2 l_2_2 l_2_3 5.008854e-04
Rlh_2_3 l_2_3 l_3_3 5.008854e-04
Rlv_2_3 l_2_3 l_2_4 5.008854e-04
Rlh_2_4 l_2_4 l_3_4 5.008854e-04
Rlv_2_4 l_2_4 l_2_5 5.008854e-04
Rlh_2_5 l_2_5 l_3_5 5.008854e-04
Rlv_2_5 l_2_5 l_2_6 5.008854e-04
Rlh_2_6 l_2_6 l_3_6 5.008854e-04
Rlv_2_6 l_2_6 l_2_7 5.008854e-04
Rlh_2_7 l_2_7 l_3_7 5.008854e-04
Rlv_2_7 l_2_7 l_2_8 5.008854e-04
Rlh_2_8 l_2_8 l_3_8 5.008854e-04
Rlv_2_8 l_2_8 l_2_9 5.008854e-04
Rlh_2_9 l_2_9 l_3_9 5.008854e-04
Rlv_2_9 l_2_9 l_2_10 5.008854e-04
Rlh_2_10 l_2_10 l_3_10 5.008854e-04
Rlv_2_10 l_2_10 l_2_11 5.008854e-04
Rlh_2_11 l_2_11 l_3_11 5.008854e-04
Rlv_2_11 l_2_11 l_2_12 5.008854e-04
Rlh_2_12 l_2_12 l_3_12 5.008854e-04
Rlv_2_12 l_2_12 l_2_13 5.008854e-04
Rlh_2_13 l_2_13 l_3_13 5.008854e-04
Rlv_2_13 l_2_13 l_2_14 5.008854e-04
Rlh_2_14 l_2_14 l_3_14 5.008854e-04
Rlv_2_14 l_2_14 l_2_15 5.008854e-04
Rlh_2_15 l_2_15 l_3_15 5.008854e-04
Rlv_2_15 l_2_15 l_2_16 5.008854e-04
Rlh_2_16 l_2_16 l_3_16 5.008854e-04
Rlv_2_16 l_2_16 l_2_17 5.008854e-04
Rlh_2_17 l_2_17 l_3_17 5.008854e-04
Rlv_2_17 l_2_17 l_2_18 5.008854e-04
Rlh_2_18 l_2_18 l_3_18 5.008854e-04
Rlv_2_18 l_2_18 l_2_19 5.008854e-04
Rlh_2_19 l_2_19 l_3_19 5.008854e-04
Rlv_2_19 l_2_19 l_2_20 5.008854e-04
Rlh_2_20 l_2_20 l_3_20 5.008854e-04
Rlv_2_20 l_2_20 l_2_21 5.008854e-04
Rlh_2_21 l_2_21 l_3_21 5.008854e-04
Rlv_2_21 l_2_21 l_2_22 5.008854e-04
Rlh_2_22 l_2_22 l_3_22 5.008854e-04
Rlv_2_22 l_2_22 l_2_23 5.008854e-04
Rlh_2_23 l_2_23 l_3_23 5.008854e-04
Rlv_2_23 l_2_23 l_2_24 5.008854e-04
Rlh_2_24 l_2_24 l_3_24 5.008854e-04
Rlv_2_24 l_2_24 l_2_25 5.008854e-04
Rlh_2_25 l_2_25 l_3_25 5.008854e-04
Rlv_2_25 l_2_25 l_2_26 5.008854e-04
Rlh_2_26 l_2_26 l_3_26 5.008854e-04
Rlv_2_26 l_2_26 l_2_27 5.008854e-04
Rlh_2_27 l_2_27 l_3_27 5.008854e-04
Rlv_2_27 l_2_27 l_2_28 5.008854e-04
Rlh_2_28 l_2_28 l_3_28 5.008854e-04
Rlv_2_28 l_2_28 l_2_29 5.008854e-04
Rlh_2_29 l_2_29 l_3_29 5.008854e-04
Rlv_2_29 l_2_29 l_2_30 5.008854e-04
Rlh_2_30 l_2_30 l_3_30 5.008854e-04
Rlv_2_30 l_2_30 l_2_31 5.008854e-04
Rlh_2_31 l_2_31 l_3_31 5.008854e-04
Rlv_2_31 l_2_31 l_2_32 5.008854e-04
Rlh_2_32 l_2_32 l_3_32 5.008854e-04
Rlv_2_32 l_2_32 l_2_33 5.008854e-04
Rlh_2_33 l_2_33 l_3_33 5.008854e-04
Rlv_2_33 l_2_33 l_2_34 5.008854e-04
Rlh_2_34 l_2_34 l_3_34 5.008854e-04
Rlv_2_34 l_2_34 l_2_35 5.008854e-04
Rlh_2_35 l_2_35 l_3_35 5.008854e-04
Rlv_2_35 l_2_35 l_2_36 5.008854e-04
Rlh_2_36 l_2_36 l_3_36 5.008854e-04
Rlv_2_36 l_2_36 l_2_37 5.008854e-04
Rlh_2_37 l_2_37 l_3_37 5.008854e-04
Rlv_2_37 l_2_37 l_2_38 5.008854e-04
Rlh_2_38 l_2_38 l_3_38 5.008854e-04
Rlv_2_38 l_2_38 l_2_39 5.008854e-04
Rlh_2_39 l_2_39 l_3_39 5.008854e-04
Rlv_2_39 l_2_39 l_2_40 5.008854e-04
Rlh_2_40 l_2_40 l_3_40 5.008854e-04
Rlv_2_40 l_2_40 l_2_41 5.008854e-04
Rlh_2_41 l_2_41 l_3_41 5.008854e-04
Rlv_2_41 l_2_41 l_2_42 5.008854e-04
Rlh_2_42 l_2_42 l_3_42 5.008854e-04
Rlv_2_42 l_2_42 l_2_43 5.008854e-04
Rlh_2_43 l_2_43 l_3_43 5.008854e-04
Rlv_2_43 l_2_43 l_2_44 5.008854e-04
Rlh_2_44 l_2_44 l_3_44 5.008854e-04
Rlv_2_44 l_2_44 l_2_45 5.008854e-04
Rlh_2_45 l_2_45 l_3_45 5.008854e-04
Rlv_2_45 l_2_45 l_2_46 5.008854e-04
Rlh_2_46 l_2_46 l_3_46 5.008854e-04
Rlv_2_46 l_2_46 l_2_47 5.008854e-04
Rlh_2_47 l_2_47 l_3_47 5.008854e-04
Rlv_2_47 l_2_47 l_2_48 5.008854e-04
Rlh_2_48 l_2_48 l_3_48 5.008854e-04
Rlv_2_48 l_2_48 l_2_49 5.008854e-04
Rlh_2_49 l_2_49 l_3_49 5.008854e-04
Rlv_2_49 l_2_49 l_2_50 5.008854e-04
Rlh_2_50 l_2_50 l_3_50 5.008854e-04
Rlv_2_50 l_2_50 l_2_51 5.008854e-04
Rlh_2_51 l_2_51 l_3_51 5.008854e-04
Rlv_2_51 l_2_51 l_2_52 5.008854e-04
Rlh_2_52 l_2_52 l_3_52 5.008854e-04
Rlv_2_52 l_2_52 l_2_53 5.008854e-04
Rlh_2_53 l_2_53 l_3_53 5.008854e-04
Rlv_2_53 l_2_53 l_2_54 5.008854e-04
Rlh_2_54 l_2_54 l_3_54 5.008854e-04
Rlv_2_54 l_2_54 l_2_55 5.008854e-04
Rlh_2_55 l_2_55 l_3_55 5.008854e-04
Rlv_2_55 l_2_55 l_2_56 5.008854e-04
Rlh_2_56 l_2_56 l_3_56 5.008854e-04
Rlv_2_56 l_2_56 l_2_57 5.008854e-04
Rlh_2_57 l_2_57 l_3_57 5.008854e-04
Rlv_2_57 l_2_57 l_2_58 5.008854e-04
Rlh_2_58 l_2_58 l_3_58 5.008854e-04
Rlv_2_58 l_2_58 l_2_59 5.008854e-04
Rlh_2_59 l_2_59 l_3_59 5.008854e-04
Rlv_2_59 l_2_59 l_2_60 5.008854e-04
Rlh_2_60 l_2_60 l_3_60 5.008854e-04
Rlv_2_60 l_2_60 l_2_61 5.008854e-04
Rlh_2_61 l_2_61 l_3_61 5.008854e-04
Rlv_2_61 l_2_61 l_2_62 5.008854e-04
Rlh_2_62 l_2_62 l_3_62 5.008854e-04
Rlv_2_62 l_2_62 l_2_63 5.008854e-04
Rlh_2_63 l_2_63 l_3_63 5.008854e-04
Rlv_2_63 l_2_63 l_2_64 5.008854e-04
Rlh_2_64 l_2_64 l_3_64 5.008854e-04
Rlv_2_64 l_2_64 l_2_65 5.008854e-04
Rlh_2_65 l_2_65 l_3_65 5.008854e-04
Rlv_2_65 l_2_65 l_2_66 5.008854e-04
Rlh_2_66 l_2_66 l_3_66 5.008854e-04
Rlv_2_66 l_2_66 l_2_67 5.008854e-04
Rlh_2_67 l_2_67 l_3_67 5.008854e-04
Rlv_2_67 l_2_67 l_2_68 5.008854e-04
Rlh_2_68 l_2_68 l_3_68 5.008854e-04
Rlv_2_68 l_2_68 l_2_69 5.008854e-04
Rlh_2_69 l_2_69 l_3_69 5.008854e-04
Rlv_2_69 l_2_69 l_2_70 5.008854e-04
Rlh_2_70 l_2_70 l_3_70 5.008854e-04
Rlv_2_70 l_2_70 l_2_71 5.008854e-04
Rlh_2_71 l_2_71 l_3_71 5.008854e-04
Rlh_3_0 l_3_0 l_4_0 5.008854e-04
Rlv_3_0 l_3_0 l_3_1 5.008854e-04
Rlh_3_1 l_3_1 l_4_1 5.008854e-04
Rlv_3_1 l_3_1 l_3_2 5.008854e-04
Rlh_3_2 l_3_2 l_4_2 5.008854e-04
Rlv_3_2 l_3_2 l_3_3 5.008854e-04
Rlh_3_3 l_3_3 l_4_3 5.008854e-04
Rlv_3_3 l_3_3 l_3_4 5.008854e-04
Rlh_3_4 l_3_4 l_4_4 5.008854e-04
Rlv_3_4 l_3_4 l_3_5 5.008854e-04
Rlh_3_5 l_3_5 l_4_5 5.008854e-04
Rlv_3_5 l_3_5 l_3_6 5.008854e-04
Rlh_3_6 l_3_6 l_4_6 5.008854e-04
Rlv_3_6 l_3_6 l_3_7 5.008854e-04
Rlh_3_7 l_3_7 l_4_7 5.008854e-04
Rlv_3_7 l_3_7 l_3_8 5.008854e-04
Rlh_3_8 l_3_8 l_4_8 5.008854e-04
Rlv_3_8 l_3_8 l_3_9 5.008854e-04
Rlh_3_9 l_3_9 l_4_9 5.008854e-04
Rlv_3_9 l_3_9 l_3_10 5.008854e-04
Rlh_3_10 l_3_10 l_4_10 5.008854e-04
Rlv_3_10 l_3_10 l_3_11 5.008854e-04
Rlh_3_11 l_3_11 l_4_11 5.008854e-04
Rlv_3_11 l_3_11 l_3_12 5.008854e-04
Rlh_3_12 l_3_12 l_4_12 5.008854e-04
Rlv_3_12 l_3_12 l_3_13 5.008854e-04
Rlh_3_13 l_3_13 l_4_13 5.008854e-04
Rlv_3_13 l_3_13 l_3_14 5.008854e-04
Rlh_3_14 l_3_14 l_4_14 5.008854e-04
Rlv_3_14 l_3_14 l_3_15 5.008854e-04
Rlh_3_15 l_3_15 l_4_15 5.008854e-04
Rlv_3_15 l_3_15 l_3_16 5.008854e-04
Rlh_3_16 l_3_16 l_4_16 5.008854e-04
Rlv_3_16 l_3_16 l_3_17 5.008854e-04
Rlh_3_17 l_3_17 l_4_17 5.008854e-04
Rlv_3_17 l_3_17 l_3_18 5.008854e-04
Rlh_3_18 l_3_18 l_4_18 5.008854e-04
Rlv_3_18 l_3_18 l_3_19 5.008854e-04
Rlh_3_19 l_3_19 l_4_19 5.008854e-04
Rlv_3_19 l_3_19 l_3_20 5.008854e-04
Rlh_3_20 l_3_20 l_4_20 5.008854e-04
Rlv_3_20 l_3_20 l_3_21 5.008854e-04
Rlh_3_21 l_3_21 l_4_21 5.008854e-04
Rlv_3_21 l_3_21 l_3_22 5.008854e-04
Rlh_3_22 l_3_22 l_4_22 5.008854e-04
Rlv_3_22 l_3_22 l_3_23 5.008854e-04
Rlh_3_23 l_3_23 l_4_23 5.008854e-04
Rlv_3_23 l_3_23 l_3_24 5.008854e-04
Rlh_3_24 l_3_24 l_4_24 5.008854e-04
Rlv_3_24 l_3_24 l_3_25 5.008854e-04
Rlh_3_25 l_3_25 l_4_25 5.008854e-04
Rlv_3_25 l_3_25 l_3_26 5.008854e-04
Rlh_3_26 l_3_26 l_4_26 5.008854e-04
Rlv_3_26 l_3_26 l_3_27 5.008854e-04
Rlh_3_27 l_3_27 l_4_27 5.008854e-04
Rlv_3_27 l_3_27 l_3_28 5.008854e-04
Rlh_3_28 l_3_28 l_4_28 5.008854e-04
Rlv_3_28 l_3_28 l_3_29 5.008854e-04
Rlh_3_29 l_3_29 l_4_29 5.008854e-04
Rlv_3_29 l_3_29 l_3_30 5.008854e-04
Rlh_3_30 l_3_30 l_4_30 5.008854e-04
Rlv_3_30 l_3_30 l_3_31 5.008854e-04
Rlh_3_31 l_3_31 l_4_31 5.008854e-04
Rlv_3_31 l_3_31 l_3_32 5.008854e-04
Rlh_3_32 l_3_32 l_4_32 5.008854e-04
Rlv_3_32 l_3_32 l_3_33 5.008854e-04
Rlh_3_33 l_3_33 l_4_33 5.008854e-04
Rlv_3_33 l_3_33 l_3_34 5.008854e-04
Rlh_3_34 l_3_34 l_4_34 5.008854e-04
Rlv_3_34 l_3_34 l_3_35 5.008854e-04
Rlh_3_35 l_3_35 l_4_35 5.008854e-04
Rlv_3_35 l_3_35 l_3_36 5.008854e-04
Rlh_3_36 l_3_36 l_4_36 5.008854e-04
Rlv_3_36 l_3_36 l_3_37 5.008854e-04
Rlh_3_37 l_3_37 l_4_37 5.008854e-04
Rlv_3_37 l_3_37 l_3_38 5.008854e-04
Rlh_3_38 l_3_38 l_4_38 5.008854e-04
Rlv_3_38 l_3_38 l_3_39 5.008854e-04
Rlh_3_39 l_3_39 l_4_39 5.008854e-04
Rlv_3_39 l_3_39 l_3_40 5.008854e-04
Rlh_3_40 l_3_40 l_4_40 5.008854e-04
Rlv_3_40 l_3_40 l_3_41 5.008854e-04
Rlh_3_41 l_3_41 l_4_41 5.008854e-04
Rlv_3_41 l_3_41 l_3_42 5.008854e-04
Rlh_3_42 l_3_42 l_4_42 5.008854e-04
Rlv_3_42 l_3_42 l_3_43 5.008854e-04
Rlh_3_43 l_3_43 l_4_43 5.008854e-04
Rlv_3_43 l_3_43 l_3_44 5.008854e-04
Rlh_3_44 l_3_44 l_4_44 5.008854e-04
Rlv_3_44 l_3_44 l_3_45 5.008854e-04
Rlh_3_45 l_3_45 l_4_45 5.008854e-04
Rlv_3_45 l_3_45 l_3_46 5.008854e-04
Rlh_3_46 l_3_46 l_4_46 5.008854e-04
Rlv_3_46 l_3_46 l_3_47 5.008854e-04
Rlh_3_47 l_3_47 l_4_47 5.008854e-04
Rlv_3_47 l_3_47 l_3_48 5.008854e-04
Rlh_3_48 l_3_48 l_4_48 5.008854e-04
Rlv_3_48 l_3_48 l_3_49 5.008854e-04
Rlh_3_49 l_3_49 l_4_49 5.008854e-04
Rlv_3_49 l_3_49 l_3_50 5.008854e-04
Rlh_3_50 l_3_50 l_4_50 5.008854e-04
Rlv_3_50 l_3_50 l_3_51 5.008854e-04
Rlh_3_51 l_3_51 l_4_51 5.008854e-04
Rlv_3_51 l_3_51 l_3_52 5.008854e-04
Rlh_3_52 l_3_52 l_4_52 5.008854e-04
Rlv_3_52 l_3_52 l_3_53 5.008854e-04
Rlh_3_53 l_3_53 l_4_53 5.008854e-04
Rlv_3_53 l_3_53 l_3_54 5.008854e-04
Rlh_3_54 l_3_54 l_4_54 5.008854e-04
Rlv_3_54 l_3_54 l_3_55 5.008854e-04
Rlh_3_55 l_3_55 l_4_55 5.008854e-04
Rlv_3_55 l_3_55 l_3_56 5.008854e-04
Rlh_3_56 l_3_56 l_4_56 5.008854e-04
Rlv_3_56 l_3_56 l_3_57 5.008854e-04
Rlh_3_57 l_3_57 l_4_57 5.008854e-04
Rlv_3_57 l_3_57 l_3_58 5.008854e-04
Rlh_3_58 l_3_58 l_4_58 5.008854e-04
Rlv_3_58 l_3_58 l_3_59 5.008854e-04
Rlh_3_59 l_3_59 l_4_59 5.008854e-04
Rlv_3_59 l_3_59 l_3_60 5.008854e-04
Rlh_3_60 l_3_60 l_4_60 5.008854e-04
Rlv_3_60 l_3_60 l_3_61 5.008854e-04
Rlh_3_61 l_3_61 l_4_61 5.008854e-04
Rlv_3_61 l_3_61 l_3_62 5.008854e-04
Rlh_3_62 l_3_62 l_4_62 5.008854e-04
Rlv_3_62 l_3_62 l_3_63 5.008854e-04
Rlh_3_63 l_3_63 l_4_63 5.008854e-04
Rlv_3_63 l_3_63 l_3_64 5.008854e-04
Rlh_3_64 l_3_64 l_4_64 5.008854e-04
Rlv_3_64 l_3_64 l_3_65 5.008854e-04
Rlh_3_65 l_3_65 l_4_65 5.008854e-04
Rlv_3_65 l_3_65 l_3_66 5.008854e-04
Rlh_3_66 l_3_66 l_4_66 5.008854e-04
Rlv_3_66 l_3_66 l_3_67 5.008854e-04
Rlh_3_67 l_3_67 l_4_67 5.008854e-04
Rlv_3_67 l_3_67 l_3_68 5.008854e-04
Rlh_3_68 l_3_68 l_4_68 5.008854e-04
Rlv_3_68 l_3_68 l_3_69 5.008854e-04
Rlh_3_69 l_3_69 l_4_69 5.008854e-04
Rlv_3_69 l_3_69 l_3_70 5.008854e-04
Rlh_3_70 l_3_70 l_4_70 5.008854e-04
Rlv_3_70 l_3_70 l_3_71 5.008854e-04
Rlh_3_71 l_3_71 l_4_71 5.008854e-04
Rlh_4_0 l_4_0 l_5_0 5.008854e-04
Rlv_4_0 l_4_0 l_4_1 5.008854e-04
Rlh_4_1 l_4_1 l_5_1 5.008854e-04
Rlv_4_1 l_4_1 l_4_2 5.008854e-04
Rlh_4_2 l_4_2 l_5_2 5.008854e-04
Rlv_4_2 l_4_2 l_4_3 5.008854e-04
Rlh_4_3 l_4_3 l_5_3 5.008854e-04
Rlv_4_3 l_4_3 l_4_4 5.008854e-04
Rlh_4_4 l_4_4 l_5_4 5.008854e-04
Rlv_4_4 l_4_4 l_4_5 5.008854e-04
Rlh_4_5 l_4_5 l_5_5 5.008854e-04
Rlv_4_5 l_4_5 l_4_6 5.008854e-04
Rlh_4_6 l_4_6 l_5_6 5.008854e-04
Rlv_4_6 l_4_6 l_4_7 5.008854e-04
Rlh_4_7 l_4_7 l_5_7 5.008854e-04
Rlv_4_7 l_4_7 l_4_8 5.008854e-04
Rlh_4_8 l_4_8 l_5_8 5.008854e-04
Rlv_4_8 l_4_8 l_4_9 5.008854e-04
Rlh_4_9 l_4_9 l_5_9 5.008854e-04
Rlv_4_9 l_4_9 l_4_10 5.008854e-04
Rlh_4_10 l_4_10 l_5_10 5.008854e-04
Rlv_4_10 l_4_10 l_4_11 5.008854e-04
Rlh_4_11 l_4_11 l_5_11 5.008854e-04
Rlv_4_11 l_4_11 l_4_12 5.008854e-04
Rlh_4_12 l_4_12 l_5_12 5.008854e-04
Rlv_4_12 l_4_12 l_4_13 5.008854e-04
Rlh_4_13 l_4_13 l_5_13 5.008854e-04
Rlv_4_13 l_4_13 l_4_14 5.008854e-04
Rlh_4_14 l_4_14 l_5_14 5.008854e-04
Rlv_4_14 l_4_14 l_4_15 5.008854e-04
Rlh_4_15 l_4_15 l_5_15 5.008854e-04
Rlv_4_15 l_4_15 l_4_16 5.008854e-04
Rlh_4_16 l_4_16 l_5_16 5.008854e-04
Rlv_4_16 l_4_16 l_4_17 5.008854e-04
Rlh_4_17 l_4_17 l_5_17 5.008854e-04
Rlv_4_17 l_4_17 l_4_18 5.008854e-04
Rlh_4_18 l_4_18 l_5_18 5.008854e-04
Rlv_4_18 l_4_18 l_4_19 5.008854e-04
Rlh_4_19 l_4_19 l_5_19 5.008854e-04
Rlv_4_19 l_4_19 l_4_20 5.008854e-04
Rlh_4_20 l_4_20 l_5_20 5.008854e-04
Rlv_4_20 l_4_20 l_4_21 5.008854e-04
Rlh_4_21 l_4_21 l_5_21 5.008854e-04
Rlv_4_21 l_4_21 l_4_22 5.008854e-04
Rlh_4_22 l_4_22 l_5_22 5.008854e-04
Rlv_4_22 l_4_22 l_4_23 5.008854e-04
Rlh_4_23 l_4_23 l_5_23 5.008854e-04
Rlv_4_23 l_4_23 l_4_24 5.008854e-04
Rlh_4_24 l_4_24 l_5_24 5.008854e-04
Rlv_4_24 l_4_24 l_4_25 5.008854e-04
Rlh_4_25 l_4_25 l_5_25 5.008854e-04
Rlv_4_25 l_4_25 l_4_26 5.008854e-04
Rlh_4_26 l_4_26 l_5_26 5.008854e-04
Rlv_4_26 l_4_26 l_4_27 5.008854e-04
Rlh_4_27 l_4_27 l_5_27 5.008854e-04
Rlv_4_27 l_4_27 l_4_28 5.008854e-04
Rlh_4_28 l_4_28 l_5_28 5.008854e-04
Rlv_4_28 l_4_28 l_4_29 5.008854e-04
Rlh_4_29 l_4_29 l_5_29 5.008854e-04
Rlv_4_29 l_4_29 l_4_30 5.008854e-04
Rlh_4_30 l_4_30 l_5_30 5.008854e-04
Rlv_4_30 l_4_30 l_4_31 5.008854e-04
Rlh_4_31 l_4_31 l_5_31 5.008854e-04
Rlv_4_31 l_4_31 l_4_32 5.008854e-04
Rlh_4_32 l_4_32 l_5_32 5.008854e-04
Rlv_4_32 l_4_32 l_4_33 5.008854e-04
Rlh_4_33 l_4_33 l_5_33 5.008854e-04
Rlv_4_33 l_4_33 l_4_34 5.008854e-04
Rlh_4_34 l_4_34 l_5_34 5.008854e-04
Rlv_4_34 l_4_34 l_4_35 5.008854e-04
Rlh_4_35 l_4_35 l_5_35 5.008854e-04
Rlv_4_35 l_4_35 l_4_36 5.008854e-04
Rlh_4_36 l_4_36 l_5_36 5.008854e-04
Rlv_4_36 l_4_36 l_4_37 5.008854e-04
Rlh_4_37 l_4_37 l_5_37 5.008854e-04
Rlv_4_37 l_4_37 l_4_38 5.008854e-04
Rlh_4_38 l_4_38 l_5_38 5.008854e-04
Rlv_4_38 l_4_38 l_4_39 5.008854e-04
Rlh_4_39 l_4_39 l_5_39 5.008854e-04
Rlv_4_39 l_4_39 l_4_40 5.008854e-04
Rlh_4_40 l_4_40 l_5_40 5.008854e-04
Rlv_4_40 l_4_40 l_4_41 5.008854e-04
Rlh_4_41 l_4_41 l_5_41 5.008854e-04
Rlv_4_41 l_4_41 l_4_42 5.008854e-04
Rlh_4_42 l_4_42 l_5_42 5.008854e-04
Rlv_4_42 l_4_42 l_4_43 5.008854e-04
Rlh_4_43 l_4_43 l_5_43 5.008854e-04
Rlv_4_43 l_4_43 l_4_44 5.008854e-04
Rlh_4_44 l_4_44 l_5_44 5.008854e-04
Rlv_4_44 l_4_44 l_4_45 5.008854e-04
Rlh_4_45 l_4_45 l_5_45 5.008854e-04
Rlv_4_45 l_4_45 l_4_46 5.008854e-04
Rlh_4_46 l_4_46 l_5_46 5.008854e-04
Rlv_4_46 l_4_46 l_4_47 5.008854e-04
Rlh_4_47 l_4_47 l_5_47 5.008854e-04
Rlv_4_47 l_4_47 l_4_48 5.008854e-04
Rlh_4_48 l_4_48 l_5_48 5.008854e-04
Rlv_4_48 l_4_48 l_4_49 5.008854e-04
Rlh_4_49 l_4_49 l_5_49 5.008854e-04
Rlv_4_49 l_4_49 l_4_50 5.008854e-04
Rlh_4_50 l_4_50 l_5_50 5.008854e-04
Rlv_4_50 l_4_50 l_4_51 5.008854e-04
Rlh_4_51 l_4_51 l_5_51 5.008854e-04
Rlv_4_51 l_4_51 l_4_52 5.008854e-04
Rlh_4_52 l_4_52 l_5_52 5.008854e-04
Rlv_4_52 l_4_52 l_4_53 5.008854e-04
Rlh_4_53 l_4_53 l_5_53 5.008854e-04
Rlv_4_53 l_4_53 l_4_54 5.008854e-04
Rlh_4_54 l_4_54 l_5_54 5.008854e-04
Rlv_4_54 l_4_54 l_4_55 5.008854e-04
Rlh_4_55 l_4_55 l_5_55 5.008854e-04
Rlv_4_55 l_4_55 l_4_56 5.008854e-04
Rlh_4_56 l_4_56 l_5_56 5.008854e-04
Rlv_4_56 l_4_56 l_4_57 5.008854e-04
Rlh_4_57 l_4_57 l_5_57 5.008854e-04
Rlv_4_57 l_4_57 l_4_58 5.008854e-04
Rlh_4_58 l_4_58 l_5_58 5.008854e-04
Rlv_4_58 l_4_58 l_4_59 5.008854e-04
Rlh_4_59 l_4_59 l_5_59 5.008854e-04
Rlv_4_59 l_4_59 l_4_60 5.008854e-04
Rlh_4_60 l_4_60 l_5_60 5.008854e-04
Rlv_4_60 l_4_60 l_4_61 5.008854e-04
Rlh_4_61 l_4_61 l_5_61 5.008854e-04
Rlv_4_61 l_4_61 l_4_62 5.008854e-04
Rlh_4_62 l_4_62 l_5_62 5.008854e-04
Rlv_4_62 l_4_62 l_4_63 5.008854e-04
Rlh_4_63 l_4_63 l_5_63 5.008854e-04
Rlv_4_63 l_4_63 l_4_64 5.008854e-04
Rlh_4_64 l_4_64 l_5_64 5.008854e-04
Rlv_4_64 l_4_64 l_4_65 5.008854e-04
Rlh_4_65 l_4_65 l_5_65 5.008854e-04
Rlv_4_65 l_4_65 l_4_66 5.008854e-04
Rlh_4_66 l_4_66 l_5_66 5.008854e-04
Rlv_4_66 l_4_66 l_4_67 5.008854e-04
Rlh_4_67 l_4_67 l_5_67 5.008854e-04
Rlv_4_67 l_4_67 l_4_68 5.008854e-04
Rlh_4_68 l_4_68 l_5_68 5.008854e-04
Rlv_4_68 l_4_68 l_4_69 5.008854e-04
Rlh_4_69 l_4_69 l_5_69 5.008854e-04
Rlv_4_69 l_4_69 l_4_70 5.008854e-04
Rlh_4_70 l_4_70 l_5_70 5.008854e-04
Rlv_4_70 l_4_70 l_4_71 5.008854e-04
Rlh_4_71 l_4_71 l_5_71 5.008854e-04
Rlh_5_0 l_5_0 l_6_0 5.008854e-04
Rlv_5_0 l_5_0 l_5_1 5.008854e-04
Rlh_5_1 l_5_1 l_6_1 5.008854e-04
Rlv_5_1 l_5_1 l_5_2 5.008854e-04
Rlh_5_2 l_5_2 l_6_2 5.008854e-04
Rlv_5_2 l_5_2 l_5_3 5.008854e-04
Rlh_5_3 l_5_3 l_6_3 5.008854e-04
Rlv_5_3 l_5_3 l_5_4 5.008854e-04
Rlh_5_4 l_5_4 l_6_4 5.008854e-04
Rlv_5_4 l_5_4 l_5_5 5.008854e-04
Rlh_5_5 l_5_5 l_6_5 5.008854e-04
Rlv_5_5 l_5_5 l_5_6 5.008854e-04
Rlh_5_6 l_5_6 l_6_6 5.008854e-04
Rlv_5_6 l_5_6 l_5_7 5.008854e-04
Rlh_5_7 l_5_7 l_6_7 5.008854e-04
Rlv_5_7 l_5_7 l_5_8 5.008854e-04
Rlh_5_8 l_5_8 l_6_8 5.008854e-04
Rlv_5_8 l_5_8 l_5_9 5.008854e-04
Rlh_5_9 l_5_9 l_6_9 5.008854e-04
Rlv_5_9 l_5_9 l_5_10 5.008854e-04
Rlh_5_10 l_5_10 l_6_10 5.008854e-04
Rlv_5_10 l_5_10 l_5_11 5.008854e-04
Rlh_5_11 l_5_11 l_6_11 5.008854e-04
Rlv_5_11 l_5_11 l_5_12 5.008854e-04
Rlh_5_12 l_5_12 l_6_12 5.008854e-04
Rlv_5_12 l_5_12 l_5_13 5.008854e-04
Rlh_5_13 l_5_13 l_6_13 5.008854e-04
Rlv_5_13 l_5_13 l_5_14 5.008854e-04
Rlh_5_14 l_5_14 l_6_14 5.008854e-04
Rlv_5_14 l_5_14 l_5_15 5.008854e-04
Rlh_5_15 l_5_15 l_6_15 5.008854e-04
Rlv_5_15 l_5_15 l_5_16 5.008854e-04
Rlh_5_16 l_5_16 l_6_16 5.008854e-04
Rlv_5_16 l_5_16 l_5_17 5.008854e-04
Rlh_5_17 l_5_17 l_6_17 5.008854e-04
Rlv_5_17 l_5_17 l_5_18 5.008854e-04
Rlh_5_18 l_5_18 l_6_18 5.008854e-04
Rlv_5_18 l_5_18 l_5_19 5.008854e-04
Rlh_5_19 l_5_19 l_6_19 5.008854e-04
Rlv_5_19 l_5_19 l_5_20 5.008854e-04
Rlh_5_20 l_5_20 l_6_20 5.008854e-04
Rlv_5_20 l_5_20 l_5_21 5.008854e-04
Rlh_5_21 l_5_21 l_6_21 5.008854e-04
Rlv_5_21 l_5_21 l_5_22 5.008854e-04
Rlh_5_22 l_5_22 l_6_22 5.008854e-04
Rlv_5_22 l_5_22 l_5_23 5.008854e-04
Rlh_5_23 l_5_23 l_6_23 5.008854e-04
Rlv_5_23 l_5_23 l_5_24 5.008854e-04
Rlh_5_24 l_5_24 l_6_24 5.008854e-04
Rlv_5_24 l_5_24 l_5_25 5.008854e-04
Rlh_5_25 l_5_25 l_6_25 5.008854e-04
Rlv_5_25 l_5_25 l_5_26 5.008854e-04
Rlh_5_26 l_5_26 l_6_26 5.008854e-04
Rlv_5_26 l_5_26 l_5_27 5.008854e-04
Rlh_5_27 l_5_27 l_6_27 5.008854e-04
Rlv_5_27 l_5_27 l_5_28 5.008854e-04
Rlh_5_28 l_5_28 l_6_28 5.008854e-04
Rlv_5_28 l_5_28 l_5_29 5.008854e-04
Rlh_5_29 l_5_29 l_6_29 5.008854e-04
Rlv_5_29 l_5_29 l_5_30 5.008854e-04
Rlh_5_30 l_5_30 l_6_30 5.008854e-04
Rlv_5_30 l_5_30 l_5_31 5.008854e-04
Rlh_5_31 l_5_31 l_6_31 5.008854e-04
Rlv_5_31 l_5_31 l_5_32 5.008854e-04
Rlh_5_32 l_5_32 l_6_32 5.008854e-04
Rlv_5_32 l_5_32 l_5_33 5.008854e-04
Rlh_5_33 l_5_33 l_6_33 5.008854e-04
Rlv_5_33 l_5_33 l_5_34 5.008854e-04
Rlh_5_34 l_5_34 l_6_34 5.008854e-04
Rlv_5_34 l_5_34 l_5_35 5.008854e-04
Rlh_5_35 l_5_35 l_6_35 5.008854e-04
Rlv_5_35 l_5_35 l_5_36 5.008854e-04
Rlh_5_36 l_5_36 l_6_36 5.008854e-04
Rlv_5_36 l_5_36 l_5_37 5.008854e-04
Rlh_5_37 l_5_37 l_6_37 5.008854e-04
Rlv_5_37 l_5_37 l_5_38 5.008854e-04
Rlh_5_38 l_5_38 l_6_38 5.008854e-04
Rlv_5_38 l_5_38 l_5_39 5.008854e-04
Rlh_5_39 l_5_39 l_6_39 5.008854e-04
Rlv_5_39 l_5_39 l_5_40 5.008854e-04
Rlh_5_40 l_5_40 l_6_40 5.008854e-04
Rlv_5_40 l_5_40 l_5_41 5.008854e-04
Rlh_5_41 l_5_41 l_6_41 5.008854e-04
Rlv_5_41 l_5_41 l_5_42 5.008854e-04
Rlh_5_42 l_5_42 l_6_42 5.008854e-04
Rlv_5_42 l_5_42 l_5_43 5.008854e-04
Rlh_5_43 l_5_43 l_6_43 5.008854e-04
Rlv_5_43 l_5_43 l_5_44 5.008854e-04
Rlh_5_44 l_5_44 l_6_44 5.008854e-04
Rlv_5_44 l_5_44 l_5_45 5.008854e-04
Rlh_5_45 l_5_45 l_6_45 5.008854e-04
Rlv_5_45 l_5_45 l_5_46 5.008854e-04
Rlh_5_46 l_5_46 l_6_46 5.008854e-04
Rlv_5_46 l_5_46 l_5_47 5.008854e-04
Rlh_5_47 l_5_47 l_6_47 5.008854e-04
Rlv_5_47 l_5_47 l_5_48 5.008854e-04
Rlh_5_48 l_5_48 l_6_48 5.008854e-04
Rlv_5_48 l_5_48 l_5_49 5.008854e-04
Rlh_5_49 l_5_49 l_6_49 5.008854e-04
Rlv_5_49 l_5_49 l_5_50 5.008854e-04
Rlh_5_50 l_5_50 l_6_50 5.008854e-04
Rlv_5_50 l_5_50 l_5_51 5.008854e-04
Rlh_5_51 l_5_51 l_6_51 5.008854e-04
Rlv_5_51 l_5_51 l_5_52 5.008854e-04
Rlh_5_52 l_5_52 l_6_52 5.008854e-04
Rlv_5_52 l_5_52 l_5_53 5.008854e-04
Rlh_5_53 l_5_53 l_6_53 5.008854e-04
Rlv_5_53 l_5_53 l_5_54 5.008854e-04
Rlh_5_54 l_5_54 l_6_54 5.008854e-04
Rlv_5_54 l_5_54 l_5_55 5.008854e-04
Rlh_5_55 l_5_55 l_6_55 5.008854e-04
Rlv_5_55 l_5_55 l_5_56 5.008854e-04
Rlh_5_56 l_5_56 l_6_56 5.008854e-04
Rlv_5_56 l_5_56 l_5_57 5.008854e-04
Rlh_5_57 l_5_57 l_6_57 5.008854e-04
Rlv_5_57 l_5_57 l_5_58 5.008854e-04
Rlh_5_58 l_5_58 l_6_58 5.008854e-04
Rlv_5_58 l_5_58 l_5_59 5.008854e-04
Rlh_5_59 l_5_59 l_6_59 5.008854e-04
Rlv_5_59 l_5_59 l_5_60 5.008854e-04
Rlh_5_60 l_5_60 l_6_60 5.008854e-04
Rlv_5_60 l_5_60 l_5_61 5.008854e-04
Rlh_5_61 l_5_61 l_6_61 5.008854e-04
Rlv_5_61 l_5_61 l_5_62 5.008854e-04
Rlh_5_62 l_5_62 l_6_62 5.008854e-04
Rlv_5_62 l_5_62 l_5_63 5.008854e-04
Rlh_5_63 l_5_63 l_6_63 5.008854e-04
Rlv_5_63 l_5_63 l_5_64 5.008854e-04
Rlh_5_64 l_5_64 l_6_64 5.008854e-04
Rlv_5_64 l_5_64 l_5_65 5.008854e-04
Rlh_5_65 l_5_65 l_6_65 5.008854e-04
Rlv_5_65 l_5_65 l_5_66 5.008854e-04
Rlh_5_66 l_5_66 l_6_66 5.008854e-04
Rlv_5_66 l_5_66 l_5_67 5.008854e-04
Rlh_5_67 l_5_67 l_6_67 5.008854e-04
Rlv_5_67 l_5_67 l_5_68 5.008854e-04
Rlh_5_68 l_5_68 l_6_68 5.008854e-04
Rlv_5_68 l_5_68 l_5_69 5.008854e-04
Rlh_5_69 l_5_69 l_6_69 5.008854e-04
Rlv_5_69 l_5_69 l_5_70 5.008854e-04
Rlh_5_70 l_5_70 l_6_70 5.008854e-04
Rlv_5_70 l_5_70 l_5_71 5.008854e-04
Rlh_5_71 l_5_71 l_6_71 5.008854e-04
Rlh_6_0 l_6_0 l_7_0 5.008854e-04
Rlv_6_0 l_6_0 l_6_1 5.008854e-04
Rlh_6_1 l_6_1 l_7_1 5.008854e-04
Rlv_6_1 l_6_1 l_6_2 5.008854e-04
Rlh_6_2 l_6_2 l_7_2 5.008854e-04
Rlv_6_2 l_6_2 l_6_3 5.008854e-04
Rlh_6_3 l_6_3 l_7_3 5.008854e-04
Rlv_6_3 l_6_3 l_6_4 5.008854e-04
Rlh_6_4 l_6_4 l_7_4 5.008854e-04
Rlv_6_4 l_6_4 l_6_5 5.008854e-04
Rlh_6_5 l_6_5 l_7_5 5.008854e-04
Rlv_6_5 l_6_5 l_6_6 5.008854e-04
Rlh_6_6 l_6_6 l_7_6 5.008854e-04
Rlv_6_6 l_6_6 l_6_7 5.008854e-04
Rlh_6_7 l_6_7 l_7_7 5.008854e-04
Rlv_6_7 l_6_7 l_6_8 5.008854e-04
Rlh_6_8 l_6_8 l_7_8 5.008854e-04
Rlv_6_8 l_6_8 l_6_9 5.008854e-04
Rlh_6_9 l_6_9 l_7_9 5.008854e-04
Rlv_6_9 l_6_9 l_6_10 5.008854e-04
Rlh_6_10 l_6_10 l_7_10 5.008854e-04
Rlv_6_10 l_6_10 l_6_11 5.008854e-04
Rlh_6_11 l_6_11 l_7_11 5.008854e-04
Rlv_6_11 l_6_11 l_6_12 5.008854e-04
Rlh_6_12 l_6_12 l_7_12 5.008854e-04
Rlv_6_12 l_6_12 l_6_13 5.008854e-04
Rlh_6_13 l_6_13 l_7_13 5.008854e-04
Rlv_6_13 l_6_13 l_6_14 5.008854e-04
Rlh_6_14 l_6_14 l_7_14 5.008854e-04
Rlv_6_14 l_6_14 l_6_15 5.008854e-04
Rlh_6_15 l_6_15 l_7_15 5.008854e-04
Rlv_6_15 l_6_15 l_6_16 5.008854e-04
Rlh_6_16 l_6_16 l_7_16 5.008854e-04
Rlv_6_16 l_6_16 l_6_17 5.008854e-04
Rlh_6_17 l_6_17 l_7_17 5.008854e-04
Rlv_6_17 l_6_17 l_6_18 5.008854e-04
Rlh_6_18 l_6_18 l_7_18 5.008854e-04
Rlv_6_18 l_6_18 l_6_19 5.008854e-04
Rlh_6_19 l_6_19 l_7_19 5.008854e-04
Rlv_6_19 l_6_19 l_6_20 5.008854e-04
Rlh_6_20 l_6_20 l_7_20 5.008854e-04
Rlv_6_20 l_6_20 l_6_21 5.008854e-04
Rlh_6_21 l_6_21 l_7_21 5.008854e-04
Rlv_6_21 l_6_21 l_6_22 5.008854e-04
Rlh_6_22 l_6_22 l_7_22 5.008854e-04
Rlv_6_22 l_6_22 l_6_23 5.008854e-04
Rlh_6_23 l_6_23 l_7_23 5.008854e-04
Rlv_6_23 l_6_23 l_6_24 5.008854e-04
Rlh_6_24 l_6_24 l_7_24 5.008854e-04
Rlv_6_24 l_6_24 l_6_25 5.008854e-04
Rlh_6_25 l_6_25 l_7_25 5.008854e-04
Rlv_6_25 l_6_25 l_6_26 5.008854e-04
Rlh_6_26 l_6_26 l_7_26 5.008854e-04
Rlv_6_26 l_6_26 l_6_27 5.008854e-04
Rlh_6_27 l_6_27 l_7_27 5.008854e-04
Rlv_6_27 l_6_27 l_6_28 5.008854e-04
Rlh_6_28 l_6_28 l_7_28 5.008854e-04
Rlv_6_28 l_6_28 l_6_29 5.008854e-04
Rlh_6_29 l_6_29 l_7_29 5.008854e-04
Rlv_6_29 l_6_29 l_6_30 5.008854e-04
Rlh_6_30 l_6_30 l_7_30 5.008854e-04
Rlv_6_30 l_6_30 l_6_31 5.008854e-04
Rlh_6_31 l_6_31 l_7_31 5.008854e-04
Rlv_6_31 l_6_31 l_6_32 5.008854e-04
Rlh_6_32 l_6_32 l_7_32 5.008854e-04
Rlv_6_32 l_6_32 l_6_33 5.008854e-04
Rlh_6_33 l_6_33 l_7_33 5.008854e-04
Rlv_6_33 l_6_33 l_6_34 5.008854e-04
Rlh_6_34 l_6_34 l_7_34 5.008854e-04
Rlv_6_34 l_6_34 l_6_35 5.008854e-04
Rlh_6_35 l_6_35 l_7_35 5.008854e-04
Rlv_6_35 l_6_35 l_6_36 5.008854e-04
Rlh_6_36 l_6_36 l_7_36 5.008854e-04
Rlv_6_36 l_6_36 l_6_37 5.008854e-04
Rlh_6_37 l_6_37 l_7_37 5.008854e-04
Rlv_6_37 l_6_37 l_6_38 5.008854e-04
Rlh_6_38 l_6_38 l_7_38 5.008854e-04
Rlv_6_38 l_6_38 l_6_39 5.008854e-04
Rlh_6_39 l_6_39 l_7_39 5.008854e-04
Rlv_6_39 l_6_39 l_6_40 5.008854e-04
Rlh_6_40 l_6_40 l_7_40 5.008854e-04
Rlv_6_40 l_6_40 l_6_41 5.008854e-04
Rlh_6_41 l_6_41 l_7_41 5.008854e-04
Rlv_6_41 l_6_41 l_6_42 5.008854e-04
Rlh_6_42 l_6_42 l_7_42 5.008854e-04
Rlv_6_42 l_6_42 l_6_43 5.008854e-04
Rlh_6_43 l_6_43 l_7_43 5.008854e-04
Rlv_6_43 l_6_43 l_6_44 5.008854e-04
Rlh_6_44 l_6_44 l_7_44 5.008854e-04
Rlv_6_44 l_6_44 l_6_45 5.008854e-04
Rlh_6_45 l_6_45 l_7_45 5.008854e-04
Rlv_6_45 l_6_45 l_6_46 5.008854e-04
Rlh_6_46 l_6_46 l_7_46 5.008854e-04
Rlv_6_46 l_6_46 l_6_47 5.008854e-04
Rlh_6_47 l_6_47 l_7_47 5.008854e-04
Rlv_6_47 l_6_47 l_6_48 5.008854e-04
Rlh_6_48 l_6_48 l_7_48 5.008854e-04
Rlv_6_48 l_6_48 l_6_49 5.008854e-04
Rlh_6_49 l_6_49 l_7_49 5.008854e-04
Rlv_6_49 l_6_49 l_6_50 5.008854e-04
Rlh_6_50 l_6_50 l_7_50 5.008854e-04
Rlv_6_50 l_6_50 l_6_51 5.008854e-04
Rlh_6_51 l_6_51 l_7_51 5.008854e-04
Rlv_6_51 l_6_51 l_6_52 5.008854e-04
Rlh_6_52 l_6_52 l_7_52 5.008854e-04
Rlv_6_52 l_6_52 l_6_53 5.008854e-04
Rlh_6_53 l_6_53 l_7_53 5.008854e-04
Rlv_6_53 l_6_53 l_6_54 5.008854e-04
Rlh_6_54 l_6_54 l_7_54 5.008854e-04
Rlv_6_54 l_6_54 l_6_55 5.008854e-04
Rlh_6_55 l_6_55 l_7_55 5.008854e-04
Rlv_6_55 l_6_55 l_6_56 5.008854e-04
Rlh_6_56 l_6_56 l_7_56 5.008854e-04
Rlv_6_56 l_6_56 l_6_57 5.008854e-04
Rlh_6_57 l_6_57 l_7_57 5.008854e-04
Rlv_6_57 l_6_57 l_6_58 5.008854e-04
Rlh_6_58 l_6_58 l_7_58 5.008854e-04
Rlv_6_58 l_6_58 l_6_59 5.008854e-04
Rlh_6_59 l_6_59 l_7_59 5.008854e-04
Rlv_6_59 l_6_59 l_6_60 5.008854e-04
Rlh_6_60 l_6_60 l_7_60 5.008854e-04
Rlv_6_60 l_6_60 l_6_61 5.008854e-04
Rlh_6_61 l_6_61 l_7_61 5.008854e-04
Rlv_6_61 l_6_61 l_6_62 5.008854e-04
Rlh_6_62 l_6_62 l_7_62 5.008854e-04
Rlv_6_62 l_6_62 l_6_63 5.008854e-04
Rlh_6_63 l_6_63 l_7_63 5.008854e-04
Rlv_6_63 l_6_63 l_6_64 5.008854e-04
Rlh_6_64 l_6_64 l_7_64 5.008854e-04
Rlv_6_64 l_6_64 l_6_65 5.008854e-04
Rlh_6_65 l_6_65 l_7_65 5.008854e-04
Rlv_6_65 l_6_65 l_6_66 5.008854e-04
Rlh_6_66 l_6_66 l_7_66 5.008854e-04
Rlv_6_66 l_6_66 l_6_67 5.008854e-04
Rlh_6_67 l_6_67 l_7_67 5.008854e-04
Rlv_6_67 l_6_67 l_6_68 5.008854e-04
Rlh_6_68 l_6_68 l_7_68 5.008854e-04
Rlv_6_68 l_6_68 l_6_69 5.008854e-04
Rlh_6_69 l_6_69 l_7_69 5.008854e-04
Rlv_6_69 l_6_69 l_6_70 5.008854e-04
Rlh_6_70 l_6_70 l_7_70 5.008854e-04
Rlv_6_70 l_6_70 l_6_71 5.008854e-04
Rlh_6_71 l_6_71 l_7_71 5.008854e-04
Rlh_7_0 l_7_0 l_8_0 5.008854e-04
Rlv_7_0 l_7_0 l_7_1 5.008854e-04
Rlh_7_1 l_7_1 l_8_1 5.008854e-04
Rlv_7_1 l_7_1 l_7_2 5.008854e-04
Rlh_7_2 l_7_2 l_8_2 5.008854e-04
Rlv_7_2 l_7_2 l_7_3 5.008854e-04
Rlh_7_3 l_7_3 l_8_3 5.008854e-04
Rlv_7_3 l_7_3 l_7_4 5.008854e-04
Rlh_7_4 l_7_4 l_8_4 5.008854e-04
Rlv_7_4 l_7_4 l_7_5 5.008854e-04
Rlh_7_5 l_7_5 l_8_5 5.008854e-04
Rlv_7_5 l_7_5 l_7_6 5.008854e-04
Rlh_7_6 l_7_6 l_8_6 5.008854e-04
Rlv_7_6 l_7_6 l_7_7 5.008854e-04
Rlh_7_7 l_7_7 l_8_7 5.008854e-04
Rlv_7_7 l_7_7 l_7_8 5.008854e-04
Rlh_7_8 l_7_8 l_8_8 5.008854e-04
Rlv_7_8 l_7_8 l_7_9 5.008854e-04
Rlh_7_9 l_7_9 l_8_9 5.008854e-04
Rlv_7_9 l_7_9 l_7_10 5.008854e-04
Rlh_7_10 l_7_10 l_8_10 5.008854e-04
Rlv_7_10 l_7_10 l_7_11 5.008854e-04
Rlh_7_11 l_7_11 l_8_11 5.008854e-04
Rlv_7_11 l_7_11 l_7_12 5.008854e-04
Rlh_7_12 l_7_12 l_8_12 5.008854e-04
Rlv_7_12 l_7_12 l_7_13 5.008854e-04
Rlh_7_13 l_7_13 l_8_13 5.008854e-04
Rlv_7_13 l_7_13 l_7_14 5.008854e-04
Rlh_7_14 l_7_14 l_8_14 5.008854e-04
Rlv_7_14 l_7_14 l_7_15 5.008854e-04
Rlh_7_15 l_7_15 l_8_15 5.008854e-04
Rlv_7_15 l_7_15 l_7_16 5.008854e-04
Rlh_7_16 l_7_16 l_8_16 5.008854e-04
Rlv_7_16 l_7_16 l_7_17 5.008854e-04
Rlh_7_17 l_7_17 l_8_17 5.008854e-04
Rlv_7_17 l_7_17 l_7_18 5.008854e-04
Rlh_7_18 l_7_18 l_8_18 5.008854e-04
Rlv_7_18 l_7_18 l_7_19 5.008854e-04
Rlh_7_19 l_7_19 l_8_19 5.008854e-04
Rlv_7_19 l_7_19 l_7_20 5.008854e-04
Rlh_7_20 l_7_20 l_8_20 5.008854e-04
Rlv_7_20 l_7_20 l_7_21 5.008854e-04
Rlh_7_21 l_7_21 l_8_21 5.008854e-04
Rlv_7_21 l_7_21 l_7_22 5.008854e-04
Rlh_7_22 l_7_22 l_8_22 5.008854e-04
Rlv_7_22 l_7_22 l_7_23 5.008854e-04
Rlh_7_23 l_7_23 l_8_23 5.008854e-04
Rlv_7_23 l_7_23 l_7_24 5.008854e-04
Rlh_7_24 l_7_24 l_8_24 5.008854e-04
Rlv_7_24 l_7_24 l_7_25 5.008854e-04
Rlh_7_25 l_7_25 l_8_25 5.008854e-04
Rlv_7_25 l_7_25 l_7_26 5.008854e-04
Rlh_7_26 l_7_26 l_8_26 5.008854e-04
Rlv_7_26 l_7_26 l_7_27 5.008854e-04
Rlh_7_27 l_7_27 l_8_27 5.008854e-04
Rlv_7_27 l_7_27 l_7_28 5.008854e-04
Rlh_7_28 l_7_28 l_8_28 5.008854e-04
Rlv_7_28 l_7_28 l_7_29 5.008854e-04
Rlh_7_29 l_7_29 l_8_29 5.008854e-04
Rlv_7_29 l_7_29 l_7_30 5.008854e-04
Rlh_7_30 l_7_30 l_8_30 5.008854e-04
Rlv_7_30 l_7_30 l_7_31 5.008854e-04
Rlh_7_31 l_7_31 l_8_31 5.008854e-04
Rlv_7_31 l_7_31 l_7_32 5.008854e-04
Rlh_7_32 l_7_32 l_8_32 5.008854e-04
Rlv_7_32 l_7_32 l_7_33 5.008854e-04
Rlh_7_33 l_7_33 l_8_33 5.008854e-04
Rlv_7_33 l_7_33 l_7_34 5.008854e-04
Rlh_7_34 l_7_34 l_8_34 5.008854e-04
Rlv_7_34 l_7_34 l_7_35 5.008854e-04
Rlh_7_35 l_7_35 l_8_35 5.008854e-04
Rlv_7_35 l_7_35 l_7_36 5.008854e-04
Rlh_7_36 l_7_36 l_8_36 5.008854e-04
Rlv_7_36 l_7_36 l_7_37 5.008854e-04
Rlh_7_37 l_7_37 l_8_37 5.008854e-04
Rlv_7_37 l_7_37 l_7_38 5.008854e-04
Rlh_7_38 l_7_38 l_8_38 5.008854e-04
Rlv_7_38 l_7_38 l_7_39 5.008854e-04
Rlh_7_39 l_7_39 l_8_39 5.008854e-04
Rlv_7_39 l_7_39 l_7_40 5.008854e-04
Rlh_7_40 l_7_40 l_8_40 5.008854e-04
Rlv_7_40 l_7_40 l_7_41 5.008854e-04
Rlh_7_41 l_7_41 l_8_41 5.008854e-04
Rlv_7_41 l_7_41 l_7_42 5.008854e-04
Rlh_7_42 l_7_42 l_8_42 5.008854e-04
Rlv_7_42 l_7_42 l_7_43 5.008854e-04
Rlh_7_43 l_7_43 l_8_43 5.008854e-04
Rlv_7_43 l_7_43 l_7_44 5.008854e-04
Rlh_7_44 l_7_44 l_8_44 5.008854e-04
Rlv_7_44 l_7_44 l_7_45 5.008854e-04
Rlh_7_45 l_7_45 l_8_45 5.008854e-04
Rlv_7_45 l_7_45 l_7_46 5.008854e-04
Rlh_7_46 l_7_46 l_8_46 5.008854e-04
Rlv_7_46 l_7_46 l_7_47 5.008854e-04
Rlh_7_47 l_7_47 l_8_47 5.008854e-04
Rlv_7_47 l_7_47 l_7_48 5.008854e-04
Rlh_7_48 l_7_48 l_8_48 5.008854e-04
Rlv_7_48 l_7_48 l_7_49 5.008854e-04
Rlh_7_49 l_7_49 l_8_49 5.008854e-04
Rlv_7_49 l_7_49 l_7_50 5.008854e-04
Rlh_7_50 l_7_50 l_8_50 5.008854e-04
Rlv_7_50 l_7_50 l_7_51 5.008854e-04
Rlh_7_51 l_7_51 l_8_51 5.008854e-04
Rlv_7_51 l_7_51 l_7_52 5.008854e-04
Rlh_7_52 l_7_52 l_8_52 5.008854e-04
Rlv_7_52 l_7_52 l_7_53 5.008854e-04
Rlh_7_53 l_7_53 l_8_53 5.008854e-04
Rlv_7_53 l_7_53 l_7_54 5.008854e-04
Rlh_7_54 l_7_54 l_8_54 5.008854e-04
Rlv_7_54 l_7_54 l_7_55 5.008854e-04
Rlh_7_55 l_7_55 l_8_55 5.008854e-04
Rlv_7_55 l_7_55 l_7_56 5.008854e-04
Rlh_7_56 l_7_56 l_8_56 5.008854e-04
Rlv_7_56 l_7_56 l_7_57 5.008854e-04
Rlh_7_57 l_7_57 l_8_57 5.008854e-04
Rlv_7_57 l_7_57 l_7_58 5.008854e-04
Rlh_7_58 l_7_58 l_8_58 5.008854e-04
Rlv_7_58 l_7_58 l_7_59 5.008854e-04
Rlh_7_59 l_7_59 l_8_59 5.008854e-04
Rlv_7_59 l_7_59 l_7_60 5.008854e-04
Rlh_7_60 l_7_60 l_8_60 5.008854e-04
Rlv_7_60 l_7_60 l_7_61 5.008854e-04
Rlh_7_61 l_7_61 l_8_61 5.008854e-04
Rlv_7_61 l_7_61 l_7_62 5.008854e-04
Rlh_7_62 l_7_62 l_8_62 5.008854e-04
Rlv_7_62 l_7_62 l_7_63 5.008854e-04
Rlh_7_63 l_7_63 l_8_63 5.008854e-04
Rlv_7_63 l_7_63 l_7_64 5.008854e-04
Rlh_7_64 l_7_64 l_8_64 5.008854e-04
Rlv_7_64 l_7_64 l_7_65 5.008854e-04
Rlh_7_65 l_7_65 l_8_65 5.008854e-04
Rlv_7_65 l_7_65 l_7_66 5.008854e-04
Rlh_7_66 l_7_66 l_8_66 5.008854e-04
Rlv_7_66 l_7_66 l_7_67 5.008854e-04
Rlh_7_67 l_7_67 l_8_67 5.008854e-04
Rlv_7_67 l_7_67 l_7_68 5.008854e-04
Rlh_7_68 l_7_68 l_8_68 5.008854e-04
Rlv_7_68 l_7_68 l_7_69 5.008854e-04
Rlh_7_69 l_7_69 l_8_69 5.008854e-04
Rlv_7_69 l_7_69 l_7_70 5.008854e-04
Rlh_7_70 l_7_70 l_8_70 5.008854e-04
Rlv_7_70 l_7_70 l_7_71 5.008854e-04
Rlh_7_71 l_7_71 l_8_71 5.008854e-04
Rlh_8_0 l_8_0 l_9_0 5.008854e-04
Rlv_8_0 l_8_0 l_8_1 5.008854e-04
Rlh_8_1 l_8_1 l_9_1 5.008854e-04
Rlv_8_1 l_8_1 l_8_2 5.008854e-04
Rlh_8_2 l_8_2 l_9_2 5.008854e-04
Rlv_8_2 l_8_2 l_8_3 5.008854e-04
Rlh_8_3 l_8_3 l_9_3 5.008854e-04
Rlv_8_3 l_8_3 l_8_4 5.008854e-04
Rlh_8_4 l_8_4 l_9_4 5.008854e-04
Rlv_8_4 l_8_4 l_8_5 5.008854e-04
Rlh_8_5 l_8_5 l_9_5 5.008854e-04
Rlv_8_5 l_8_5 l_8_6 5.008854e-04
Rlh_8_6 l_8_6 l_9_6 5.008854e-04
Rlv_8_6 l_8_6 l_8_7 5.008854e-04
Rlh_8_7 l_8_7 l_9_7 5.008854e-04
Rlv_8_7 l_8_7 l_8_8 5.008854e-04
Rlh_8_8 l_8_8 l_9_8 5.008854e-04
Rlv_8_8 l_8_8 l_8_9 5.008854e-04
Rlh_8_9 l_8_9 l_9_9 5.008854e-04
Rlv_8_9 l_8_9 l_8_10 5.008854e-04
Rlh_8_10 l_8_10 l_9_10 5.008854e-04
Rlv_8_10 l_8_10 l_8_11 5.008854e-04
Rlh_8_11 l_8_11 l_9_11 5.008854e-04
Rlv_8_11 l_8_11 l_8_12 5.008854e-04
Rlh_8_12 l_8_12 l_9_12 5.008854e-04
Rlv_8_12 l_8_12 l_8_13 5.008854e-04
Rlh_8_13 l_8_13 l_9_13 5.008854e-04
Rlv_8_13 l_8_13 l_8_14 5.008854e-04
Rlh_8_14 l_8_14 l_9_14 5.008854e-04
Rlv_8_14 l_8_14 l_8_15 5.008854e-04
Rlh_8_15 l_8_15 l_9_15 5.008854e-04
Rlv_8_15 l_8_15 l_8_16 5.008854e-04
Rlh_8_16 l_8_16 l_9_16 5.008854e-04
Rlv_8_16 l_8_16 l_8_17 5.008854e-04
Rlh_8_17 l_8_17 l_9_17 5.008854e-04
Rlv_8_17 l_8_17 l_8_18 5.008854e-04
Rlh_8_18 l_8_18 l_9_18 5.008854e-04
Rlv_8_18 l_8_18 l_8_19 5.008854e-04
Rlh_8_19 l_8_19 l_9_19 5.008854e-04
Rlv_8_19 l_8_19 l_8_20 5.008854e-04
Rlh_8_20 l_8_20 l_9_20 5.008854e-04
Rlv_8_20 l_8_20 l_8_21 5.008854e-04
Rlh_8_21 l_8_21 l_9_21 5.008854e-04
Rlv_8_21 l_8_21 l_8_22 5.008854e-04
Rlh_8_22 l_8_22 l_9_22 5.008854e-04
Rlv_8_22 l_8_22 l_8_23 5.008854e-04
Rlh_8_23 l_8_23 l_9_23 5.008854e-04
Rlv_8_23 l_8_23 l_8_24 5.008854e-04
Rlh_8_24 l_8_24 l_9_24 5.008854e-04
Rlv_8_24 l_8_24 l_8_25 5.008854e-04
Rlh_8_25 l_8_25 l_9_25 5.008854e-04
Rlv_8_25 l_8_25 l_8_26 5.008854e-04
Rlh_8_26 l_8_26 l_9_26 5.008854e-04
Rlv_8_26 l_8_26 l_8_27 5.008854e-04
Rlh_8_27 l_8_27 l_9_27 5.008854e-04
Rlv_8_27 l_8_27 l_8_28 5.008854e-04
Rlh_8_28 l_8_28 l_9_28 5.008854e-04
Rlv_8_28 l_8_28 l_8_29 5.008854e-04
Rlh_8_29 l_8_29 l_9_29 5.008854e-04
Rlv_8_29 l_8_29 l_8_30 5.008854e-04
Rlh_8_30 l_8_30 l_9_30 5.008854e-04
Rlv_8_30 l_8_30 l_8_31 5.008854e-04
Rlh_8_31 l_8_31 l_9_31 5.008854e-04
Rlv_8_31 l_8_31 l_8_32 5.008854e-04
Rlh_8_32 l_8_32 l_9_32 5.008854e-04
Rlv_8_32 l_8_32 l_8_33 5.008854e-04
Rlh_8_33 l_8_33 l_9_33 5.008854e-04
Rlv_8_33 l_8_33 l_8_34 5.008854e-04
Rlh_8_34 l_8_34 l_9_34 5.008854e-04
Rlv_8_34 l_8_34 l_8_35 5.008854e-04
Rlh_8_35 l_8_35 l_9_35 5.008854e-04
Rlv_8_35 l_8_35 l_8_36 5.008854e-04
Rlh_8_36 l_8_36 l_9_36 5.008854e-04
Rlv_8_36 l_8_36 l_8_37 5.008854e-04
Rlh_8_37 l_8_37 l_9_37 5.008854e-04
Rlv_8_37 l_8_37 l_8_38 5.008854e-04
Rlh_8_38 l_8_38 l_9_38 5.008854e-04
Rlv_8_38 l_8_38 l_8_39 5.008854e-04
Rlh_8_39 l_8_39 l_9_39 5.008854e-04
Rlv_8_39 l_8_39 l_8_40 5.008854e-04
Rlh_8_40 l_8_40 l_9_40 5.008854e-04
Rlv_8_40 l_8_40 l_8_41 5.008854e-04
Rlh_8_41 l_8_41 l_9_41 5.008854e-04
Rlv_8_41 l_8_41 l_8_42 5.008854e-04
Rlh_8_42 l_8_42 l_9_42 5.008854e-04
Rlv_8_42 l_8_42 l_8_43 5.008854e-04
Rlh_8_43 l_8_43 l_9_43 5.008854e-04
Rlv_8_43 l_8_43 l_8_44 5.008854e-04
Rlh_8_44 l_8_44 l_9_44 5.008854e-04
Rlv_8_44 l_8_44 l_8_45 5.008854e-04
Rlh_8_45 l_8_45 l_9_45 5.008854e-04
Rlv_8_45 l_8_45 l_8_46 5.008854e-04
Rlh_8_46 l_8_46 l_9_46 5.008854e-04
Rlv_8_46 l_8_46 l_8_47 5.008854e-04
Rlh_8_47 l_8_47 l_9_47 5.008854e-04
Rlv_8_47 l_8_47 l_8_48 5.008854e-04
Rlh_8_48 l_8_48 l_9_48 5.008854e-04
Rlv_8_48 l_8_48 l_8_49 5.008854e-04
Rlh_8_49 l_8_49 l_9_49 5.008854e-04
Rlv_8_49 l_8_49 l_8_50 5.008854e-04
Rlh_8_50 l_8_50 l_9_50 5.008854e-04
Rlv_8_50 l_8_50 l_8_51 5.008854e-04
Rlh_8_51 l_8_51 l_9_51 5.008854e-04
Rlv_8_51 l_8_51 l_8_52 5.008854e-04
Rlh_8_52 l_8_52 l_9_52 5.008854e-04
Rlv_8_52 l_8_52 l_8_53 5.008854e-04
Rlh_8_53 l_8_53 l_9_53 5.008854e-04
Rlv_8_53 l_8_53 l_8_54 5.008854e-04
Rlh_8_54 l_8_54 l_9_54 5.008854e-04
Rlv_8_54 l_8_54 l_8_55 5.008854e-04
Rlh_8_55 l_8_55 l_9_55 5.008854e-04
Rlv_8_55 l_8_55 l_8_56 5.008854e-04
Rlh_8_56 l_8_56 l_9_56 5.008854e-04
Rlv_8_56 l_8_56 l_8_57 5.008854e-04
Rlh_8_57 l_8_57 l_9_57 5.008854e-04
Rlv_8_57 l_8_57 l_8_58 5.008854e-04
Rlh_8_58 l_8_58 l_9_58 5.008854e-04
Rlv_8_58 l_8_58 l_8_59 5.008854e-04
Rlh_8_59 l_8_59 l_9_59 5.008854e-04
Rlv_8_59 l_8_59 l_8_60 5.008854e-04
Rlh_8_60 l_8_60 l_9_60 5.008854e-04
Rlv_8_60 l_8_60 l_8_61 5.008854e-04
Rlh_8_61 l_8_61 l_9_61 5.008854e-04
Rlv_8_61 l_8_61 l_8_62 5.008854e-04
Rlh_8_62 l_8_62 l_9_62 5.008854e-04
Rlv_8_62 l_8_62 l_8_63 5.008854e-04
Rlh_8_63 l_8_63 l_9_63 5.008854e-04
Rlv_8_63 l_8_63 l_8_64 5.008854e-04
Rlh_8_64 l_8_64 l_9_64 5.008854e-04
Rlv_8_64 l_8_64 l_8_65 5.008854e-04
Rlh_8_65 l_8_65 l_9_65 5.008854e-04
Rlv_8_65 l_8_65 l_8_66 5.008854e-04
Rlh_8_66 l_8_66 l_9_66 5.008854e-04
Rlv_8_66 l_8_66 l_8_67 5.008854e-04
Rlh_8_67 l_8_67 l_9_67 5.008854e-04
Rlv_8_67 l_8_67 l_8_68 5.008854e-04
Rlh_8_68 l_8_68 l_9_68 5.008854e-04
Rlv_8_68 l_8_68 l_8_69 5.008854e-04
Rlh_8_69 l_8_69 l_9_69 5.008854e-04
Rlv_8_69 l_8_69 l_8_70 5.008854e-04
Rlh_8_70 l_8_70 l_9_70 5.008854e-04
Rlv_8_70 l_8_70 l_8_71 5.008854e-04
Rlh_8_71 l_8_71 l_9_71 5.008854e-04
Rlh_9_0 l_9_0 l_10_0 5.008854e-04
Rlv_9_0 l_9_0 l_9_1 5.008854e-04
Rlh_9_1 l_9_1 l_10_1 5.008854e-04
Rlv_9_1 l_9_1 l_9_2 5.008854e-04
Rlh_9_2 l_9_2 l_10_2 5.008854e-04
Rlv_9_2 l_9_2 l_9_3 5.008854e-04
Rlh_9_3 l_9_3 l_10_3 5.008854e-04
Rlv_9_3 l_9_3 l_9_4 5.008854e-04
Rlh_9_4 l_9_4 l_10_4 5.008854e-04
Rlv_9_4 l_9_4 l_9_5 5.008854e-04
Rlh_9_5 l_9_5 l_10_5 5.008854e-04
Rlv_9_5 l_9_5 l_9_6 5.008854e-04
Rlh_9_6 l_9_6 l_10_6 5.008854e-04
Rlv_9_6 l_9_6 l_9_7 5.008854e-04
Rlh_9_7 l_9_7 l_10_7 5.008854e-04
Rlv_9_7 l_9_7 l_9_8 5.008854e-04
Rlh_9_8 l_9_8 l_10_8 5.008854e-04
Rlv_9_8 l_9_8 l_9_9 5.008854e-04
Rlh_9_9 l_9_9 l_10_9 5.008854e-04
Rlv_9_9 l_9_9 l_9_10 5.008854e-04
Rlh_9_10 l_9_10 l_10_10 5.008854e-04
Rlv_9_10 l_9_10 l_9_11 5.008854e-04
Rlh_9_11 l_9_11 l_10_11 5.008854e-04
Rlv_9_11 l_9_11 l_9_12 5.008854e-04
Rlh_9_12 l_9_12 l_10_12 5.008854e-04
Rlv_9_12 l_9_12 l_9_13 5.008854e-04
Rlh_9_13 l_9_13 l_10_13 5.008854e-04
Rlv_9_13 l_9_13 l_9_14 5.008854e-04
Rlh_9_14 l_9_14 l_10_14 5.008854e-04
Rlv_9_14 l_9_14 l_9_15 5.008854e-04
Rlh_9_15 l_9_15 l_10_15 5.008854e-04
Rlv_9_15 l_9_15 l_9_16 5.008854e-04
Rlh_9_16 l_9_16 l_10_16 5.008854e-04
Rlv_9_16 l_9_16 l_9_17 5.008854e-04
Rlh_9_17 l_9_17 l_10_17 5.008854e-04
Rlv_9_17 l_9_17 l_9_18 5.008854e-04
Rlh_9_18 l_9_18 l_10_18 5.008854e-04
Rlv_9_18 l_9_18 l_9_19 5.008854e-04
Rlh_9_19 l_9_19 l_10_19 5.008854e-04
Rlv_9_19 l_9_19 l_9_20 5.008854e-04
Rlh_9_20 l_9_20 l_10_20 5.008854e-04
Rlv_9_20 l_9_20 l_9_21 5.008854e-04
Rlh_9_21 l_9_21 l_10_21 5.008854e-04
Rlv_9_21 l_9_21 l_9_22 5.008854e-04
Rlh_9_22 l_9_22 l_10_22 5.008854e-04
Rlv_9_22 l_9_22 l_9_23 5.008854e-04
Rlh_9_23 l_9_23 l_10_23 5.008854e-04
Rlv_9_23 l_9_23 l_9_24 5.008854e-04
Rlh_9_24 l_9_24 l_10_24 5.008854e-04
Rlv_9_24 l_9_24 l_9_25 5.008854e-04
Rlh_9_25 l_9_25 l_10_25 5.008854e-04
Rlv_9_25 l_9_25 l_9_26 5.008854e-04
Rlh_9_26 l_9_26 l_10_26 5.008854e-04
Rlv_9_26 l_9_26 l_9_27 5.008854e-04
Rlh_9_27 l_9_27 l_10_27 5.008854e-04
Rlv_9_27 l_9_27 l_9_28 5.008854e-04
Rlh_9_28 l_9_28 l_10_28 5.008854e-04
Rlv_9_28 l_9_28 l_9_29 5.008854e-04
Rlh_9_29 l_9_29 l_10_29 5.008854e-04
Rlv_9_29 l_9_29 l_9_30 5.008854e-04
Rlh_9_30 l_9_30 l_10_30 5.008854e-04
Rlv_9_30 l_9_30 l_9_31 5.008854e-04
Rlh_9_31 l_9_31 l_10_31 5.008854e-04
Rlv_9_31 l_9_31 l_9_32 5.008854e-04
Rlh_9_32 l_9_32 l_10_32 5.008854e-04
Rlv_9_32 l_9_32 l_9_33 5.008854e-04
Rlh_9_33 l_9_33 l_10_33 5.008854e-04
Rlv_9_33 l_9_33 l_9_34 5.008854e-04
Rlh_9_34 l_9_34 l_10_34 5.008854e-04
Rlv_9_34 l_9_34 l_9_35 5.008854e-04
Rlh_9_35 l_9_35 l_10_35 5.008854e-04
Rlv_9_35 l_9_35 l_9_36 5.008854e-04
Rlh_9_36 l_9_36 l_10_36 5.008854e-04
Rlv_9_36 l_9_36 l_9_37 5.008854e-04
Rlh_9_37 l_9_37 l_10_37 5.008854e-04
Rlv_9_37 l_9_37 l_9_38 5.008854e-04
Rlh_9_38 l_9_38 l_10_38 5.008854e-04
Rlv_9_38 l_9_38 l_9_39 5.008854e-04
Rlh_9_39 l_9_39 l_10_39 5.008854e-04
Rlv_9_39 l_9_39 l_9_40 5.008854e-04
Rlh_9_40 l_9_40 l_10_40 5.008854e-04
Rlv_9_40 l_9_40 l_9_41 5.008854e-04
Rlh_9_41 l_9_41 l_10_41 5.008854e-04
Rlv_9_41 l_9_41 l_9_42 5.008854e-04
Rlh_9_42 l_9_42 l_10_42 5.008854e-04
Rlv_9_42 l_9_42 l_9_43 5.008854e-04
Rlh_9_43 l_9_43 l_10_43 5.008854e-04
Rlv_9_43 l_9_43 l_9_44 5.008854e-04
Rlh_9_44 l_9_44 l_10_44 5.008854e-04
Rlv_9_44 l_9_44 l_9_45 5.008854e-04
Rlh_9_45 l_9_45 l_10_45 5.008854e-04
Rlv_9_45 l_9_45 l_9_46 5.008854e-04
Rlh_9_46 l_9_46 l_10_46 5.008854e-04
Rlv_9_46 l_9_46 l_9_47 5.008854e-04
Rlh_9_47 l_9_47 l_10_47 5.008854e-04
Rlv_9_47 l_9_47 l_9_48 5.008854e-04
Rlh_9_48 l_9_48 l_10_48 5.008854e-04
Rlv_9_48 l_9_48 l_9_49 5.008854e-04
Rlh_9_49 l_9_49 l_10_49 5.008854e-04
Rlv_9_49 l_9_49 l_9_50 5.008854e-04
Rlh_9_50 l_9_50 l_10_50 5.008854e-04
Rlv_9_50 l_9_50 l_9_51 5.008854e-04
Rlh_9_51 l_9_51 l_10_51 5.008854e-04
Rlv_9_51 l_9_51 l_9_52 5.008854e-04
Rlh_9_52 l_9_52 l_10_52 5.008854e-04
Rlv_9_52 l_9_52 l_9_53 5.008854e-04
Rlh_9_53 l_9_53 l_10_53 5.008854e-04
Rlv_9_53 l_9_53 l_9_54 5.008854e-04
Rlh_9_54 l_9_54 l_10_54 5.008854e-04
Rlv_9_54 l_9_54 l_9_55 5.008854e-04
Rlh_9_55 l_9_55 l_10_55 5.008854e-04
Rlv_9_55 l_9_55 l_9_56 5.008854e-04
Rlh_9_56 l_9_56 l_10_56 5.008854e-04
Rlv_9_56 l_9_56 l_9_57 5.008854e-04
Rlh_9_57 l_9_57 l_10_57 5.008854e-04
Rlv_9_57 l_9_57 l_9_58 5.008854e-04
Rlh_9_58 l_9_58 l_10_58 5.008854e-04
Rlv_9_58 l_9_58 l_9_59 5.008854e-04
Rlh_9_59 l_9_59 l_10_59 5.008854e-04
Rlv_9_59 l_9_59 l_9_60 5.008854e-04
Rlh_9_60 l_9_60 l_10_60 5.008854e-04
Rlv_9_60 l_9_60 l_9_61 5.008854e-04
Rlh_9_61 l_9_61 l_10_61 5.008854e-04
Rlv_9_61 l_9_61 l_9_62 5.008854e-04
Rlh_9_62 l_9_62 l_10_62 5.008854e-04
Rlv_9_62 l_9_62 l_9_63 5.008854e-04
Rlh_9_63 l_9_63 l_10_63 5.008854e-04
Rlv_9_63 l_9_63 l_9_64 5.008854e-04
Rlh_9_64 l_9_64 l_10_64 5.008854e-04
Rlv_9_64 l_9_64 l_9_65 5.008854e-04
Rlh_9_65 l_9_65 l_10_65 5.008854e-04
Rlv_9_65 l_9_65 l_9_66 5.008854e-04
Rlh_9_66 l_9_66 l_10_66 5.008854e-04
Rlv_9_66 l_9_66 l_9_67 5.008854e-04
Rlh_9_67 l_9_67 l_10_67 5.008854e-04
Rlv_9_67 l_9_67 l_9_68 5.008854e-04
Rlh_9_68 l_9_68 l_10_68 5.008854e-04
Rlv_9_68 l_9_68 l_9_69 5.008854e-04
Rlh_9_69 l_9_69 l_10_69 5.008854e-04
Rlv_9_69 l_9_69 l_9_70 5.008854e-04
Rlh_9_70 l_9_70 l_10_70 5.008854e-04
Rlv_9_70 l_9_70 l_9_71 5.008854e-04
Rlh_9_71 l_9_71 l_10_71 5.008854e-04
Rlh_10_0 l_10_0 l_11_0 5.008854e-04
Rlv_10_0 l_10_0 l_10_1 5.008854e-04
Rlh_10_1 l_10_1 l_11_1 5.008854e-04
Rlv_10_1 l_10_1 l_10_2 5.008854e-04
Rlh_10_2 l_10_2 l_11_2 5.008854e-04
Rlv_10_2 l_10_2 l_10_3 5.008854e-04
Rlh_10_3 l_10_3 l_11_3 5.008854e-04
Rlv_10_3 l_10_3 l_10_4 5.008854e-04
Rlh_10_4 l_10_4 l_11_4 5.008854e-04
Rlv_10_4 l_10_4 l_10_5 5.008854e-04
Rlh_10_5 l_10_5 l_11_5 5.008854e-04
Rlv_10_5 l_10_5 l_10_6 5.008854e-04
Rlh_10_6 l_10_6 l_11_6 5.008854e-04
Rlv_10_6 l_10_6 l_10_7 5.008854e-04
Rlh_10_7 l_10_7 l_11_7 5.008854e-04
Rlv_10_7 l_10_7 l_10_8 5.008854e-04
Rlh_10_8 l_10_8 l_11_8 5.008854e-04
Rlv_10_8 l_10_8 l_10_9 5.008854e-04
Rlh_10_9 l_10_9 l_11_9 5.008854e-04
Rlv_10_9 l_10_9 l_10_10 5.008854e-04
Rlh_10_10 l_10_10 l_11_10 5.008854e-04
Rlv_10_10 l_10_10 l_10_11 5.008854e-04
Rlh_10_11 l_10_11 l_11_11 5.008854e-04
Rlv_10_11 l_10_11 l_10_12 5.008854e-04
Rlh_10_12 l_10_12 l_11_12 5.008854e-04
Rlv_10_12 l_10_12 l_10_13 5.008854e-04
Rlh_10_13 l_10_13 l_11_13 5.008854e-04
Rlv_10_13 l_10_13 l_10_14 5.008854e-04
Rlh_10_14 l_10_14 l_11_14 5.008854e-04
Rlv_10_14 l_10_14 l_10_15 5.008854e-04
Rlh_10_15 l_10_15 l_11_15 5.008854e-04
Rlv_10_15 l_10_15 l_10_16 5.008854e-04
Rlh_10_16 l_10_16 l_11_16 5.008854e-04
Rlv_10_16 l_10_16 l_10_17 5.008854e-04
Rlh_10_17 l_10_17 l_11_17 5.008854e-04
Rlv_10_17 l_10_17 l_10_18 5.008854e-04
Rlh_10_18 l_10_18 l_11_18 5.008854e-04
Rlv_10_18 l_10_18 l_10_19 5.008854e-04
Rlh_10_19 l_10_19 l_11_19 5.008854e-04
Rlv_10_19 l_10_19 l_10_20 5.008854e-04
Rlh_10_20 l_10_20 l_11_20 5.008854e-04
Rlv_10_20 l_10_20 l_10_21 5.008854e-04
Rlh_10_21 l_10_21 l_11_21 5.008854e-04
Rlv_10_21 l_10_21 l_10_22 5.008854e-04
Rlh_10_22 l_10_22 l_11_22 5.008854e-04
Rlv_10_22 l_10_22 l_10_23 5.008854e-04
Rlh_10_23 l_10_23 l_11_23 5.008854e-04
Rlv_10_23 l_10_23 l_10_24 5.008854e-04
Rlh_10_24 l_10_24 l_11_24 5.008854e-04
Rlv_10_24 l_10_24 l_10_25 5.008854e-04
Rlh_10_25 l_10_25 l_11_25 5.008854e-04
Rlv_10_25 l_10_25 l_10_26 5.008854e-04
Rlh_10_26 l_10_26 l_11_26 5.008854e-04
Rlv_10_26 l_10_26 l_10_27 5.008854e-04
Rlh_10_27 l_10_27 l_11_27 5.008854e-04
Rlv_10_27 l_10_27 l_10_28 5.008854e-04
Rlh_10_28 l_10_28 l_11_28 5.008854e-04
Rlv_10_28 l_10_28 l_10_29 5.008854e-04
Rlh_10_29 l_10_29 l_11_29 5.008854e-04
Rlv_10_29 l_10_29 l_10_30 5.008854e-04
Rlh_10_30 l_10_30 l_11_30 5.008854e-04
Rlv_10_30 l_10_30 l_10_31 5.008854e-04
Rlh_10_31 l_10_31 l_11_31 5.008854e-04
Rlv_10_31 l_10_31 l_10_32 5.008854e-04
Rlh_10_32 l_10_32 l_11_32 5.008854e-04
Rlv_10_32 l_10_32 l_10_33 5.008854e-04
Rlh_10_33 l_10_33 l_11_33 5.008854e-04
Rlv_10_33 l_10_33 l_10_34 5.008854e-04
Rlh_10_34 l_10_34 l_11_34 5.008854e-04
Rlv_10_34 l_10_34 l_10_35 5.008854e-04
Rlh_10_35 l_10_35 l_11_35 5.008854e-04
Rlv_10_35 l_10_35 l_10_36 5.008854e-04
Rlh_10_36 l_10_36 l_11_36 5.008854e-04
Rlv_10_36 l_10_36 l_10_37 5.008854e-04
Rlh_10_37 l_10_37 l_11_37 5.008854e-04
Rlv_10_37 l_10_37 l_10_38 5.008854e-04
Rlh_10_38 l_10_38 l_11_38 5.008854e-04
Rlv_10_38 l_10_38 l_10_39 5.008854e-04
Rlh_10_39 l_10_39 l_11_39 5.008854e-04
Rlv_10_39 l_10_39 l_10_40 5.008854e-04
Rlh_10_40 l_10_40 l_11_40 5.008854e-04
Rlv_10_40 l_10_40 l_10_41 5.008854e-04
Rlh_10_41 l_10_41 l_11_41 5.008854e-04
Rlv_10_41 l_10_41 l_10_42 5.008854e-04
Rlh_10_42 l_10_42 l_11_42 5.008854e-04
Rlv_10_42 l_10_42 l_10_43 5.008854e-04
Rlh_10_43 l_10_43 l_11_43 5.008854e-04
Rlv_10_43 l_10_43 l_10_44 5.008854e-04
Rlh_10_44 l_10_44 l_11_44 5.008854e-04
Rlv_10_44 l_10_44 l_10_45 5.008854e-04
Rlh_10_45 l_10_45 l_11_45 5.008854e-04
Rlv_10_45 l_10_45 l_10_46 5.008854e-04
Rlh_10_46 l_10_46 l_11_46 5.008854e-04
Rlv_10_46 l_10_46 l_10_47 5.008854e-04
Rlh_10_47 l_10_47 l_11_47 5.008854e-04
Rlv_10_47 l_10_47 l_10_48 5.008854e-04
Rlh_10_48 l_10_48 l_11_48 5.008854e-04
Rlv_10_48 l_10_48 l_10_49 5.008854e-04
Rlh_10_49 l_10_49 l_11_49 5.008854e-04
Rlv_10_49 l_10_49 l_10_50 5.008854e-04
Rlh_10_50 l_10_50 l_11_50 5.008854e-04
Rlv_10_50 l_10_50 l_10_51 5.008854e-04
Rlh_10_51 l_10_51 l_11_51 5.008854e-04
Rlv_10_51 l_10_51 l_10_52 5.008854e-04
Rlh_10_52 l_10_52 l_11_52 5.008854e-04
Rlv_10_52 l_10_52 l_10_53 5.008854e-04
Rlh_10_53 l_10_53 l_11_53 5.008854e-04
Rlv_10_53 l_10_53 l_10_54 5.008854e-04
Rlh_10_54 l_10_54 l_11_54 5.008854e-04
Rlv_10_54 l_10_54 l_10_55 5.008854e-04
Rlh_10_55 l_10_55 l_11_55 5.008854e-04
Rlv_10_55 l_10_55 l_10_56 5.008854e-04
Rlh_10_56 l_10_56 l_11_56 5.008854e-04
Rlv_10_56 l_10_56 l_10_57 5.008854e-04
Rlh_10_57 l_10_57 l_11_57 5.008854e-04
Rlv_10_57 l_10_57 l_10_58 5.008854e-04
Rlh_10_58 l_10_58 l_11_58 5.008854e-04
Rlv_10_58 l_10_58 l_10_59 5.008854e-04
Rlh_10_59 l_10_59 l_11_59 5.008854e-04
Rlv_10_59 l_10_59 l_10_60 5.008854e-04
Rlh_10_60 l_10_60 l_11_60 5.008854e-04
Rlv_10_60 l_10_60 l_10_61 5.008854e-04
Rlh_10_61 l_10_61 l_11_61 5.008854e-04
Rlv_10_61 l_10_61 l_10_62 5.008854e-04
Rlh_10_62 l_10_62 l_11_62 5.008854e-04
Rlv_10_62 l_10_62 l_10_63 5.008854e-04
Rlh_10_63 l_10_63 l_11_63 5.008854e-04
Rlv_10_63 l_10_63 l_10_64 5.008854e-04
Rlh_10_64 l_10_64 l_11_64 5.008854e-04
Rlv_10_64 l_10_64 l_10_65 5.008854e-04
Rlh_10_65 l_10_65 l_11_65 5.008854e-04
Rlv_10_65 l_10_65 l_10_66 5.008854e-04
Rlh_10_66 l_10_66 l_11_66 5.008854e-04
Rlv_10_66 l_10_66 l_10_67 5.008854e-04
Rlh_10_67 l_10_67 l_11_67 5.008854e-04
Rlv_10_67 l_10_67 l_10_68 5.008854e-04
Rlh_10_68 l_10_68 l_11_68 5.008854e-04
Rlv_10_68 l_10_68 l_10_69 5.008854e-04
Rlh_10_69 l_10_69 l_11_69 5.008854e-04
Rlv_10_69 l_10_69 l_10_70 5.008854e-04
Rlh_10_70 l_10_70 l_11_70 5.008854e-04
Rlv_10_70 l_10_70 l_10_71 5.008854e-04
Rlh_10_71 l_10_71 l_11_71 5.008854e-04
Rlh_11_0 l_11_0 l_12_0 5.008854e-04
Rlv_11_0 l_11_0 l_11_1 5.008854e-04
Rlh_11_1 l_11_1 l_12_1 5.008854e-04
Rlv_11_1 l_11_1 l_11_2 5.008854e-04
Rlh_11_2 l_11_2 l_12_2 5.008854e-04
Rlv_11_2 l_11_2 l_11_3 5.008854e-04
Rlh_11_3 l_11_3 l_12_3 5.008854e-04
Rlv_11_3 l_11_3 l_11_4 5.008854e-04
Rlh_11_4 l_11_4 l_12_4 5.008854e-04
Rlv_11_4 l_11_4 l_11_5 5.008854e-04
Rlh_11_5 l_11_5 l_12_5 5.008854e-04
Rlv_11_5 l_11_5 l_11_6 5.008854e-04
Rlh_11_6 l_11_6 l_12_6 5.008854e-04
Rlv_11_6 l_11_6 l_11_7 5.008854e-04
Rlh_11_7 l_11_7 l_12_7 5.008854e-04
Rlv_11_7 l_11_7 l_11_8 5.008854e-04
Rlh_11_8 l_11_8 l_12_8 5.008854e-04
Rlv_11_8 l_11_8 l_11_9 5.008854e-04
Rlh_11_9 l_11_9 l_12_9 5.008854e-04
Rlv_11_9 l_11_9 l_11_10 5.008854e-04
Rlh_11_10 l_11_10 l_12_10 5.008854e-04
Rlv_11_10 l_11_10 l_11_11 5.008854e-04
Rlh_11_11 l_11_11 l_12_11 5.008854e-04
Rlv_11_11 l_11_11 l_11_12 5.008854e-04
Rlh_11_12 l_11_12 l_12_12 5.008854e-04
Rlv_11_12 l_11_12 l_11_13 5.008854e-04
Rlh_11_13 l_11_13 l_12_13 5.008854e-04
Rlv_11_13 l_11_13 l_11_14 5.008854e-04
Rlh_11_14 l_11_14 l_12_14 5.008854e-04
Rlv_11_14 l_11_14 l_11_15 5.008854e-04
Rlh_11_15 l_11_15 l_12_15 5.008854e-04
Rlv_11_15 l_11_15 l_11_16 5.008854e-04
Rlh_11_16 l_11_16 l_12_16 5.008854e-04
Rlv_11_16 l_11_16 l_11_17 5.008854e-04
Rlh_11_17 l_11_17 l_12_17 5.008854e-04
Rlv_11_17 l_11_17 l_11_18 5.008854e-04
Rlh_11_18 l_11_18 l_12_18 5.008854e-04
Rlv_11_18 l_11_18 l_11_19 5.008854e-04
Rlh_11_19 l_11_19 l_12_19 5.008854e-04
Rlv_11_19 l_11_19 l_11_20 5.008854e-04
Rlh_11_20 l_11_20 l_12_20 5.008854e-04
Rlv_11_20 l_11_20 l_11_21 5.008854e-04
Rlh_11_21 l_11_21 l_12_21 5.008854e-04
Rlv_11_21 l_11_21 l_11_22 5.008854e-04
Rlh_11_22 l_11_22 l_12_22 5.008854e-04
Rlv_11_22 l_11_22 l_11_23 5.008854e-04
Rlh_11_23 l_11_23 l_12_23 5.008854e-04
Rlv_11_23 l_11_23 l_11_24 5.008854e-04
Rlh_11_24 l_11_24 l_12_24 5.008854e-04
Rlv_11_24 l_11_24 l_11_25 5.008854e-04
Rlh_11_25 l_11_25 l_12_25 5.008854e-04
Rlv_11_25 l_11_25 l_11_26 5.008854e-04
Rlh_11_26 l_11_26 l_12_26 5.008854e-04
Rlv_11_26 l_11_26 l_11_27 5.008854e-04
Rlh_11_27 l_11_27 l_12_27 5.008854e-04
Rlv_11_27 l_11_27 l_11_28 5.008854e-04
Rlh_11_28 l_11_28 l_12_28 5.008854e-04
Rlv_11_28 l_11_28 l_11_29 5.008854e-04
Rlh_11_29 l_11_29 l_12_29 5.008854e-04
Rlv_11_29 l_11_29 l_11_30 5.008854e-04
Rlh_11_30 l_11_30 l_12_30 5.008854e-04
Rlv_11_30 l_11_30 l_11_31 5.008854e-04
Rlh_11_31 l_11_31 l_12_31 5.008854e-04
Rlv_11_31 l_11_31 l_11_32 5.008854e-04
Rlh_11_32 l_11_32 l_12_32 5.008854e-04
Rlv_11_32 l_11_32 l_11_33 5.008854e-04
Rlh_11_33 l_11_33 l_12_33 5.008854e-04
Rlv_11_33 l_11_33 l_11_34 5.008854e-04
Rlh_11_34 l_11_34 l_12_34 5.008854e-04
Rlv_11_34 l_11_34 l_11_35 5.008854e-04
Rlh_11_35 l_11_35 l_12_35 5.008854e-04
Rlv_11_35 l_11_35 l_11_36 5.008854e-04
Rlh_11_36 l_11_36 l_12_36 5.008854e-04
Rlv_11_36 l_11_36 l_11_37 5.008854e-04
Rlh_11_37 l_11_37 l_12_37 5.008854e-04
Rlv_11_37 l_11_37 l_11_38 5.008854e-04
Rlh_11_38 l_11_38 l_12_38 5.008854e-04
Rlv_11_38 l_11_38 l_11_39 5.008854e-04
Rlh_11_39 l_11_39 l_12_39 5.008854e-04
Rlv_11_39 l_11_39 l_11_40 5.008854e-04
Rlh_11_40 l_11_40 l_12_40 5.008854e-04
Rlv_11_40 l_11_40 l_11_41 5.008854e-04
Rlh_11_41 l_11_41 l_12_41 5.008854e-04
Rlv_11_41 l_11_41 l_11_42 5.008854e-04
Rlh_11_42 l_11_42 l_12_42 5.008854e-04
Rlv_11_42 l_11_42 l_11_43 5.008854e-04
Rlh_11_43 l_11_43 l_12_43 5.008854e-04
Rlv_11_43 l_11_43 l_11_44 5.008854e-04
Rlh_11_44 l_11_44 l_12_44 5.008854e-04
Rlv_11_44 l_11_44 l_11_45 5.008854e-04
Rlh_11_45 l_11_45 l_12_45 5.008854e-04
Rlv_11_45 l_11_45 l_11_46 5.008854e-04
Rlh_11_46 l_11_46 l_12_46 5.008854e-04
Rlv_11_46 l_11_46 l_11_47 5.008854e-04
Rlh_11_47 l_11_47 l_12_47 5.008854e-04
Rlv_11_47 l_11_47 l_11_48 5.008854e-04
Rlh_11_48 l_11_48 l_12_48 5.008854e-04
Rlv_11_48 l_11_48 l_11_49 5.008854e-04
Rlh_11_49 l_11_49 l_12_49 5.008854e-04
Rlv_11_49 l_11_49 l_11_50 5.008854e-04
Rlh_11_50 l_11_50 l_12_50 5.008854e-04
Rlv_11_50 l_11_50 l_11_51 5.008854e-04
Rlh_11_51 l_11_51 l_12_51 5.008854e-04
Rlv_11_51 l_11_51 l_11_52 5.008854e-04
Rlh_11_52 l_11_52 l_12_52 5.008854e-04
Rlv_11_52 l_11_52 l_11_53 5.008854e-04
Rlh_11_53 l_11_53 l_12_53 5.008854e-04
Rlv_11_53 l_11_53 l_11_54 5.008854e-04
Rlh_11_54 l_11_54 l_12_54 5.008854e-04
Rlv_11_54 l_11_54 l_11_55 5.008854e-04
Rlh_11_55 l_11_55 l_12_55 5.008854e-04
Rlv_11_55 l_11_55 l_11_56 5.008854e-04
Rlh_11_56 l_11_56 l_12_56 5.008854e-04
Rlv_11_56 l_11_56 l_11_57 5.008854e-04
Rlh_11_57 l_11_57 l_12_57 5.008854e-04
Rlv_11_57 l_11_57 l_11_58 5.008854e-04
Rlh_11_58 l_11_58 l_12_58 5.008854e-04
Rlv_11_58 l_11_58 l_11_59 5.008854e-04
Rlh_11_59 l_11_59 l_12_59 5.008854e-04
Rlv_11_59 l_11_59 l_11_60 5.008854e-04
Rlh_11_60 l_11_60 l_12_60 5.008854e-04
Rlv_11_60 l_11_60 l_11_61 5.008854e-04
Rlh_11_61 l_11_61 l_12_61 5.008854e-04
Rlv_11_61 l_11_61 l_11_62 5.008854e-04
Rlh_11_62 l_11_62 l_12_62 5.008854e-04
Rlv_11_62 l_11_62 l_11_63 5.008854e-04
Rlh_11_63 l_11_63 l_12_63 5.008854e-04
Rlv_11_63 l_11_63 l_11_64 5.008854e-04
Rlh_11_64 l_11_64 l_12_64 5.008854e-04
Rlv_11_64 l_11_64 l_11_65 5.008854e-04
Rlh_11_65 l_11_65 l_12_65 5.008854e-04
Rlv_11_65 l_11_65 l_11_66 5.008854e-04
Rlh_11_66 l_11_66 l_12_66 5.008854e-04
Rlv_11_66 l_11_66 l_11_67 5.008854e-04
Rlh_11_67 l_11_67 l_12_67 5.008854e-04
Rlv_11_67 l_11_67 l_11_68 5.008854e-04
Rlh_11_68 l_11_68 l_12_68 5.008854e-04
Rlv_11_68 l_11_68 l_11_69 5.008854e-04
Rlh_11_69 l_11_69 l_12_69 5.008854e-04
Rlv_11_69 l_11_69 l_11_70 5.008854e-04
Rlh_11_70 l_11_70 l_12_70 5.008854e-04
Rlv_11_70 l_11_70 l_11_71 5.008854e-04
Rlh_11_71 l_11_71 l_12_71 5.008854e-04
Rlh_12_0 l_12_0 l_13_0 5.008854e-04
Rlv_12_0 l_12_0 l_12_1 5.008854e-04
Rlh_12_1 l_12_1 l_13_1 5.008854e-04
Rlv_12_1 l_12_1 l_12_2 5.008854e-04
Rlh_12_2 l_12_2 l_13_2 5.008854e-04
Rlv_12_2 l_12_2 l_12_3 5.008854e-04
Rlh_12_3 l_12_3 l_13_3 5.008854e-04
Rlv_12_3 l_12_3 l_12_4 5.008854e-04
Rlh_12_4 l_12_4 l_13_4 5.008854e-04
Rlv_12_4 l_12_4 l_12_5 5.008854e-04
Rlh_12_5 l_12_5 l_13_5 5.008854e-04
Rlv_12_5 l_12_5 l_12_6 5.008854e-04
Rlh_12_6 l_12_6 l_13_6 5.008854e-04
Rlv_12_6 l_12_6 l_12_7 5.008854e-04
Rlh_12_7 l_12_7 l_13_7 5.008854e-04
Rlv_12_7 l_12_7 l_12_8 5.008854e-04
Rlh_12_8 l_12_8 l_13_8 5.008854e-04
Rlv_12_8 l_12_8 l_12_9 5.008854e-04
Rlh_12_9 l_12_9 l_13_9 5.008854e-04
Rlv_12_9 l_12_9 l_12_10 5.008854e-04
Rlh_12_10 l_12_10 l_13_10 5.008854e-04
Rlv_12_10 l_12_10 l_12_11 5.008854e-04
Rlh_12_11 l_12_11 l_13_11 5.008854e-04
Rlv_12_11 l_12_11 l_12_12 5.008854e-04
Rlh_12_12 l_12_12 l_13_12 5.008854e-04
Rlv_12_12 l_12_12 l_12_13 5.008854e-04
Rlh_12_13 l_12_13 l_13_13 5.008854e-04
Rlv_12_13 l_12_13 l_12_14 5.008854e-04
Rlh_12_14 l_12_14 l_13_14 5.008854e-04
Rlv_12_14 l_12_14 l_12_15 5.008854e-04
Rlh_12_15 l_12_15 l_13_15 5.008854e-04
Rlv_12_15 l_12_15 l_12_16 5.008854e-04
Rlh_12_16 l_12_16 l_13_16 5.008854e-04
Rlv_12_16 l_12_16 l_12_17 5.008854e-04
Rlh_12_17 l_12_17 l_13_17 5.008854e-04
Rlv_12_17 l_12_17 l_12_18 5.008854e-04
Rlh_12_18 l_12_18 l_13_18 5.008854e-04
Rlv_12_18 l_12_18 l_12_19 5.008854e-04
Rlh_12_19 l_12_19 l_13_19 5.008854e-04
Rlv_12_19 l_12_19 l_12_20 5.008854e-04
Rlh_12_20 l_12_20 l_13_20 5.008854e-04
Rlv_12_20 l_12_20 l_12_21 5.008854e-04
Rlh_12_21 l_12_21 l_13_21 5.008854e-04
Rlv_12_21 l_12_21 l_12_22 5.008854e-04
Rlh_12_22 l_12_22 l_13_22 5.008854e-04
Rlv_12_22 l_12_22 l_12_23 5.008854e-04
Rlh_12_23 l_12_23 l_13_23 5.008854e-04
Rlv_12_23 l_12_23 l_12_24 5.008854e-04
Rlh_12_24 l_12_24 l_13_24 5.008854e-04
Rlv_12_24 l_12_24 l_12_25 5.008854e-04
Rlh_12_25 l_12_25 l_13_25 5.008854e-04
Rlv_12_25 l_12_25 l_12_26 5.008854e-04
Rlh_12_26 l_12_26 l_13_26 5.008854e-04
Rlv_12_26 l_12_26 l_12_27 5.008854e-04
Rlh_12_27 l_12_27 l_13_27 5.008854e-04
Rlv_12_27 l_12_27 l_12_28 5.008854e-04
Rlh_12_28 l_12_28 l_13_28 5.008854e-04
Rlv_12_28 l_12_28 l_12_29 5.008854e-04
Rlh_12_29 l_12_29 l_13_29 5.008854e-04
Rlv_12_29 l_12_29 l_12_30 5.008854e-04
Rlh_12_30 l_12_30 l_13_30 5.008854e-04
Rlv_12_30 l_12_30 l_12_31 5.008854e-04
Rlh_12_31 l_12_31 l_13_31 5.008854e-04
Rlv_12_31 l_12_31 l_12_32 5.008854e-04
Rlh_12_32 l_12_32 l_13_32 5.008854e-04
Rlv_12_32 l_12_32 l_12_33 5.008854e-04
Rlh_12_33 l_12_33 l_13_33 5.008854e-04
Rlv_12_33 l_12_33 l_12_34 5.008854e-04
Rlh_12_34 l_12_34 l_13_34 5.008854e-04
Rlv_12_34 l_12_34 l_12_35 5.008854e-04
Rlh_12_35 l_12_35 l_13_35 5.008854e-04
Rlv_12_35 l_12_35 l_12_36 5.008854e-04
Rlh_12_36 l_12_36 l_13_36 5.008854e-04
Rlv_12_36 l_12_36 l_12_37 5.008854e-04
Rlh_12_37 l_12_37 l_13_37 5.008854e-04
Rlv_12_37 l_12_37 l_12_38 5.008854e-04
Rlh_12_38 l_12_38 l_13_38 5.008854e-04
Rlv_12_38 l_12_38 l_12_39 5.008854e-04
Rlh_12_39 l_12_39 l_13_39 5.008854e-04
Rlv_12_39 l_12_39 l_12_40 5.008854e-04
Rlh_12_40 l_12_40 l_13_40 5.008854e-04
Rlv_12_40 l_12_40 l_12_41 5.008854e-04
Rlh_12_41 l_12_41 l_13_41 5.008854e-04
Rlv_12_41 l_12_41 l_12_42 5.008854e-04
Rlh_12_42 l_12_42 l_13_42 5.008854e-04
Rlv_12_42 l_12_42 l_12_43 5.008854e-04
Rlh_12_43 l_12_43 l_13_43 5.008854e-04
Rlv_12_43 l_12_43 l_12_44 5.008854e-04
Rlh_12_44 l_12_44 l_13_44 5.008854e-04
Rlv_12_44 l_12_44 l_12_45 5.008854e-04
Rlh_12_45 l_12_45 l_13_45 5.008854e-04
Rlv_12_45 l_12_45 l_12_46 5.008854e-04
Rlh_12_46 l_12_46 l_13_46 5.008854e-04
Rlv_12_46 l_12_46 l_12_47 5.008854e-04
Rlh_12_47 l_12_47 l_13_47 5.008854e-04
Rlv_12_47 l_12_47 l_12_48 5.008854e-04
Rlh_12_48 l_12_48 l_13_48 5.008854e-04
Rlv_12_48 l_12_48 l_12_49 5.008854e-04
Rlh_12_49 l_12_49 l_13_49 5.008854e-04
Rlv_12_49 l_12_49 l_12_50 5.008854e-04
Rlh_12_50 l_12_50 l_13_50 5.008854e-04
Rlv_12_50 l_12_50 l_12_51 5.008854e-04
Rlh_12_51 l_12_51 l_13_51 5.008854e-04
Rlv_12_51 l_12_51 l_12_52 5.008854e-04
Rlh_12_52 l_12_52 l_13_52 5.008854e-04
Rlv_12_52 l_12_52 l_12_53 5.008854e-04
Rlh_12_53 l_12_53 l_13_53 5.008854e-04
Rlv_12_53 l_12_53 l_12_54 5.008854e-04
Rlh_12_54 l_12_54 l_13_54 5.008854e-04
Rlv_12_54 l_12_54 l_12_55 5.008854e-04
Rlh_12_55 l_12_55 l_13_55 5.008854e-04
Rlv_12_55 l_12_55 l_12_56 5.008854e-04
Rlh_12_56 l_12_56 l_13_56 5.008854e-04
Rlv_12_56 l_12_56 l_12_57 5.008854e-04
Rlh_12_57 l_12_57 l_13_57 5.008854e-04
Rlv_12_57 l_12_57 l_12_58 5.008854e-04
Rlh_12_58 l_12_58 l_13_58 5.008854e-04
Rlv_12_58 l_12_58 l_12_59 5.008854e-04
Rlh_12_59 l_12_59 l_13_59 5.008854e-04
Rlv_12_59 l_12_59 l_12_60 5.008854e-04
Rlh_12_60 l_12_60 l_13_60 5.008854e-04
Rlv_12_60 l_12_60 l_12_61 5.008854e-04
Rlh_12_61 l_12_61 l_13_61 5.008854e-04
Rlv_12_61 l_12_61 l_12_62 5.008854e-04
Rlh_12_62 l_12_62 l_13_62 5.008854e-04
Rlv_12_62 l_12_62 l_12_63 5.008854e-04
Rlh_12_63 l_12_63 l_13_63 5.008854e-04
Rlv_12_63 l_12_63 l_12_64 5.008854e-04
Rlh_12_64 l_12_64 l_13_64 5.008854e-04
Rlv_12_64 l_12_64 l_12_65 5.008854e-04
Rlh_12_65 l_12_65 l_13_65 5.008854e-04
Rlv_12_65 l_12_65 l_12_66 5.008854e-04
Rlh_12_66 l_12_66 l_13_66 5.008854e-04
Rlv_12_66 l_12_66 l_12_67 5.008854e-04
Rlh_12_67 l_12_67 l_13_67 5.008854e-04
Rlv_12_67 l_12_67 l_12_68 5.008854e-04
Rlh_12_68 l_12_68 l_13_68 5.008854e-04
Rlv_12_68 l_12_68 l_12_69 5.008854e-04
Rlh_12_69 l_12_69 l_13_69 5.008854e-04
Rlv_12_69 l_12_69 l_12_70 5.008854e-04
Rlh_12_70 l_12_70 l_13_70 5.008854e-04
Rlv_12_70 l_12_70 l_12_71 5.008854e-04
Rlh_12_71 l_12_71 l_13_71 5.008854e-04
Rlh_13_0 l_13_0 l_14_0 5.008854e-04
Rlv_13_0 l_13_0 l_13_1 5.008854e-04
Rlh_13_1 l_13_1 l_14_1 5.008854e-04
Rlv_13_1 l_13_1 l_13_2 5.008854e-04
Rlh_13_2 l_13_2 l_14_2 5.008854e-04
Rlv_13_2 l_13_2 l_13_3 5.008854e-04
Rlh_13_3 l_13_3 l_14_3 5.008854e-04
Rlv_13_3 l_13_3 l_13_4 5.008854e-04
Rlh_13_4 l_13_4 l_14_4 5.008854e-04
Rlv_13_4 l_13_4 l_13_5 5.008854e-04
Rlh_13_5 l_13_5 l_14_5 5.008854e-04
Rlv_13_5 l_13_5 l_13_6 5.008854e-04
Rlh_13_6 l_13_6 l_14_6 5.008854e-04
Rlv_13_6 l_13_6 l_13_7 5.008854e-04
Rlh_13_7 l_13_7 l_14_7 5.008854e-04
Rlv_13_7 l_13_7 l_13_8 5.008854e-04
Rlh_13_8 l_13_8 l_14_8 5.008854e-04
Rlv_13_8 l_13_8 l_13_9 5.008854e-04
Rlh_13_9 l_13_9 l_14_9 5.008854e-04
Rlv_13_9 l_13_9 l_13_10 5.008854e-04
Rlh_13_10 l_13_10 l_14_10 5.008854e-04
Rlv_13_10 l_13_10 l_13_11 5.008854e-04
Rlh_13_11 l_13_11 l_14_11 5.008854e-04
Rlv_13_11 l_13_11 l_13_12 5.008854e-04
Rlh_13_12 l_13_12 l_14_12 5.008854e-04
Rlv_13_12 l_13_12 l_13_13 5.008854e-04
Rlh_13_13 l_13_13 l_14_13 5.008854e-04
Rlv_13_13 l_13_13 l_13_14 5.008854e-04
Rlh_13_14 l_13_14 l_14_14 5.008854e-04
Rlv_13_14 l_13_14 l_13_15 5.008854e-04
Rlh_13_15 l_13_15 l_14_15 5.008854e-04
Rlv_13_15 l_13_15 l_13_16 5.008854e-04
Rlh_13_16 l_13_16 l_14_16 5.008854e-04
Rlv_13_16 l_13_16 l_13_17 5.008854e-04
Rlh_13_17 l_13_17 l_14_17 5.008854e-04
Rlv_13_17 l_13_17 l_13_18 5.008854e-04
Rlh_13_18 l_13_18 l_14_18 5.008854e-04
Rlv_13_18 l_13_18 l_13_19 5.008854e-04
Rlh_13_19 l_13_19 l_14_19 5.008854e-04
Rlv_13_19 l_13_19 l_13_20 5.008854e-04
Rlh_13_20 l_13_20 l_14_20 5.008854e-04
Rlv_13_20 l_13_20 l_13_21 5.008854e-04
Rlh_13_21 l_13_21 l_14_21 5.008854e-04
Rlv_13_21 l_13_21 l_13_22 5.008854e-04
Rlh_13_22 l_13_22 l_14_22 5.008854e-04
Rlv_13_22 l_13_22 l_13_23 5.008854e-04
Rlh_13_23 l_13_23 l_14_23 5.008854e-04
Rlv_13_23 l_13_23 l_13_24 5.008854e-04
Rlh_13_24 l_13_24 l_14_24 5.008854e-04
Rlv_13_24 l_13_24 l_13_25 5.008854e-04
Rlh_13_25 l_13_25 l_14_25 5.008854e-04
Rlv_13_25 l_13_25 l_13_26 5.008854e-04
Rlh_13_26 l_13_26 l_14_26 5.008854e-04
Rlv_13_26 l_13_26 l_13_27 5.008854e-04
Rlh_13_27 l_13_27 l_14_27 5.008854e-04
Rlv_13_27 l_13_27 l_13_28 5.008854e-04
Rlh_13_28 l_13_28 l_14_28 5.008854e-04
Rlv_13_28 l_13_28 l_13_29 5.008854e-04
Rlh_13_29 l_13_29 l_14_29 5.008854e-04
Rlv_13_29 l_13_29 l_13_30 5.008854e-04
Rlh_13_30 l_13_30 l_14_30 5.008854e-04
Rlv_13_30 l_13_30 l_13_31 5.008854e-04
Rlh_13_31 l_13_31 l_14_31 5.008854e-04
Rlv_13_31 l_13_31 l_13_32 5.008854e-04
Rlh_13_32 l_13_32 l_14_32 5.008854e-04
Rlv_13_32 l_13_32 l_13_33 5.008854e-04
Rlh_13_33 l_13_33 l_14_33 5.008854e-04
Rlv_13_33 l_13_33 l_13_34 5.008854e-04
Rlh_13_34 l_13_34 l_14_34 5.008854e-04
Rlv_13_34 l_13_34 l_13_35 5.008854e-04
Rlh_13_35 l_13_35 l_14_35 5.008854e-04
Rlv_13_35 l_13_35 l_13_36 5.008854e-04
Rlh_13_36 l_13_36 l_14_36 5.008854e-04
Rlv_13_36 l_13_36 l_13_37 5.008854e-04
Rlh_13_37 l_13_37 l_14_37 5.008854e-04
Rlv_13_37 l_13_37 l_13_38 5.008854e-04
Rlh_13_38 l_13_38 l_14_38 5.008854e-04
Rlv_13_38 l_13_38 l_13_39 5.008854e-04
Rlh_13_39 l_13_39 l_14_39 5.008854e-04
Rlv_13_39 l_13_39 l_13_40 5.008854e-04
Rlh_13_40 l_13_40 l_14_40 5.008854e-04
Rlv_13_40 l_13_40 l_13_41 5.008854e-04
Rlh_13_41 l_13_41 l_14_41 5.008854e-04
Rlv_13_41 l_13_41 l_13_42 5.008854e-04
Rlh_13_42 l_13_42 l_14_42 5.008854e-04
Rlv_13_42 l_13_42 l_13_43 5.008854e-04
Rlh_13_43 l_13_43 l_14_43 5.008854e-04
Rlv_13_43 l_13_43 l_13_44 5.008854e-04
Rlh_13_44 l_13_44 l_14_44 5.008854e-04
Rlv_13_44 l_13_44 l_13_45 5.008854e-04
Rlh_13_45 l_13_45 l_14_45 5.008854e-04
Rlv_13_45 l_13_45 l_13_46 5.008854e-04
Rlh_13_46 l_13_46 l_14_46 5.008854e-04
Rlv_13_46 l_13_46 l_13_47 5.008854e-04
Rlh_13_47 l_13_47 l_14_47 5.008854e-04
Rlv_13_47 l_13_47 l_13_48 5.008854e-04
Rlh_13_48 l_13_48 l_14_48 5.008854e-04
Rlv_13_48 l_13_48 l_13_49 5.008854e-04
Rlh_13_49 l_13_49 l_14_49 5.008854e-04
Rlv_13_49 l_13_49 l_13_50 5.008854e-04
Rlh_13_50 l_13_50 l_14_50 5.008854e-04
Rlv_13_50 l_13_50 l_13_51 5.008854e-04
Rlh_13_51 l_13_51 l_14_51 5.008854e-04
Rlv_13_51 l_13_51 l_13_52 5.008854e-04
Rlh_13_52 l_13_52 l_14_52 5.008854e-04
Rlv_13_52 l_13_52 l_13_53 5.008854e-04
Rlh_13_53 l_13_53 l_14_53 5.008854e-04
Rlv_13_53 l_13_53 l_13_54 5.008854e-04
Rlh_13_54 l_13_54 l_14_54 5.008854e-04
Rlv_13_54 l_13_54 l_13_55 5.008854e-04
Rlh_13_55 l_13_55 l_14_55 5.008854e-04
Rlv_13_55 l_13_55 l_13_56 5.008854e-04
Rlh_13_56 l_13_56 l_14_56 5.008854e-04
Rlv_13_56 l_13_56 l_13_57 5.008854e-04
Rlh_13_57 l_13_57 l_14_57 5.008854e-04
Rlv_13_57 l_13_57 l_13_58 5.008854e-04
Rlh_13_58 l_13_58 l_14_58 5.008854e-04
Rlv_13_58 l_13_58 l_13_59 5.008854e-04
Rlh_13_59 l_13_59 l_14_59 5.008854e-04
Rlv_13_59 l_13_59 l_13_60 5.008854e-04
Rlh_13_60 l_13_60 l_14_60 5.008854e-04
Rlv_13_60 l_13_60 l_13_61 5.008854e-04
Rlh_13_61 l_13_61 l_14_61 5.008854e-04
Rlv_13_61 l_13_61 l_13_62 5.008854e-04
Rlh_13_62 l_13_62 l_14_62 5.008854e-04
Rlv_13_62 l_13_62 l_13_63 5.008854e-04
Rlh_13_63 l_13_63 l_14_63 5.008854e-04
Rlv_13_63 l_13_63 l_13_64 5.008854e-04
Rlh_13_64 l_13_64 l_14_64 5.008854e-04
Rlv_13_64 l_13_64 l_13_65 5.008854e-04
Rlh_13_65 l_13_65 l_14_65 5.008854e-04
Rlv_13_65 l_13_65 l_13_66 5.008854e-04
Rlh_13_66 l_13_66 l_14_66 5.008854e-04
Rlv_13_66 l_13_66 l_13_67 5.008854e-04
Rlh_13_67 l_13_67 l_14_67 5.008854e-04
Rlv_13_67 l_13_67 l_13_68 5.008854e-04
Rlh_13_68 l_13_68 l_14_68 5.008854e-04
Rlv_13_68 l_13_68 l_13_69 5.008854e-04
Rlh_13_69 l_13_69 l_14_69 5.008854e-04
Rlv_13_69 l_13_69 l_13_70 5.008854e-04
Rlh_13_70 l_13_70 l_14_70 5.008854e-04
Rlv_13_70 l_13_70 l_13_71 5.008854e-04
Rlh_13_71 l_13_71 l_14_71 5.008854e-04
Rlh_14_0 l_14_0 l_15_0 5.008854e-04
Rlv_14_0 l_14_0 l_14_1 5.008854e-04
Rlh_14_1 l_14_1 l_15_1 5.008854e-04
Rlv_14_1 l_14_1 l_14_2 5.008854e-04
Rlh_14_2 l_14_2 l_15_2 5.008854e-04
Rlv_14_2 l_14_2 l_14_3 5.008854e-04
Rlh_14_3 l_14_3 l_15_3 5.008854e-04
Rlv_14_3 l_14_3 l_14_4 5.008854e-04
Rlh_14_4 l_14_4 l_15_4 5.008854e-04
Rlv_14_4 l_14_4 l_14_5 5.008854e-04
Rlh_14_5 l_14_5 l_15_5 5.008854e-04
Rlv_14_5 l_14_5 l_14_6 5.008854e-04
Rlh_14_6 l_14_6 l_15_6 5.008854e-04
Rlv_14_6 l_14_6 l_14_7 5.008854e-04
Rlh_14_7 l_14_7 l_15_7 5.008854e-04
Rlv_14_7 l_14_7 l_14_8 5.008854e-04
Rlh_14_8 l_14_8 l_15_8 5.008854e-04
Rlv_14_8 l_14_8 l_14_9 5.008854e-04
Rlh_14_9 l_14_9 l_15_9 5.008854e-04
Rlv_14_9 l_14_9 l_14_10 5.008854e-04
Rlh_14_10 l_14_10 l_15_10 5.008854e-04
Rlv_14_10 l_14_10 l_14_11 5.008854e-04
Rlh_14_11 l_14_11 l_15_11 5.008854e-04
Rlv_14_11 l_14_11 l_14_12 5.008854e-04
Rlh_14_12 l_14_12 l_15_12 5.008854e-04
Rlv_14_12 l_14_12 l_14_13 5.008854e-04
Rlh_14_13 l_14_13 l_15_13 5.008854e-04
Rlv_14_13 l_14_13 l_14_14 5.008854e-04
Rlh_14_14 l_14_14 l_15_14 5.008854e-04
Rlv_14_14 l_14_14 l_14_15 5.008854e-04
Rlh_14_15 l_14_15 l_15_15 5.008854e-04
Rlv_14_15 l_14_15 l_14_16 5.008854e-04
Rlh_14_16 l_14_16 l_15_16 5.008854e-04
Rlv_14_16 l_14_16 l_14_17 5.008854e-04
Rlh_14_17 l_14_17 l_15_17 5.008854e-04
Rlv_14_17 l_14_17 l_14_18 5.008854e-04
Rlh_14_18 l_14_18 l_15_18 5.008854e-04
Rlv_14_18 l_14_18 l_14_19 5.008854e-04
Rlh_14_19 l_14_19 l_15_19 5.008854e-04
Rlv_14_19 l_14_19 l_14_20 5.008854e-04
Rlh_14_20 l_14_20 l_15_20 5.008854e-04
Rlv_14_20 l_14_20 l_14_21 5.008854e-04
Rlh_14_21 l_14_21 l_15_21 5.008854e-04
Rlv_14_21 l_14_21 l_14_22 5.008854e-04
Rlh_14_22 l_14_22 l_15_22 5.008854e-04
Rlv_14_22 l_14_22 l_14_23 5.008854e-04
Rlh_14_23 l_14_23 l_15_23 5.008854e-04
Rlv_14_23 l_14_23 l_14_24 5.008854e-04
Rlh_14_24 l_14_24 l_15_24 5.008854e-04
Rlv_14_24 l_14_24 l_14_25 5.008854e-04
Rlh_14_25 l_14_25 l_15_25 5.008854e-04
Rlv_14_25 l_14_25 l_14_26 5.008854e-04
Rlh_14_26 l_14_26 l_15_26 5.008854e-04
Rlv_14_26 l_14_26 l_14_27 5.008854e-04
Rlh_14_27 l_14_27 l_15_27 5.008854e-04
Rlv_14_27 l_14_27 l_14_28 5.008854e-04
Rlh_14_28 l_14_28 l_15_28 5.008854e-04
Rlv_14_28 l_14_28 l_14_29 5.008854e-04
Rlh_14_29 l_14_29 l_15_29 5.008854e-04
Rlv_14_29 l_14_29 l_14_30 5.008854e-04
Rlh_14_30 l_14_30 l_15_30 5.008854e-04
Rlv_14_30 l_14_30 l_14_31 5.008854e-04
Rlh_14_31 l_14_31 l_15_31 5.008854e-04
Rlv_14_31 l_14_31 l_14_32 5.008854e-04
Rlh_14_32 l_14_32 l_15_32 5.008854e-04
Rlv_14_32 l_14_32 l_14_33 5.008854e-04
Rlh_14_33 l_14_33 l_15_33 5.008854e-04
Rlv_14_33 l_14_33 l_14_34 5.008854e-04
Rlh_14_34 l_14_34 l_15_34 5.008854e-04
Rlv_14_34 l_14_34 l_14_35 5.008854e-04
Rlh_14_35 l_14_35 l_15_35 5.008854e-04
Rlv_14_35 l_14_35 l_14_36 5.008854e-04
Rlh_14_36 l_14_36 l_15_36 5.008854e-04
Rlv_14_36 l_14_36 l_14_37 5.008854e-04
Rlh_14_37 l_14_37 l_15_37 5.008854e-04
Rlv_14_37 l_14_37 l_14_38 5.008854e-04
Rlh_14_38 l_14_38 l_15_38 5.008854e-04
Rlv_14_38 l_14_38 l_14_39 5.008854e-04
Rlh_14_39 l_14_39 l_15_39 5.008854e-04
Rlv_14_39 l_14_39 l_14_40 5.008854e-04
Rlh_14_40 l_14_40 l_15_40 5.008854e-04
Rlv_14_40 l_14_40 l_14_41 5.008854e-04
Rlh_14_41 l_14_41 l_15_41 5.008854e-04
Rlv_14_41 l_14_41 l_14_42 5.008854e-04
Rlh_14_42 l_14_42 l_15_42 5.008854e-04
Rlv_14_42 l_14_42 l_14_43 5.008854e-04
Rlh_14_43 l_14_43 l_15_43 5.008854e-04
Rlv_14_43 l_14_43 l_14_44 5.008854e-04
Rlh_14_44 l_14_44 l_15_44 5.008854e-04
Rlv_14_44 l_14_44 l_14_45 5.008854e-04
Rlh_14_45 l_14_45 l_15_45 5.008854e-04
Rlv_14_45 l_14_45 l_14_46 5.008854e-04
Rlh_14_46 l_14_46 l_15_46 5.008854e-04
Rlv_14_46 l_14_46 l_14_47 5.008854e-04
Rlh_14_47 l_14_47 l_15_47 5.008854e-04
Rlv_14_47 l_14_47 l_14_48 5.008854e-04
Rlh_14_48 l_14_48 l_15_48 5.008854e-04
Rlv_14_48 l_14_48 l_14_49 5.008854e-04
Rlh_14_49 l_14_49 l_15_49 5.008854e-04
Rlv_14_49 l_14_49 l_14_50 5.008854e-04
Rlh_14_50 l_14_50 l_15_50 5.008854e-04
Rlv_14_50 l_14_50 l_14_51 5.008854e-04
Rlh_14_51 l_14_51 l_15_51 5.008854e-04
Rlv_14_51 l_14_51 l_14_52 5.008854e-04
Rlh_14_52 l_14_52 l_15_52 5.008854e-04
Rlv_14_52 l_14_52 l_14_53 5.008854e-04
Rlh_14_53 l_14_53 l_15_53 5.008854e-04
Rlv_14_53 l_14_53 l_14_54 5.008854e-04
Rlh_14_54 l_14_54 l_15_54 5.008854e-04
Rlv_14_54 l_14_54 l_14_55 5.008854e-04
Rlh_14_55 l_14_55 l_15_55 5.008854e-04
Rlv_14_55 l_14_55 l_14_56 5.008854e-04
Rlh_14_56 l_14_56 l_15_56 5.008854e-04
Rlv_14_56 l_14_56 l_14_57 5.008854e-04
Rlh_14_57 l_14_57 l_15_57 5.008854e-04
Rlv_14_57 l_14_57 l_14_58 5.008854e-04
Rlh_14_58 l_14_58 l_15_58 5.008854e-04
Rlv_14_58 l_14_58 l_14_59 5.008854e-04
Rlh_14_59 l_14_59 l_15_59 5.008854e-04
Rlv_14_59 l_14_59 l_14_60 5.008854e-04
Rlh_14_60 l_14_60 l_15_60 5.008854e-04
Rlv_14_60 l_14_60 l_14_61 5.008854e-04
Rlh_14_61 l_14_61 l_15_61 5.008854e-04
Rlv_14_61 l_14_61 l_14_62 5.008854e-04
Rlh_14_62 l_14_62 l_15_62 5.008854e-04
Rlv_14_62 l_14_62 l_14_63 5.008854e-04
Rlh_14_63 l_14_63 l_15_63 5.008854e-04
Rlv_14_63 l_14_63 l_14_64 5.008854e-04
Rlh_14_64 l_14_64 l_15_64 5.008854e-04
Rlv_14_64 l_14_64 l_14_65 5.008854e-04
Rlh_14_65 l_14_65 l_15_65 5.008854e-04
Rlv_14_65 l_14_65 l_14_66 5.008854e-04
Rlh_14_66 l_14_66 l_15_66 5.008854e-04
Rlv_14_66 l_14_66 l_14_67 5.008854e-04
Rlh_14_67 l_14_67 l_15_67 5.008854e-04
Rlv_14_67 l_14_67 l_14_68 5.008854e-04
Rlh_14_68 l_14_68 l_15_68 5.008854e-04
Rlv_14_68 l_14_68 l_14_69 5.008854e-04
Rlh_14_69 l_14_69 l_15_69 5.008854e-04
Rlv_14_69 l_14_69 l_14_70 5.008854e-04
Rlh_14_70 l_14_70 l_15_70 5.008854e-04
Rlv_14_70 l_14_70 l_14_71 5.008854e-04
Rlh_14_71 l_14_71 l_15_71 5.008854e-04
Rlh_15_0 l_15_0 l_16_0 5.008854e-04
Rlv_15_0 l_15_0 l_15_1 5.008854e-04
Rlh_15_1 l_15_1 l_16_1 5.008854e-04
Rlv_15_1 l_15_1 l_15_2 5.008854e-04
Rlh_15_2 l_15_2 l_16_2 5.008854e-04
Rlv_15_2 l_15_2 l_15_3 5.008854e-04
Rlh_15_3 l_15_3 l_16_3 5.008854e-04
Rlv_15_3 l_15_3 l_15_4 5.008854e-04
Rlh_15_4 l_15_4 l_16_4 5.008854e-04
Rlv_15_4 l_15_4 l_15_5 5.008854e-04
Rlh_15_5 l_15_5 l_16_5 5.008854e-04
Rlv_15_5 l_15_5 l_15_6 5.008854e-04
Rlh_15_6 l_15_6 l_16_6 5.008854e-04
Rlv_15_6 l_15_6 l_15_7 5.008854e-04
Rlh_15_7 l_15_7 l_16_7 5.008854e-04
Rlv_15_7 l_15_7 l_15_8 5.008854e-04
Rlh_15_8 l_15_8 l_16_8 5.008854e-04
Rlv_15_8 l_15_8 l_15_9 5.008854e-04
Rlh_15_9 l_15_9 l_16_9 5.008854e-04
Rlv_15_9 l_15_9 l_15_10 5.008854e-04
Rlh_15_10 l_15_10 l_16_10 5.008854e-04
Rlv_15_10 l_15_10 l_15_11 5.008854e-04
Rlh_15_11 l_15_11 l_16_11 5.008854e-04
Rlv_15_11 l_15_11 l_15_12 5.008854e-04
Rlh_15_12 l_15_12 l_16_12 5.008854e-04
Rlv_15_12 l_15_12 l_15_13 5.008854e-04
Rlh_15_13 l_15_13 l_16_13 5.008854e-04
Rlv_15_13 l_15_13 l_15_14 5.008854e-04
Rlh_15_14 l_15_14 l_16_14 5.008854e-04
Rlv_15_14 l_15_14 l_15_15 5.008854e-04
Rlh_15_15 l_15_15 l_16_15 5.008854e-04
Rlv_15_15 l_15_15 l_15_16 5.008854e-04
Rlh_15_16 l_15_16 l_16_16 5.008854e-04
Rlv_15_16 l_15_16 l_15_17 5.008854e-04
Rlh_15_17 l_15_17 l_16_17 5.008854e-04
Rlv_15_17 l_15_17 l_15_18 5.008854e-04
Rlh_15_18 l_15_18 l_16_18 5.008854e-04
Rlv_15_18 l_15_18 l_15_19 5.008854e-04
Rlh_15_19 l_15_19 l_16_19 5.008854e-04
Rlv_15_19 l_15_19 l_15_20 5.008854e-04
Rlh_15_20 l_15_20 l_16_20 5.008854e-04
Rlv_15_20 l_15_20 l_15_21 5.008854e-04
Rlh_15_21 l_15_21 l_16_21 5.008854e-04
Rlv_15_21 l_15_21 l_15_22 5.008854e-04
Rlh_15_22 l_15_22 l_16_22 5.008854e-04
Rlv_15_22 l_15_22 l_15_23 5.008854e-04
Rlh_15_23 l_15_23 l_16_23 5.008854e-04
Rlv_15_23 l_15_23 l_15_24 5.008854e-04
Rlh_15_24 l_15_24 l_16_24 5.008854e-04
Rlv_15_24 l_15_24 l_15_25 5.008854e-04
Rlh_15_25 l_15_25 l_16_25 5.008854e-04
Rlv_15_25 l_15_25 l_15_26 5.008854e-04
Rlh_15_26 l_15_26 l_16_26 5.008854e-04
Rlv_15_26 l_15_26 l_15_27 5.008854e-04
Rlh_15_27 l_15_27 l_16_27 5.008854e-04
Rlv_15_27 l_15_27 l_15_28 5.008854e-04
Rlh_15_28 l_15_28 l_16_28 5.008854e-04
Rlv_15_28 l_15_28 l_15_29 5.008854e-04
Rlh_15_29 l_15_29 l_16_29 5.008854e-04
Rlv_15_29 l_15_29 l_15_30 5.008854e-04
Rlh_15_30 l_15_30 l_16_30 5.008854e-04
Rlv_15_30 l_15_30 l_15_31 5.008854e-04
Rlh_15_31 l_15_31 l_16_31 5.008854e-04
Rlv_15_31 l_15_31 l_15_32 5.008854e-04
Rlh_15_32 l_15_32 l_16_32 5.008854e-04
Rlv_15_32 l_15_32 l_15_33 5.008854e-04
Rlh_15_33 l_15_33 l_16_33 5.008854e-04
Rlv_15_33 l_15_33 l_15_34 5.008854e-04
Rlh_15_34 l_15_34 l_16_34 5.008854e-04
Rlv_15_34 l_15_34 l_15_35 5.008854e-04
Rlh_15_35 l_15_35 l_16_35 5.008854e-04
Rlv_15_35 l_15_35 l_15_36 5.008854e-04
Rlh_15_36 l_15_36 l_16_36 5.008854e-04
Rlv_15_36 l_15_36 l_15_37 5.008854e-04
Rlh_15_37 l_15_37 l_16_37 5.008854e-04
Rlv_15_37 l_15_37 l_15_38 5.008854e-04
Rlh_15_38 l_15_38 l_16_38 5.008854e-04
Rlv_15_38 l_15_38 l_15_39 5.008854e-04
Rlh_15_39 l_15_39 l_16_39 5.008854e-04
Rlv_15_39 l_15_39 l_15_40 5.008854e-04
Rlh_15_40 l_15_40 l_16_40 5.008854e-04
Rlv_15_40 l_15_40 l_15_41 5.008854e-04
Rlh_15_41 l_15_41 l_16_41 5.008854e-04
Rlv_15_41 l_15_41 l_15_42 5.008854e-04
Rlh_15_42 l_15_42 l_16_42 5.008854e-04
Rlv_15_42 l_15_42 l_15_43 5.008854e-04
Rlh_15_43 l_15_43 l_16_43 5.008854e-04
Rlv_15_43 l_15_43 l_15_44 5.008854e-04
Rlh_15_44 l_15_44 l_16_44 5.008854e-04
Rlv_15_44 l_15_44 l_15_45 5.008854e-04
Rlh_15_45 l_15_45 l_16_45 5.008854e-04
Rlv_15_45 l_15_45 l_15_46 5.008854e-04
Rlh_15_46 l_15_46 l_16_46 5.008854e-04
Rlv_15_46 l_15_46 l_15_47 5.008854e-04
Rlh_15_47 l_15_47 l_16_47 5.008854e-04
Rlv_15_47 l_15_47 l_15_48 5.008854e-04
Rlh_15_48 l_15_48 l_16_48 5.008854e-04
Rlv_15_48 l_15_48 l_15_49 5.008854e-04
Rlh_15_49 l_15_49 l_16_49 5.008854e-04
Rlv_15_49 l_15_49 l_15_50 5.008854e-04
Rlh_15_50 l_15_50 l_16_50 5.008854e-04
Rlv_15_50 l_15_50 l_15_51 5.008854e-04
Rlh_15_51 l_15_51 l_16_51 5.008854e-04
Rlv_15_51 l_15_51 l_15_52 5.008854e-04
Rlh_15_52 l_15_52 l_16_52 5.008854e-04
Rlv_15_52 l_15_52 l_15_53 5.008854e-04
Rlh_15_53 l_15_53 l_16_53 5.008854e-04
Rlv_15_53 l_15_53 l_15_54 5.008854e-04
Rlh_15_54 l_15_54 l_16_54 5.008854e-04
Rlv_15_54 l_15_54 l_15_55 5.008854e-04
Rlh_15_55 l_15_55 l_16_55 5.008854e-04
Rlv_15_55 l_15_55 l_15_56 5.008854e-04
Rlh_15_56 l_15_56 l_16_56 5.008854e-04
Rlv_15_56 l_15_56 l_15_57 5.008854e-04
Rlh_15_57 l_15_57 l_16_57 5.008854e-04
Rlv_15_57 l_15_57 l_15_58 5.008854e-04
Rlh_15_58 l_15_58 l_16_58 5.008854e-04
Rlv_15_58 l_15_58 l_15_59 5.008854e-04
Rlh_15_59 l_15_59 l_16_59 5.008854e-04
Rlv_15_59 l_15_59 l_15_60 5.008854e-04
Rlh_15_60 l_15_60 l_16_60 5.008854e-04
Rlv_15_60 l_15_60 l_15_61 5.008854e-04
Rlh_15_61 l_15_61 l_16_61 5.008854e-04
Rlv_15_61 l_15_61 l_15_62 5.008854e-04
Rlh_15_62 l_15_62 l_16_62 5.008854e-04
Rlv_15_62 l_15_62 l_15_63 5.008854e-04
Rlh_15_63 l_15_63 l_16_63 5.008854e-04
Rlv_15_63 l_15_63 l_15_64 5.008854e-04
Rlh_15_64 l_15_64 l_16_64 5.008854e-04
Rlv_15_64 l_15_64 l_15_65 5.008854e-04
Rlh_15_65 l_15_65 l_16_65 5.008854e-04
Rlv_15_65 l_15_65 l_15_66 5.008854e-04
Rlh_15_66 l_15_66 l_16_66 5.008854e-04
Rlv_15_66 l_15_66 l_15_67 5.008854e-04
Rlh_15_67 l_15_67 l_16_67 5.008854e-04
Rlv_15_67 l_15_67 l_15_68 5.008854e-04
Rlh_15_68 l_15_68 l_16_68 5.008854e-04
Rlv_15_68 l_15_68 l_15_69 5.008854e-04
Rlh_15_69 l_15_69 l_16_69 5.008854e-04
Rlv_15_69 l_15_69 l_15_70 5.008854e-04
Rlh_15_70 l_15_70 l_16_70 5.008854e-04
Rlv_15_70 l_15_70 l_15_71 5.008854e-04
Rlh_15_71 l_15_71 l_16_71 5.008854e-04
Rlh_16_0 l_16_0 l_17_0 5.008854e-04
Rlv_16_0 l_16_0 l_16_1 5.008854e-04
Rlh_16_1 l_16_1 l_17_1 5.008854e-04
Rlv_16_1 l_16_1 l_16_2 5.008854e-04
Rlh_16_2 l_16_2 l_17_2 5.008854e-04
Rlv_16_2 l_16_2 l_16_3 5.008854e-04
Rlh_16_3 l_16_3 l_17_3 5.008854e-04
Rlv_16_3 l_16_3 l_16_4 5.008854e-04
Rlh_16_4 l_16_4 l_17_4 5.008854e-04
Rlv_16_4 l_16_4 l_16_5 5.008854e-04
Rlh_16_5 l_16_5 l_17_5 5.008854e-04
Rlv_16_5 l_16_5 l_16_6 5.008854e-04
Rlh_16_6 l_16_6 l_17_6 5.008854e-04
Rlv_16_6 l_16_6 l_16_7 5.008854e-04
Rlh_16_7 l_16_7 l_17_7 5.008854e-04
Rlv_16_7 l_16_7 l_16_8 5.008854e-04
Rlh_16_8 l_16_8 l_17_8 5.008854e-04
Rlv_16_8 l_16_8 l_16_9 5.008854e-04
Rlh_16_9 l_16_9 l_17_9 5.008854e-04
Rlv_16_9 l_16_9 l_16_10 5.008854e-04
Rlh_16_10 l_16_10 l_17_10 5.008854e-04
Rlv_16_10 l_16_10 l_16_11 5.008854e-04
Rlh_16_11 l_16_11 l_17_11 5.008854e-04
Rlv_16_11 l_16_11 l_16_12 5.008854e-04
Rlh_16_12 l_16_12 l_17_12 5.008854e-04
Rlv_16_12 l_16_12 l_16_13 5.008854e-04
Rlh_16_13 l_16_13 l_17_13 5.008854e-04
Rlv_16_13 l_16_13 l_16_14 5.008854e-04
Rlh_16_14 l_16_14 l_17_14 5.008854e-04
Rlv_16_14 l_16_14 l_16_15 5.008854e-04
Rlh_16_15 l_16_15 l_17_15 5.008854e-04
Rlv_16_15 l_16_15 l_16_16 5.008854e-04
Rlh_16_16 l_16_16 l_17_16 5.008854e-04
Rlv_16_16 l_16_16 l_16_17 5.008854e-04
Rlh_16_17 l_16_17 l_17_17 5.008854e-04
Rlv_16_17 l_16_17 l_16_18 5.008854e-04
Rlh_16_18 l_16_18 l_17_18 5.008854e-04
Rlv_16_18 l_16_18 l_16_19 5.008854e-04
Rlh_16_19 l_16_19 l_17_19 5.008854e-04
Rlv_16_19 l_16_19 l_16_20 5.008854e-04
Rlh_16_20 l_16_20 l_17_20 5.008854e-04
Rlv_16_20 l_16_20 l_16_21 5.008854e-04
Rlh_16_21 l_16_21 l_17_21 5.008854e-04
Rlv_16_21 l_16_21 l_16_22 5.008854e-04
Rlh_16_22 l_16_22 l_17_22 5.008854e-04
Rlv_16_22 l_16_22 l_16_23 5.008854e-04
Rlh_16_23 l_16_23 l_17_23 5.008854e-04
Rlv_16_23 l_16_23 l_16_24 5.008854e-04
Rlh_16_24 l_16_24 l_17_24 5.008854e-04
Rlv_16_24 l_16_24 l_16_25 5.008854e-04
Rlh_16_25 l_16_25 l_17_25 5.008854e-04
Rlv_16_25 l_16_25 l_16_26 5.008854e-04
Rlh_16_26 l_16_26 l_17_26 5.008854e-04
Rlv_16_26 l_16_26 l_16_27 5.008854e-04
Rlh_16_27 l_16_27 l_17_27 5.008854e-04
Rlv_16_27 l_16_27 l_16_28 5.008854e-04
Rlh_16_28 l_16_28 l_17_28 5.008854e-04
Rlv_16_28 l_16_28 l_16_29 5.008854e-04
Rlh_16_29 l_16_29 l_17_29 5.008854e-04
Rlv_16_29 l_16_29 l_16_30 5.008854e-04
Rlh_16_30 l_16_30 l_17_30 5.008854e-04
Rlv_16_30 l_16_30 l_16_31 5.008854e-04
Rlh_16_31 l_16_31 l_17_31 5.008854e-04
Rlv_16_31 l_16_31 l_16_32 5.008854e-04
Rlh_16_32 l_16_32 l_17_32 5.008854e-04
Rlv_16_32 l_16_32 l_16_33 5.008854e-04
Rlh_16_33 l_16_33 l_17_33 5.008854e-04
Rlv_16_33 l_16_33 l_16_34 5.008854e-04
Rlh_16_34 l_16_34 l_17_34 5.008854e-04
Rlv_16_34 l_16_34 l_16_35 5.008854e-04
Rlh_16_35 l_16_35 l_17_35 5.008854e-04
Rlv_16_35 l_16_35 l_16_36 5.008854e-04
Rlh_16_36 l_16_36 l_17_36 5.008854e-04
Rlv_16_36 l_16_36 l_16_37 5.008854e-04
Rlh_16_37 l_16_37 l_17_37 5.008854e-04
Rlv_16_37 l_16_37 l_16_38 5.008854e-04
Rlh_16_38 l_16_38 l_17_38 5.008854e-04
Rlv_16_38 l_16_38 l_16_39 5.008854e-04
Rlh_16_39 l_16_39 l_17_39 5.008854e-04
Rlv_16_39 l_16_39 l_16_40 5.008854e-04
Rlh_16_40 l_16_40 l_17_40 5.008854e-04
Rlv_16_40 l_16_40 l_16_41 5.008854e-04
Rlh_16_41 l_16_41 l_17_41 5.008854e-04
Rlv_16_41 l_16_41 l_16_42 5.008854e-04
Rlh_16_42 l_16_42 l_17_42 5.008854e-04
Rlv_16_42 l_16_42 l_16_43 5.008854e-04
Rlh_16_43 l_16_43 l_17_43 5.008854e-04
Rlv_16_43 l_16_43 l_16_44 5.008854e-04
Rlh_16_44 l_16_44 l_17_44 5.008854e-04
Rlv_16_44 l_16_44 l_16_45 5.008854e-04
Rlh_16_45 l_16_45 l_17_45 5.008854e-04
Rlv_16_45 l_16_45 l_16_46 5.008854e-04
Rlh_16_46 l_16_46 l_17_46 5.008854e-04
Rlv_16_46 l_16_46 l_16_47 5.008854e-04
Rlh_16_47 l_16_47 l_17_47 5.008854e-04
Rlv_16_47 l_16_47 l_16_48 5.008854e-04
Rlh_16_48 l_16_48 l_17_48 5.008854e-04
Rlv_16_48 l_16_48 l_16_49 5.008854e-04
Rlh_16_49 l_16_49 l_17_49 5.008854e-04
Rlv_16_49 l_16_49 l_16_50 5.008854e-04
Rlh_16_50 l_16_50 l_17_50 5.008854e-04
Rlv_16_50 l_16_50 l_16_51 5.008854e-04
Rlh_16_51 l_16_51 l_17_51 5.008854e-04
Rlv_16_51 l_16_51 l_16_52 5.008854e-04
Rlh_16_52 l_16_52 l_17_52 5.008854e-04
Rlv_16_52 l_16_52 l_16_53 5.008854e-04
Rlh_16_53 l_16_53 l_17_53 5.008854e-04
Rlv_16_53 l_16_53 l_16_54 5.008854e-04
Rlh_16_54 l_16_54 l_17_54 5.008854e-04
Rlv_16_54 l_16_54 l_16_55 5.008854e-04
Rlh_16_55 l_16_55 l_17_55 5.008854e-04
Rlv_16_55 l_16_55 l_16_56 5.008854e-04
Rlh_16_56 l_16_56 l_17_56 5.008854e-04
Rlv_16_56 l_16_56 l_16_57 5.008854e-04
Rlh_16_57 l_16_57 l_17_57 5.008854e-04
Rlv_16_57 l_16_57 l_16_58 5.008854e-04
Rlh_16_58 l_16_58 l_17_58 5.008854e-04
Rlv_16_58 l_16_58 l_16_59 5.008854e-04
Rlh_16_59 l_16_59 l_17_59 5.008854e-04
Rlv_16_59 l_16_59 l_16_60 5.008854e-04
Rlh_16_60 l_16_60 l_17_60 5.008854e-04
Rlv_16_60 l_16_60 l_16_61 5.008854e-04
Rlh_16_61 l_16_61 l_17_61 5.008854e-04
Rlv_16_61 l_16_61 l_16_62 5.008854e-04
Rlh_16_62 l_16_62 l_17_62 5.008854e-04
Rlv_16_62 l_16_62 l_16_63 5.008854e-04
Rlh_16_63 l_16_63 l_17_63 5.008854e-04
Rlv_16_63 l_16_63 l_16_64 5.008854e-04
Rlh_16_64 l_16_64 l_17_64 5.008854e-04
Rlv_16_64 l_16_64 l_16_65 5.008854e-04
Rlh_16_65 l_16_65 l_17_65 5.008854e-04
Rlv_16_65 l_16_65 l_16_66 5.008854e-04
Rlh_16_66 l_16_66 l_17_66 5.008854e-04
Rlv_16_66 l_16_66 l_16_67 5.008854e-04
Rlh_16_67 l_16_67 l_17_67 5.008854e-04
Rlv_16_67 l_16_67 l_16_68 5.008854e-04
Rlh_16_68 l_16_68 l_17_68 5.008854e-04
Rlv_16_68 l_16_68 l_16_69 5.008854e-04
Rlh_16_69 l_16_69 l_17_69 5.008854e-04
Rlv_16_69 l_16_69 l_16_70 5.008854e-04
Rlh_16_70 l_16_70 l_17_70 5.008854e-04
Rlv_16_70 l_16_70 l_16_71 5.008854e-04
Rlh_16_71 l_16_71 l_17_71 5.008854e-04
Rlh_17_0 l_17_0 l_18_0 5.008854e-04
Rlv_17_0 l_17_0 l_17_1 5.008854e-04
Rlh_17_1 l_17_1 l_18_1 5.008854e-04
Rlv_17_1 l_17_1 l_17_2 5.008854e-04
Rlh_17_2 l_17_2 l_18_2 5.008854e-04
Rlv_17_2 l_17_2 l_17_3 5.008854e-04
Rlh_17_3 l_17_3 l_18_3 5.008854e-04
Rlv_17_3 l_17_3 l_17_4 5.008854e-04
Rlh_17_4 l_17_4 l_18_4 5.008854e-04
Rlv_17_4 l_17_4 l_17_5 5.008854e-04
Rlh_17_5 l_17_5 l_18_5 5.008854e-04
Rlv_17_5 l_17_5 l_17_6 5.008854e-04
Rlh_17_6 l_17_6 l_18_6 5.008854e-04
Rlv_17_6 l_17_6 l_17_7 5.008854e-04
Rlh_17_7 l_17_7 l_18_7 5.008854e-04
Rlv_17_7 l_17_7 l_17_8 5.008854e-04
Rlh_17_8 l_17_8 l_18_8 5.008854e-04
Rlv_17_8 l_17_8 l_17_9 5.008854e-04
Rlh_17_9 l_17_9 l_18_9 5.008854e-04
Rlv_17_9 l_17_9 l_17_10 5.008854e-04
Rlh_17_10 l_17_10 l_18_10 5.008854e-04
Rlv_17_10 l_17_10 l_17_11 5.008854e-04
Rlh_17_11 l_17_11 l_18_11 5.008854e-04
Rlv_17_11 l_17_11 l_17_12 5.008854e-04
Rlh_17_12 l_17_12 l_18_12 5.008854e-04
Rlv_17_12 l_17_12 l_17_13 5.008854e-04
Rlh_17_13 l_17_13 l_18_13 5.008854e-04
Rlv_17_13 l_17_13 l_17_14 5.008854e-04
Rlh_17_14 l_17_14 l_18_14 5.008854e-04
Rlv_17_14 l_17_14 l_17_15 5.008854e-04
Rlh_17_15 l_17_15 l_18_15 5.008854e-04
Rlv_17_15 l_17_15 l_17_16 5.008854e-04
Rlh_17_16 l_17_16 l_18_16 5.008854e-04
Rlv_17_16 l_17_16 l_17_17 5.008854e-04
Rlh_17_17 l_17_17 l_18_17 5.008854e-04
Rlv_17_17 l_17_17 l_17_18 5.008854e-04
Rlh_17_18 l_17_18 l_18_18 5.008854e-04
Rlv_17_18 l_17_18 l_17_19 5.008854e-04
Rlh_17_19 l_17_19 l_18_19 5.008854e-04
Rlv_17_19 l_17_19 l_17_20 5.008854e-04
Rlh_17_20 l_17_20 l_18_20 5.008854e-04
Rlv_17_20 l_17_20 l_17_21 5.008854e-04
Rlh_17_21 l_17_21 l_18_21 5.008854e-04
Rlv_17_21 l_17_21 l_17_22 5.008854e-04
Rlh_17_22 l_17_22 l_18_22 5.008854e-04
Rlv_17_22 l_17_22 l_17_23 5.008854e-04
Rlh_17_23 l_17_23 l_18_23 5.008854e-04
Rlv_17_23 l_17_23 l_17_24 5.008854e-04
Rlh_17_24 l_17_24 l_18_24 5.008854e-04
Rlv_17_24 l_17_24 l_17_25 5.008854e-04
Rlh_17_25 l_17_25 l_18_25 5.008854e-04
Rlv_17_25 l_17_25 l_17_26 5.008854e-04
Rlh_17_26 l_17_26 l_18_26 5.008854e-04
Rlv_17_26 l_17_26 l_17_27 5.008854e-04
Rlh_17_27 l_17_27 l_18_27 5.008854e-04
Rlv_17_27 l_17_27 l_17_28 5.008854e-04
Rlh_17_28 l_17_28 l_18_28 5.008854e-04
Rlv_17_28 l_17_28 l_17_29 5.008854e-04
Rlh_17_29 l_17_29 l_18_29 5.008854e-04
Rlv_17_29 l_17_29 l_17_30 5.008854e-04
Rlh_17_30 l_17_30 l_18_30 5.008854e-04
Rlv_17_30 l_17_30 l_17_31 5.008854e-04
Rlh_17_31 l_17_31 l_18_31 5.008854e-04
Rlv_17_31 l_17_31 l_17_32 5.008854e-04
Rlh_17_32 l_17_32 l_18_32 5.008854e-04
Rlv_17_32 l_17_32 l_17_33 5.008854e-04
Rlh_17_33 l_17_33 l_18_33 5.008854e-04
Rlv_17_33 l_17_33 l_17_34 5.008854e-04
Rlh_17_34 l_17_34 l_18_34 5.008854e-04
Rlv_17_34 l_17_34 l_17_35 5.008854e-04
Rlh_17_35 l_17_35 l_18_35 5.008854e-04
Rlv_17_35 l_17_35 l_17_36 5.008854e-04
Rlh_17_36 l_17_36 l_18_36 5.008854e-04
Rlv_17_36 l_17_36 l_17_37 5.008854e-04
Rlh_17_37 l_17_37 l_18_37 5.008854e-04
Rlv_17_37 l_17_37 l_17_38 5.008854e-04
Rlh_17_38 l_17_38 l_18_38 5.008854e-04
Rlv_17_38 l_17_38 l_17_39 5.008854e-04
Rlh_17_39 l_17_39 l_18_39 5.008854e-04
Rlv_17_39 l_17_39 l_17_40 5.008854e-04
Rlh_17_40 l_17_40 l_18_40 5.008854e-04
Rlv_17_40 l_17_40 l_17_41 5.008854e-04
Rlh_17_41 l_17_41 l_18_41 5.008854e-04
Rlv_17_41 l_17_41 l_17_42 5.008854e-04
Rlh_17_42 l_17_42 l_18_42 5.008854e-04
Rlv_17_42 l_17_42 l_17_43 5.008854e-04
Rlh_17_43 l_17_43 l_18_43 5.008854e-04
Rlv_17_43 l_17_43 l_17_44 5.008854e-04
Rlh_17_44 l_17_44 l_18_44 5.008854e-04
Rlv_17_44 l_17_44 l_17_45 5.008854e-04
Rlh_17_45 l_17_45 l_18_45 5.008854e-04
Rlv_17_45 l_17_45 l_17_46 5.008854e-04
Rlh_17_46 l_17_46 l_18_46 5.008854e-04
Rlv_17_46 l_17_46 l_17_47 5.008854e-04
Rlh_17_47 l_17_47 l_18_47 5.008854e-04
Rlv_17_47 l_17_47 l_17_48 5.008854e-04
Rlh_17_48 l_17_48 l_18_48 5.008854e-04
Rlv_17_48 l_17_48 l_17_49 5.008854e-04
Rlh_17_49 l_17_49 l_18_49 5.008854e-04
Rlv_17_49 l_17_49 l_17_50 5.008854e-04
Rlh_17_50 l_17_50 l_18_50 5.008854e-04
Rlv_17_50 l_17_50 l_17_51 5.008854e-04
Rlh_17_51 l_17_51 l_18_51 5.008854e-04
Rlv_17_51 l_17_51 l_17_52 5.008854e-04
Rlh_17_52 l_17_52 l_18_52 5.008854e-04
Rlv_17_52 l_17_52 l_17_53 5.008854e-04
Rlh_17_53 l_17_53 l_18_53 5.008854e-04
Rlv_17_53 l_17_53 l_17_54 5.008854e-04
Rlh_17_54 l_17_54 l_18_54 5.008854e-04
Rlv_17_54 l_17_54 l_17_55 5.008854e-04
Rlh_17_55 l_17_55 l_18_55 5.008854e-04
Rlv_17_55 l_17_55 l_17_56 5.008854e-04
Rlh_17_56 l_17_56 l_18_56 5.008854e-04
Rlv_17_56 l_17_56 l_17_57 5.008854e-04
Rlh_17_57 l_17_57 l_18_57 5.008854e-04
Rlv_17_57 l_17_57 l_17_58 5.008854e-04
Rlh_17_58 l_17_58 l_18_58 5.008854e-04
Rlv_17_58 l_17_58 l_17_59 5.008854e-04
Rlh_17_59 l_17_59 l_18_59 5.008854e-04
Rlv_17_59 l_17_59 l_17_60 5.008854e-04
Rlh_17_60 l_17_60 l_18_60 5.008854e-04
Rlv_17_60 l_17_60 l_17_61 5.008854e-04
Rlh_17_61 l_17_61 l_18_61 5.008854e-04
Rlv_17_61 l_17_61 l_17_62 5.008854e-04
Rlh_17_62 l_17_62 l_18_62 5.008854e-04
Rlv_17_62 l_17_62 l_17_63 5.008854e-04
Rlh_17_63 l_17_63 l_18_63 5.008854e-04
Rlv_17_63 l_17_63 l_17_64 5.008854e-04
Rlh_17_64 l_17_64 l_18_64 5.008854e-04
Rlv_17_64 l_17_64 l_17_65 5.008854e-04
Rlh_17_65 l_17_65 l_18_65 5.008854e-04
Rlv_17_65 l_17_65 l_17_66 5.008854e-04
Rlh_17_66 l_17_66 l_18_66 5.008854e-04
Rlv_17_66 l_17_66 l_17_67 5.008854e-04
Rlh_17_67 l_17_67 l_18_67 5.008854e-04
Rlv_17_67 l_17_67 l_17_68 5.008854e-04
Rlh_17_68 l_17_68 l_18_68 5.008854e-04
Rlv_17_68 l_17_68 l_17_69 5.008854e-04
Rlh_17_69 l_17_69 l_18_69 5.008854e-04
Rlv_17_69 l_17_69 l_17_70 5.008854e-04
Rlh_17_70 l_17_70 l_18_70 5.008854e-04
Rlv_17_70 l_17_70 l_17_71 5.008854e-04
Rlh_17_71 l_17_71 l_18_71 5.008854e-04
Rlh_18_0 l_18_0 l_19_0 5.008854e-04
Rlv_18_0 l_18_0 l_18_1 5.008854e-04
Rlh_18_1 l_18_1 l_19_1 5.008854e-04
Rlv_18_1 l_18_1 l_18_2 5.008854e-04
Rlh_18_2 l_18_2 l_19_2 5.008854e-04
Rlv_18_2 l_18_2 l_18_3 5.008854e-04
Rlh_18_3 l_18_3 l_19_3 5.008854e-04
Rlv_18_3 l_18_3 l_18_4 5.008854e-04
Rlh_18_4 l_18_4 l_19_4 5.008854e-04
Rlv_18_4 l_18_4 l_18_5 5.008854e-04
Rlh_18_5 l_18_5 l_19_5 5.008854e-04
Rlv_18_5 l_18_5 l_18_6 5.008854e-04
Rlh_18_6 l_18_6 l_19_6 5.008854e-04
Rlv_18_6 l_18_6 l_18_7 5.008854e-04
Rlh_18_7 l_18_7 l_19_7 5.008854e-04
Rlv_18_7 l_18_7 l_18_8 5.008854e-04
Rlh_18_8 l_18_8 l_19_8 5.008854e-04
Rlv_18_8 l_18_8 l_18_9 5.008854e-04
Rlh_18_9 l_18_9 l_19_9 5.008854e-04
Rlv_18_9 l_18_9 l_18_10 5.008854e-04
Rlh_18_10 l_18_10 l_19_10 5.008854e-04
Rlv_18_10 l_18_10 l_18_11 5.008854e-04
Rlh_18_11 l_18_11 l_19_11 5.008854e-04
Rlv_18_11 l_18_11 l_18_12 5.008854e-04
Rlh_18_12 l_18_12 l_19_12 5.008854e-04
Rlv_18_12 l_18_12 l_18_13 5.008854e-04
Rlh_18_13 l_18_13 l_19_13 5.008854e-04
Rlv_18_13 l_18_13 l_18_14 5.008854e-04
Rlh_18_14 l_18_14 l_19_14 5.008854e-04
Rlv_18_14 l_18_14 l_18_15 5.008854e-04
Rlh_18_15 l_18_15 l_19_15 5.008854e-04
Rlv_18_15 l_18_15 l_18_16 5.008854e-04
Rlh_18_16 l_18_16 l_19_16 5.008854e-04
Rlv_18_16 l_18_16 l_18_17 5.008854e-04
Rlh_18_17 l_18_17 l_19_17 5.008854e-04
Rlv_18_17 l_18_17 l_18_18 5.008854e-04
Rlh_18_18 l_18_18 l_19_18 5.008854e-04
Rlv_18_18 l_18_18 l_18_19 5.008854e-04
Rlh_18_19 l_18_19 l_19_19 5.008854e-04
Rlv_18_19 l_18_19 l_18_20 5.008854e-04
Rlh_18_20 l_18_20 l_19_20 5.008854e-04
Rlv_18_20 l_18_20 l_18_21 5.008854e-04
Rlh_18_21 l_18_21 l_19_21 5.008854e-04
Rlv_18_21 l_18_21 l_18_22 5.008854e-04
Rlh_18_22 l_18_22 l_19_22 5.008854e-04
Rlv_18_22 l_18_22 l_18_23 5.008854e-04
Rlh_18_23 l_18_23 l_19_23 5.008854e-04
Rlv_18_23 l_18_23 l_18_24 5.008854e-04
Rlh_18_24 l_18_24 l_19_24 5.008854e-04
Rlv_18_24 l_18_24 l_18_25 5.008854e-04
Rlh_18_25 l_18_25 l_19_25 5.008854e-04
Rlv_18_25 l_18_25 l_18_26 5.008854e-04
Rlh_18_26 l_18_26 l_19_26 5.008854e-04
Rlv_18_26 l_18_26 l_18_27 5.008854e-04
Rlh_18_27 l_18_27 l_19_27 5.008854e-04
Rlv_18_27 l_18_27 l_18_28 5.008854e-04
Rlh_18_28 l_18_28 l_19_28 5.008854e-04
Rlv_18_28 l_18_28 l_18_29 5.008854e-04
Rlh_18_29 l_18_29 l_19_29 5.008854e-04
Rlv_18_29 l_18_29 l_18_30 5.008854e-04
Rlh_18_30 l_18_30 l_19_30 5.008854e-04
Rlv_18_30 l_18_30 l_18_31 5.008854e-04
Rlh_18_31 l_18_31 l_19_31 5.008854e-04
Rlv_18_31 l_18_31 l_18_32 5.008854e-04
Rlh_18_32 l_18_32 l_19_32 5.008854e-04
Rlv_18_32 l_18_32 l_18_33 5.008854e-04
Rlh_18_33 l_18_33 l_19_33 5.008854e-04
Rlv_18_33 l_18_33 l_18_34 5.008854e-04
Rlh_18_34 l_18_34 l_19_34 5.008854e-04
Rlv_18_34 l_18_34 l_18_35 5.008854e-04
Rlh_18_35 l_18_35 l_19_35 5.008854e-04
Rlv_18_35 l_18_35 l_18_36 5.008854e-04
Rlh_18_36 l_18_36 l_19_36 5.008854e-04
Rlv_18_36 l_18_36 l_18_37 5.008854e-04
Rlh_18_37 l_18_37 l_19_37 5.008854e-04
Rlv_18_37 l_18_37 l_18_38 5.008854e-04
Rlh_18_38 l_18_38 l_19_38 5.008854e-04
Rlv_18_38 l_18_38 l_18_39 5.008854e-04
Rlh_18_39 l_18_39 l_19_39 5.008854e-04
Rlv_18_39 l_18_39 l_18_40 5.008854e-04
Rlh_18_40 l_18_40 l_19_40 5.008854e-04
Rlv_18_40 l_18_40 l_18_41 5.008854e-04
Rlh_18_41 l_18_41 l_19_41 5.008854e-04
Rlv_18_41 l_18_41 l_18_42 5.008854e-04
Rlh_18_42 l_18_42 l_19_42 5.008854e-04
Rlv_18_42 l_18_42 l_18_43 5.008854e-04
Rlh_18_43 l_18_43 l_19_43 5.008854e-04
Rlv_18_43 l_18_43 l_18_44 5.008854e-04
Rlh_18_44 l_18_44 l_19_44 5.008854e-04
Rlv_18_44 l_18_44 l_18_45 5.008854e-04
Rlh_18_45 l_18_45 l_19_45 5.008854e-04
Rlv_18_45 l_18_45 l_18_46 5.008854e-04
Rlh_18_46 l_18_46 l_19_46 5.008854e-04
Rlv_18_46 l_18_46 l_18_47 5.008854e-04
Rlh_18_47 l_18_47 l_19_47 5.008854e-04
Rlv_18_47 l_18_47 l_18_48 5.008854e-04
Rlh_18_48 l_18_48 l_19_48 5.008854e-04
Rlv_18_48 l_18_48 l_18_49 5.008854e-04
Rlh_18_49 l_18_49 l_19_49 5.008854e-04
Rlv_18_49 l_18_49 l_18_50 5.008854e-04
Rlh_18_50 l_18_50 l_19_50 5.008854e-04
Rlv_18_50 l_18_50 l_18_51 5.008854e-04
Rlh_18_51 l_18_51 l_19_51 5.008854e-04
Rlv_18_51 l_18_51 l_18_52 5.008854e-04
Rlh_18_52 l_18_52 l_19_52 5.008854e-04
Rlv_18_52 l_18_52 l_18_53 5.008854e-04
Rlh_18_53 l_18_53 l_19_53 5.008854e-04
Rlv_18_53 l_18_53 l_18_54 5.008854e-04
Rlh_18_54 l_18_54 l_19_54 5.008854e-04
Rlv_18_54 l_18_54 l_18_55 5.008854e-04
Rlh_18_55 l_18_55 l_19_55 5.008854e-04
Rlv_18_55 l_18_55 l_18_56 5.008854e-04
Rlh_18_56 l_18_56 l_19_56 5.008854e-04
Rlv_18_56 l_18_56 l_18_57 5.008854e-04
Rlh_18_57 l_18_57 l_19_57 5.008854e-04
Rlv_18_57 l_18_57 l_18_58 5.008854e-04
Rlh_18_58 l_18_58 l_19_58 5.008854e-04
Rlv_18_58 l_18_58 l_18_59 5.008854e-04
Rlh_18_59 l_18_59 l_19_59 5.008854e-04
Rlv_18_59 l_18_59 l_18_60 5.008854e-04
Rlh_18_60 l_18_60 l_19_60 5.008854e-04
Rlv_18_60 l_18_60 l_18_61 5.008854e-04
Rlh_18_61 l_18_61 l_19_61 5.008854e-04
Rlv_18_61 l_18_61 l_18_62 5.008854e-04
Rlh_18_62 l_18_62 l_19_62 5.008854e-04
Rlv_18_62 l_18_62 l_18_63 5.008854e-04
Rlh_18_63 l_18_63 l_19_63 5.008854e-04
Rlv_18_63 l_18_63 l_18_64 5.008854e-04
Rlh_18_64 l_18_64 l_19_64 5.008854e-04
Rlv_18_64 l_18_64 l_18_65 5.008854e-04
Rlh_18_65 l_18_65 l_19_65 5.008854e-04
Rlv_18_65 l_18_65 l_18_66 5.008854e-04
Rlh_18_66 l_18_66 l_19_66 5.008854e-04
Rlv_18_66 l_18_66 l_18_67 5.008854e-04
Rlh_18_67 l_18_67 l_19_67 5.008854e-04
Rlv_18_67 l_18_67 l_18_68 5.008854e-04
Rlh_18_68 l_18_68 l_19_68 5.008854e-04
Rlv_18_68 l_18_68 l_18_69 5.008854e-04
Rlh_18_69 l_18_69 l_19_69 5.008854e-04
Rlv_18_69 l_18_69 l_18_70 5.008854e-04
Rlh_18_70 l_18_70 l_19_70 5.008854e-04
Rlv_18_70 l_18_70 l_18_71 5.008854e-04
Rlh_18_71 l_18_71 l_19_71 5.008854e-04
Rlh_19_0 l_19_0 l_20_0 5.008854e-04
Rlv_19_0 l_19_0 l_19_1 5.008854e-04
Rlh_19_1 l_19_1 l_20_1 5.008854e-04
Rlv_19_1 l_19_1 l_19_2 5.008854e-04
Rlh_19_2 l_19_2 l_20_2 5.008854e-04
Rlv_19_2 l_19_2 l_19_3 5.008854e-04
Rlh_19_3 l_19_3 l_20_3 5.008854e-04
Rlv_19_3 l_19_3 l_19_4 5.008854e-04
Rlh_19_4 l_19_4 l_20_4 5.008854e-04
Rlv_19_4 l_19_4 l_19_5 5.008854e-04
Rlh_19_5 l_19_5 l_20_5 5.008854e-04
Rlv_19_5 l_19_5 l_19_6 5.008854e-04
Rlh_19_6 l_19_6 l_20_6 5.008854e-04
Rlv_19_6 l_19_6 l_19_7 5.008854e-04
Rlh_19_7 l_19_7 l_20_7 5.008854e-04
Rlv_19_7 l_19_7 l_19_8 5.008854e-04
Rlh_19_8 l_19_8 l_20_8 5.008854e-04
Rlv_19_8 l_19_8 l_19_9 5.008854e-04
Rlh_19_9 l_19_9 l_20_9 5.008854e-04
Rlv_19_9 l_19_9 l_19_10 5.008854e-04
Rlh_19_10 l_19_10 l_20_10 5.008854e-04
Rlv_19_10 l_19_10 l_19_11 5.008854e-04
Rlh_19_11 l_19_11 l_20_11 5.008854e-04
Rlv_19_11 l_19_11 l_19_12 5.008854e-04
Rlh_19_12 l_19_12 l_20_12 5.008854e-04
Rlv_19_12 l_19_12 l_19_13 5.008854e-04
Rlh_19_13 l_19_13 l_20_13 5.008854e-04
Rlv_19_13 l_19_13 l_19_14 5.008854e-04
Rlh_19_14 l_19_14 l_20_14 5.008854e-04
Rlv_19_14 l_19_14 l_19_15 5.008854e-04
Rlh_19_15 l_19_15 l_20_15 5.008854e-04
Rlv_19_15 l_19_15 l_19_16 5.008854e-04
Rlh_19_16 l_19_16 l_20_16 5.008854e-04
Rlv_19_16 l_19_16 l_19_17 5.008854e-04
Rlh_19_17 l_19_17 l_20_17 5.008854e-04
Rlv_19_17 l_19_17 l_19_18 5.008854e-04
Rlh_19_18 l_19_18 l_20_18 5.008854e-04
Rlv_19_18 l_19_18 l_19_19 5.008854e-04
Rlh_19_19 l_19_19 l_20_19 5.008854e-04
Rlv_19_19 l_19_19 l_19_20 5.008854e-04
Rlh_19_20 l_19_20 l_20_20 5.008854e-04
Rlv_19_20 l_19_20 l_19_21 5.008854e-04
Rlh_19_21 l_19_21 l_20_21 5.008854e-04
Rlv_19_21 l_19_21 l_19_22 5.008854e-04
Rlh_19_22 l_19_22 l_20_22 5.008854e-04
Rlv_19_22 l_19_22 l_19_23 5.008854e-04
Rlh_19_23 l_19_23 l_20_23 5.008854e-04
Rlv_19_23 l_19_23 l_19_24 5.008854e-04
Rlh_19_24 l_19_24 l_20_24 5.008854e-04
Rlv_19_24 l_19_24 l_19_25 5.008854e-04
Rlh_19_25 l_19_25 l_20_25 5.008854e-04
Rlv_19_25 l_19_25 l_19_26 5.008854e-04
Rlh_19_26 l_19_26 l_20_26 5.008854e-04
Rlv_19_26 l_19_26 l_19_27 5.008854e-04
Rlh_19_27 l_19_27 l_20_27 5.008854e-04
Rlv_19_27 l_19_27 l_19_28 5.008854e-04
Rlh_19_28 l_19_28 l_20_28 5.008854e-04
Rlv_19_28 l_19_28 l_19_29 5.008854e-04
Rlh_19_29 l_19_29 l_20_29 5.008854e-04
Rlv_19_29 l_19_29 l_19_30 5.008854e-04
Rlh_19_30 l_19_30 l_20_30 5.008854e-04
Rlv_19_30 l_19_30 l_19_31 5.008854e-04
Rlh_19_31 l_19_31 l_20_31 5.008854e-04
Rlv_19_31 l_19_31 l_19_32 5.008854e-04
Rlh_19_32 l_19_32 l_20_32 5.008854e-04
Rlv_19_32 l_19_32 l_19_33 5.008854e-04
Rlh_19_33 l_19_33 l_20_33 5.008854e-04
Rlv_19_33 l_19_33 l_19_34 5.008854e-04
Rlh_19_34 l_19_34 l_20_34 5.008854e-04
Rlv_19_34 l_19_34 l_19_35 5.008854e-04
Rlh_19_35 l_19_35 l_20_35 5.008854e-04
Rlv_19_35 l_19_35 l_19_36 5.008854e-04
Rlh_19_36 l_19_36 l_20_36 5.008854e-04
Rlv_19_36 l_19_36 l_19_37 5.008854e-04
Rlh_19_37 l_19_37 l_20_37 5.008854e-04
Rlv_19_37 l_19_37 l_19_38 5.008854e-04
Rlh_19_38 l_19_38 l_20_38 5.008854e-04
Rlv_19_38 l_19_38 l_19_39 5.008854e-04
Rlh_19_39 l_19_39 l_20_39 5.008854e-04
Rlv_19_39 l_19_39 l_19_40 5.008854e-04
Rlh_19_40 l_19_40 l_20_40 5.008854e-04
Rlv_19_40 l_19_40 l_19_41 5.008854e-04
Rlh_19_41 l_19_41 l_20_41 5.008854e-04
Rlv_19_41 l_19_41 l_19_42 5.008854e-04
Rlh_19_42 l_19_42 l_20_42 5.008854e-04
Rlv_19_42 l_19_42 l_19_43 5.008854e-04
Rlh_19_43 l_19_43 l_20_43 5.008854e-04
Rlv_19_43 l_19_43 l_19_44 5.008854e-04
Rlh_19_44 l_19_44 l_20_44 5.008854e-04
Rlv_19_44 l_19_44 l_19_45 5.008854e-04
Rlh_19_45 l_19_45 l_20_45 5.008854e-04
Rlv_19_45 l_19_45 l_19_46 5.008854e-04
Rlh_19_46 l_19_46 l_20_46 5.008854e-04
Rlv_19_46 l_19_46 l_19_47 5.008854e-04
Rlh_19_47 l_19_47 l_20_47 5.008854e-04
Rlv_19_47 l_19_47 l_19_48 5.008854e-04
Rlh_19_48 l_19_48 l_20_48 5.008854e-04
Rlv_19_48 l_19_48 l_19_49 5.008854e-04
Rlh_19_49 l_19_49 l_20_49 5.008854e-04
Rlv_19_49 l_19_49 l_19_50 5.008854e-04
Rlh_19_50 l_19_50 l_20_50 5.008854e-04
Rlv_19_50 l_19_50 l_19_51 5.008854e-04
Rlh_19_51 l_19_51 l_20_51 5.008854e-04
Rlv_19_51 l_19_51 l_19_52 5.008854e-04
Rlh_19_52 l_19_52 l_20_52 5.008854e-04
Rlv_19_52 l_19_52 l_19_53 5.008854e-04
Rlh_19_53 l_19_53 l_20_53 5.008854e-04
Rlv_19_53 l_19_53 l_19_54 5.008854e-04
Rlh_19_54 l_19_54 l_20_54 5.008854e-04
Rlv_19_54 l_19_54 l_19_55 5.008854e-04
Rlh_19_55 l_19_55 l_20_55 5.008854e-04
Rlv_19_55 l_19_55 l_19_56 5.008854e-04
Rlh_19_56 l_19_56 l_20_56 5.008854e-04
Rlv_19_56 l_19_56 l_19_57 5.008854e-04
Rlh_19_57 l_19_57 l_20_57 5.008854e-04
Rlv_19_57 l_19_57 l_19_58 5.008854e-04
Rlh_19_58 l_19_58 l_20_58 5.008854e-04
Rlv_19_58 l_19_58 l_19_59 5.008854e-04
Rlh_19_59 l_19_59 l_20_59 5.008854e-04
Rlv_19_59 l_19_59 l_19_60 5.008854e-04
Rlh_19_60 l_19_60 l_20_60 5.008854e-04
Rlv_19_60 l_19_60 l_19_61 5.008854e-04
Rlh_19_61 l_19_61 l_20_61 5.008854e-04
Rlv_19_61 l_19_61 l_19_62 5.008854e-04
Rlh_19_62 l_19_62 l_20_62 5.008854e-04
Rlv_19_62 l_19_62 l_19_63 5.008854e-04
Rlh_19_63 l_19_63 l_20_63 5.008854e-04
Rlv_19_63 l_19_63 l_19_64 5.008854e-04
Rlh_19_64 l_19_64 l_20_64 5.008854e-04
Rlv_19_64 l_19_64 l_19_65 5.008854e-04
Rlh_19_65 l_19_65 l_20_65 5.008854e-04
Rlv_19_65 l_19_65 l_19_66 5.008854e-04
Rlh_19_66 l_19_66 l_20_66 5.008854e-04
Rlv_19_66 l_19_66 l_19_67 5.008854e-04
Rlh_19_67 l_19_67 l_20_67 5.008854e-04
Rlv_19_67 l_19_67 l_19_68 5.008854e-04
Rlh_19_68 l_19_68 l_20_68 5.008854e-04
Rlv_19_68 l_19_68 l_19_69 5.008854e-04
Rlh_19_69 l_19_69 l_20_69 5.008854e-04
Rlv_19_69 l_19_69 l_19_70 5.008854e-04
Rlh_19_70 l_19_70 l_20_70 5.008854e-04
Rlv_19_70 l_19_70 l_19_71 5.008854e-04
Rlh_19_71 l_19_71 l_20_71 5.008854e-04
Rlh_20_0 l_20_0 l_21_0 5.008854e-04
Rlv_20_0 l_20_0 l_20_1 5.008854e-04
Rlh_20_1 l_20_1 l_21_1 5.008854e-04
Rlv_20_1 l_20_1 l_20_2 5.008854e-04
Rlh_20_2 l_20_2 l_21_2 5.008854e-04
Rlv_20_2 l_20_2 l_20_3 5.008854e-04
Rlh_20_3 l_20_3 l_21_3 5.008854e-04
Rlv_20_3 l_20_3 l_20_4 5.008854e-04
Rlh_20_4 l_20_4 l_21_4 5.008854e-04
Rlv_20_4 l_20_4 l_20_5 5.008854e-04
Rlh_20_5 l_20_5 l_21_5 5.008854e-04
Rlv_20_5 l_20_5 l_20_6 5.008854e-04
Rlh_20_6 l_20_6 l_21_6 5.008854e-04
Rlv_20_6 l_20_6 l_20_7 5.008854e-04
Rlh_20_7 l_20_7 l_21_7 5.008854e-04
Rlv_20_7 l_20_7 l_20_8 5.008854e-04
Rlh_20_8 l_20_8 l_21_8 5.008854e-04
Rlv_20_8 l_20_8 l_20_9 5.008854e-04
Rlh_20_9 l_20_9 l_21_9 5.008854e-04
Rlv_20_9 l_20_9 l_20_10 5.008854e-04
Rlh_20_10 l_20_10 l_21_10 5.008854e-04
Rlv_20_10 l_20_10 l_20_11 5.008854e-04
Rlh_20_11 l_20_11 l_21_11 5.008854e-04
Rlv_20_11 l_20_11 l_20_12 5.008854e-04
Rlh_20_12 l_20_12 l_21_12 5.008854e-04
Rlv_20_12 l_20_12 l_20_13 5.008854e-04
Rlh_20_13 l_20_13 l_21_13 5.008854e-04
Rlv_20_13 l_20_13 l_20_14 5.008854e-04
Rlh_20_14 l_20_14 l_21_14 5.008854e-04
Rlv_20_14 l_20_14 l_20_15 5.008854e-04
Rlh_20_15 l_20_15 l_21_15 5.008854e-04
Rlv_20_15 l_20_15 l_20_16 5.008854e-04
Rlh_20_16 l_20_16 l_21_16 5.008854e-04
Rlv_20_16 l_20_16 l_20_17 5.008854e-04
Rlh_20_17 l_20_17 l_21_17 5.008854e-04
Rlv_20_17 l_20_17 l_20_18 5.008854e-04
Rlh_20_18 l_20_18 l_21_18 5.008854e-04
Rlv_20_18 l_20_18 l_20_19 5.008854e-04
Rlh_20_19 l_20_19 l_21_19 5.008854e-04
Rlv_20_19 l_20_19 l_20_20 5.008854e-04
Rlh_20_20 l_20_20 l_21_20 5.008854e-04
Rlv_20_20 l_20_20 l_20_21 5.008854e-04
Rlh_20_21 l_20_21 l_21_21 5.008854e-04
Rlv_20_21 l_20_21 l_20_22 5.008854e-04
Rlh_20_22 l_20_22 l_21_22 5.008854e-04
Rlv_20_22 l_20_22 l_20_23 5.008854e-04
Rlh_20_23 l_20_23 l_21_23 5.008854e-04
Rlv_20_23 l_20_23 l_20_24 5.008854e-04
Rlh_20_24 l_20_24 l_21_24 5.008854e-04
Rlv_20_24 l_20_24 l_20_25 5.008854e-04
Rlh_20_25 l_20_25 l_21_25 5.008854e-04
Rlv_20_25 l_20_25 l_20_26 5.008854e-04
Rlh_20_26 l_20_26 l_21_26 5.008854e-04
Rlv_20_26 l_20_26 l_20_27 5.008854e-04
Rlh_20_27 l_20_27 l_21_27 5.008854e-04
Rlv_20_27 l_20_27 l_20_28 5.008854e-04
Rlh_20_28 l_20_28 l_21_28 5.008854e-04
Rlv_20_28 l_20_28 l_20_29 5.008854e-04
Rlh_20_29 l_20_29 l_21_29 5.008854e-04
Rlv_20_29 l_20_29 l_20_30 5.008854e-04
Rlh_20_30 l_20_30 l_21_30 5.008854e-04
Rlv_20_30 l_20_30 l_20_31 5.008854e-04
Rlh_20_31 l_20_31 l_21_31 5.008854e-04
Rlv_20_31 l_20_31 l_20_32 5.008854e-04
Rlh_20_32 l_20_32 l_21_32 5.008854e-04
Rlv_20_32 l_20_32 l_20_33 5.008854e-04
Rlh_20_33 l_20_33 l_21_33 5.008854e-04
Rlv_20_33 l_20_33 l_20_34 5.008854e-04
Rlh_20_34 l_20_34 l_21_34 5.008854e-04
Rlv_20_34 l_20_34 l_20_35 5.008854e-04
Rlh_20_35 l_20_35 l_21_35 5.008854e-04
Rlv_20_35 l_20_35 l_20_36 5.008854e-04
Rlh_20_36 l_20_36 l_21_36 5.008854e-04
Rlv_20_36 l_20_36 l_20_37 5.008854e-04
Rlh_20_37 l_20_37 l_21_37 5.008854e-04
Rlv_20_37 l_20_37 l_20_38 5.008854e-04
Rlh_20_38 l_20_38 l_21_38 5.008854e-04
Rlv_20_38 l_20_38 l_20_39 5.008854e-04
Rlh_20_39 l_20_39 l_21_39 5.008854e-04
Rlv_20_39 l_20_39 l_20_40 5.008854e-04
Rlh_20_40 l_20_40 l_21_40 5.008854e-04
Rlv_20_40 l_20_40 l_20_41 5.008854e-04
Rlh_20_41 l_20_41 l_21_41 5.008854e-04
Rlv_20_41 l_20_41 l_20_42 5.008854e-04
Rlh_20_42 l_20_42 l_21_42 5.008854e-04
Rlv_20_42 l_20_42 l_20_43 5.008854e-04
Rlh_20_43 l_20_43 l_21_43 5.008854e-04
Rlv_20_43 l_20_43 l_20_44 5.008854e-04
Rlh_20_44 l_20_44 l_21_44 5.008854e-04
Rlv_20_44 l_20_44 l_20_45 5.008854e-04
Rlh_20_45 l_20_45 l_21_45 5.008854e-04
Rlv_20_45 l_20_45 l_20_46 5.008854e-04
Rlh_20_46 l_20_46 l_21_46 5.008854e-04
Rlv_20_46 l_20_46 l_20_47 5.008854e-04
Rlh_20_47 l_20_47 l_21_47 5.008854e-04
Rlv_20_47 l_20_47 l_20_48 5.008854e-04
Rlh_20_48 l_20_48 l_21_48 5.008854e-04
Rlv_20_48 l_20_48 l_20_49 5.008854e-04
Rlh_20_49 l_20_49 l_21_49 5.008854e-04
Rlv_20_49 l_20_49 l_20_50 5.008854e-04
Rlh_20_50 l_20_50 l_21_50 5.008854e-04
Rlv_20_50 l_20_50 l_20_51 5.008854e-04
Rlh_20_51 l_20_51 l_21_51 5.008854e-04
Rlv_20_51 l_20_51 l_20_52 5.008854e-04
Rlh_20_52 l_20_52 l_21_52 5.008854e-04
Rlv_20_52 l_20_52 l_20_53 5.008854e-04
Rlh_20_53 l_20_53 l_21_53 5.008854e-04
Rlv_20_53 l_20_53 l_20_54 5.008854e-04
Rlh_20_54 l_20_54 l_21_54 5.008854e-04
Rlv_20_54 l_20_54 l_20_55 5.008854e-04
Rlh_20_55 l_20_55 l_21_55 5.008854e-04
Rlv_20_55 l_20_55 l_20_56 5.008854e-04
Rlh_20_56 l_20_56 l_21_56 5.008854e-04
Rlv_20_56 l_20_56 l_20_57 5.008854e-04
Rlh_20_57 l_20_57 l_21_57 5.008854e-04
Rlv_20_57 l_20_57 l_20_58 5.008854e-04
Rlh_20_58 l_20_58 l_21_58 5.008854e-04
Rlv_20_58 l_20_58 l_20_59 5.008854e-04
Rlh_20_59 l_20_59 l_21_59 5.008854e-04
Rlv_20_59 l_20_59 l_20_60 5.008854e-04
Rlh_20_60 l_20_60 l_21_60 5.008854e-04
Rlv_20_60 l_20_60 l_20_61 5.008854e-04
Rlh_20_61 l_20_61 l_21_61 5.008854e-04
Rlv_20_61 l_20_61 l_20_62 5.008854e-04
Rlh_20_62 l_20_62 l_21_62 5.008854e-04
Rlv_20_62 l_20_62 l_20_63 5.008854e-04
Rlh_20_63 l_20_63 l_21_63 5.008854e-04
Rlv_20_63 l_20_63 l_20_64 5.008854e-04
Rlh_20_64 l_20_64 l_21_64 5.008854e-04
Rlv_20_64 l_20_64 l_20_65 5.008854e-04
Rlh_20_65 l_20_65 l_21_65 5.008854e-04
Rlv_20_65 l_20_65 l_20_66 5.008854e-04
Rlh_20_66 l_20_66 l_21_66 5.008854e-04
Rlv_20_66 l_20_66 l_20_67 5.008854e-04
Rlh_20_67 l_20_67 l_21_67 5.008854e-04
Rlv_20_67 l_20_67 l_20_68 5.008854e-04
Rlh_20_68 l_20_68 l_21_68 5.008854e-04
Rlv_20_68 l_20_68 l_20_69 5.008854e-04
Rlh_20_69 l_20_69 l_21_69 5.008854e-04
Rlv_20_69 l_20_69 l_20_70 5.008854e-04
Rlh_20_70 l_20_70 l_21_70 5.008854e-04
Rlv_20_70 l_20_70 l_20_71 5.008854e-04
Rlh_20_71 l_20_71 l_21_71 5.008854e-04
Rlh_21_0 l_21_0 l_22_0 5.008854e-04
Rlv_21_0 l_21_0 l_21_1 5.008854e-04
Rlh_21_1 l_21_1 l_22_1 5.008854e-04
Rlv_21_1 l_21_1 l_21_2 5.008854e-04
Rlh_21_2 l_21_2 l_22_2 5.008854e-04
Rlv_21_2 l_21_2 l_21_3 5.008854e-04
Rlh_21_3 l_21_3 l_22_3 5.008854e-04
Rlv_21_3 l_21_3 l_21_4 5.008854e-04
Rlh_21_4 l_21_4 l_22_4 5.008854e-04
Rlv_21_4 l_21_4 l_21_5 5.008854e-04
Rlh_21_5 l_21_5 l_22_5 5.008854e-04
Rlv_21_5 l_21_5 l_21_6 5.008854e-04
Rlh_21_6 l_21_6 l_22_6 5.008854e-04
Rlv_21_6 l_21_6 l_21_7 5.008854e-04
Rlh_21_7 l_21_7 l_22_7 5.008854e-04
Rlv_21_7 l_21_7 l_21_8 5.008854e-04
Rlh_21_8 l_21_8 l_22_8 5.008854e-04
Rlv_21_8 l_21_8 l_21_9 5.008854e-04
Rlh_21_9 l_21_9 l_22_9 5.008854e-04
Rlv_21_9 l_21_9 l_21_10 5.008854e-04
Rlh_21_10 l_21_10 l_22_10 5.008854e-04
Rlv_21_10 l_21_10 l_21_11 5.008854e-04
Rlh_21_11 l_21_11 l_22_11 5.008854e-04
Rlv_21_11 l_21_11 l_21_12 5.008854e-04
Rlh_21_12 l_21_12 l_22_12 5.008854e-04
Rlv_21_12 l_21_12 l_21_13 5.008854e-04
Rlh_21_13 l_21_13 l_22_13 5.008854e-04
Rlv_21_13 l_21_13 l_21_14 5.008854e-04
Rlh_21_14 l_21_14 l_22_14 5.008854e-04
Rlv_21_14 l_21_14 l_21_15 5.008854e-04
Rlh_21_15 l_21_15 l_22_15 5.008854e-04
Rlv_21_15 l_21_15 l_21_16 5.008854e-04
Rlh_21_16 l_21_16 l_22_16 5.008854e-04
Rlv_21_16 l_21_16 l_21_17 5.008854e-04
Rlh_21_17 l_21_17 l_22_17 5.008854e-04
Rlv_21_17 l_21_17 l_21_18 5.008854e-04
Rlh_21_18 l_21_18 l_22_18 5.008854e-04
Rlv_21_18 l_21_18 l_21_19 5.008854e-04
Rlh_21_19 l_21_19 l_22_19 5.008854e-04
Rlv_21_19 l_21_19 l_21_20 5.008854e-04
Rlh_21_20 l_21_20 l_22_20 5.008854e-04
Rlv_21_20 l_21_20 l_21_21 5.008854e-04
Rlh_21_21 l_21_21 l_22_21 5.008854e-04
Rlv_21_21 l_21_21 l_21_22 5.008854e-04
Rlh_21_22 l_21_22 l_22_22 5.008854e-04
Rlv_21_22 l_21_22 l_21_23 5.008854e-04
Rlh_21_23 l_21_23 l_22_23 5.008854e-04
Rlv_21_23 l_21_23 l_21_24 5.008854e-04
Rlh_21_24 l_21_24 l_22_24 5.008854e-04
Rlv_21_24 l_21_24 l_21_25 5.008854e-04
Rlh_21_25 l_21_25 l_22_25 5.008854e-04
Rlv_21_25 l_21_25 l_21_26 5.008854e-04
Rlh_21_26 l_21_26 l_22_26 5.008854e-04
Rlv_21_26 l_21_26 l_21_27 5.008854e-04
Rlh_21_27 l_21_27 l_22_27 5.008854e-04
Rlv_21_27 l_21_27 l_21_28 5.008854e-04
Rlh_21_28 l_21_28 l_22_28 5.008854e-04
Rlv_21_28 l_21_28 l_21_29 5.008854e-04
Rlh_21_29 l_21_29 l_22_29 5.008854e-04
Rlv_21_29 l_21_29 l_21_30 5.008854e-04
Rlh_21_30 l_21_30 l_22_30 5.008854e-04
Rlv_21_30 l_21_30 l_21_31 5.008854e-04
Rlh_21_31 l_21_31 l_22_31 5.008854e-04
Rlv_21_31 l_21_31 l_21_32 5.008854e-04
Rlh_21_32 l_21_32 l_22_32 5.008854e-04
Rlv_21_32 l_21_32 l_21_33 5.008854e-04
Rlh_21_33 l_21_33 l_22_33 5.008854e-04
Rlv_21_33 l_21_33 l_21_34 5.008854e-04
Rlh_21_34 l_21_34 l_22_34 5.008854e-04
Rlv_21_34 l_21_34 l_21_35 5.008854e-04
Rlh_21_35 l_21_35 l_22_35 5.008854e-04
Rlv_21_35 l_21_35 l_21_36 5.008854e-04
Rlh_21_36 l_21_36 l_22_36 5.008854e-04
Rlv_21_36 l_21_36 l_21_37 5.008854e-04
Rlh_21_37 l_21_37 l_22_37 5.008854e-04
Rlv_21_37 l_21_37 l_21_38 5.008854e-04
Rlh_21_38 l_21_38 l_22_38 5.008854e-04
Rlv_21_38 l_21_38 l_21_39 5.008854e-04
Rlh_21_39 l_21_39 l_22_39 5.008854e-04
Rlv_21_39 l_21_39 l_21_40 5.008854e-04
Rlh_21_40 l_21_40 l_22_40 5.008854e-04
Rlv_21_40 l_21_40 l_21_41 5.008854e-04
Rlh_21_41 l_21_41 l_22_41 5.008854e-04
Rlv_21_41 l_21_41 l_21_42 5.008854e-04
Rlh_21_42 l_21_42 l_22_42 5.008854e-04
Rlv_21_42 l_21_42 l_21_43 5.008854e-04
Rlh_21_43 l_21_43 l_22_43 5.008854e-04
Rlv_21_43 l_21_43 l_21_44 5.008854e-04
Rlh_21_44 l_21_44 l_22_44 5.008854e-04
Rlv_21_44 l_21_44 l_21_45 5.008854e-04
Rlh_21_45 l_21_45 l_22_45 5.008854e-04
Rlv_21_45 l_21_45 l_21_46 5.008854e-04
Rlh_21_46 l_21_46 l_22_46 5.008854e-04
Rlv_21_46 l_21_46 l_21_47 5.008854e-04
Rlh_21_47 l_21_47 l_22_47 5.008854e-04
Rlv_21_47 l_21_47 l_21_48 5.008854e-04
Rlh_21_48 l_21_48 l_22_48 5.008854e-04
Rlv_21_48 l_21_48 l_21_49 5.008854e-04
Rlh_21_49 l_21_49 l_22_49 5.008854e-04
Rlv_21_49 l_21_49 l_21_50 5.008854e-04
Rlh_21_50 l_21_50 l_22_50 5.008854e-04
Rlv_21_50 l_21_50 l_21_51 5.008854e-04
Rlh_21_51 l_21_51 l_22_51 5.008854e-04
Rlv_21_51 l_21_51 l_21_52 5.008854e-04
Rlh_21_52 l_21_52 l_22_52 5.008854e-04
Rlv_21_52 l_21_52 l_21_53 5.008854e-04
Rlh_21_53 l_21_53 l_22_53 5.008854e-04
Rlv_21_53 l_21_53 l_21_54 5.008854e-04
Rlh_21_54 l_21_54 l_22_54 5.008854e-04
Rlv_21_54 l_21_54 l_21_55 5.008854e-04
Rlh_21_55 l_21_55 l_22_55 5.008854e-04
Rlv_21_55 l_21_55 l_21_56 5.008854e-04
Rlh_21_56 l_21_56 l_22_56 5.008854e-04
Rlv_21_56 l_21_56 l_21_57 5.008854e-04
Rlh_21_57 l_21_57 l_22_57 5.008854e-04
Rlv_21_57 l_21_57 l_21_58 5.008854e-04
Rlh_21_58 l_21_58 l_22_58 5.008854e-04
Rlv_21_58 l_21_58 l_21_59 5.008854e-04
Rlh_21_59 l_21_59 l_22_59 5.008854e-04
Rlv_21_59 l_21_59 l_21_60 5.008854e-04
Rlh_21_60 l_21_60 l_22_60 5.008854e-04
Rlv_21_60 l_21_60 l_21_61 5.008854e-04
Rlh_21_61 l_21_61 l_22_61 5.008854e-04
Rlv_21_61 l_21_61 l_21_62 5.008854e-04
Rlh_21_62 l_21_62 l_22_62 5.008854e-04
Rlv_21_62 l_21_62 l_21_63 5.008854e-04
Rlh_21_63 l_21_63 l_22_63 5.008854e-04
Rlv_21_63 l_21_63 l_21_64 5.008854e-04
Rlh_21_64 l_21_64 l_22_64 5.008854e-04
Rlv_21_64 l_21_64 l_21_65 5.008854e-04
Rlh_21_65 l_21_65 l_22_65 5.008854e-04
Rlv_21_65 l_21_65 l_21_66 5.008854e-04
Rlh_21_66 l_21_66 l_22_66 5.008854e-04
Rlv_21_66 l_21_66 l_21_67 5.008854e-04
Rlh_21_67 l_21_67 l_22_67 5.008854e-04
Rlv_21_67 l_21_67 l_21_68 5.008854e-04
Rlh_21_68 l_21_68 l_22_68 5.008854e-04
Rlv_21_68 l_21_68 l_21_69 5.008854e-04
Rlh_21_69 l_21_69 l_22_69 5.008854e-04
Rlv_21_69 l_21_69 l_21_70 5.008854e-04
Rlh_21_70 l_21_70 l_22_70 5.008854e-04
Rlv_21_70 l_21_70 l_21_71 5.008854e-04
Rlh_21_71 l_21_71 l_22_71 5.008854e-04
Rlh_22_0 l_22_0 l_23_0 5.008854e-04
Rlv_22_0 l_22_0 l_22_1 5.008854e-04
Rlh_22_1 l_22_1 l_23_1 5.008854e-04
Rlv_22_1 l_22_1 l_22_2 5.008854e-04
Rlh_22_2 l_22_2 l_23_2 5.008854e-04
Rlv_22_2 l_22_2 l_22_3 5.008854e-04
Rlh_22_3 l_22_3 l_23_3 5.008854e-04
Rlv_22_3 l_22_3 l_22_4 5.008854e-04
Rlh_22_4 l_22_4 l_23_4 5.008854e-04
Rlv_22_4 l_22_4 l_22_5 5.008854e-04
Rlh_22_5 l_22_5 l_23_5 5.008854e-04
Rlv_22_5 l_22_5 l_22_6 5.008854e-04
Rlh_22_6 l_22_6 l_23_6 5.008854e-04
Rlv_22_6 l_22_6 l_22_7 5.008854e-04
Rlh_22_7 l_22_7 l_23_7 5.008854e-04
Rlv_22_7 l_22_7 l_22_8 5.008854e-04
Rlh_22_8 l_22_8 l_23_8 5.008854e-04
Rlv_22_8 l_22_8 l_22_9 5.008854e-04
Rlh_22_9 l_22_9 l_23_9 5.008854e-04
Rlv_22_9 l_22_9 l_22_10 5.008854e-04
Rlh_22_10 l_22_10 l_23_10 5.008854e-04
Rlv_22_10 l_22_10 l_22_11 5.008854e-04
Rlh_22_11 l_22_11 l_23_11 5.008854e-04
Rlv_22_11 l_22_11 l_22_12 5.008854e-04
Rlh_22_12 l_22_12 l_23_12 5.008854e-04
Rlv_22_12 l_22_12 l_22_13 5.008854e-04
Rlh_22_13 l_22_13 l_23_13 5.008854e-04
Rlv_22_13 l_22_13 l_22_14 5.008854e-04
Rlh_22_14 l_22_14 l_23_14 5.008854e-04
Rlv_22_14 l_22_14 l_22_15 5.008854e-04
Rlh_22_15 l_22_15 l_23_15 5.008854e-04
Rlv_22_15 l_22_15 l_22_16 5.008854e-04
Rlh_22_16 l_22_16 l_23_16 5.008854e-04
Rlv_22_16 l_22_16 l_22_17 5.008854e-04
Rlh_22_17 l_22_17 l_23_17 5.008854e-04
Rlv_22_17 l_22_17 l_22_18 5.008854e-04
Rlh_22_18 l_22_18 l_23_18 5.008854e-04
Rlv_22_18 l_22_18 l_22_19 5.008854e-04
Rlh_22_19 l_22_19 l_23_19 5.008854e-04
Rlv_22_19 l_22_19 l_22_20 5.008854e-04
Rlh_22_20 l_22_20 l_23_20 5.008854e-04
Rlv_22_20 l_22_20 l_22_21 5.008854e-04
Rlh_22_21 l_22_21 l_23_21 5.008854e-04
Rlv_22_21 l_22_21 l_22_22 5.008854e-04
Rlh_22_22 l_22_22 l_23_22 5.008854e-04
Rlv_22_22 l_22_22 l_22_23 5.008854e-04
Rlh_22_23 l_22_23 l_23_23 5.008854e-04
Rlv_22_23 l_22_23 l_22_24 5.008854e-04
Rlh_22_24 l_22_24 l_23_24 5.008854e-04
Rlv_22_24 l_22_24 l_22_25 5.008854e-04
Rlh_22_25 l_22_25 l_23_25 5.008854e-04
Rlv_22_25 l_22_25 l_22_26 5.008854e-04
Rlh_22_26 l_22_26 l_23_26 5.008854e-04
Rlv_22_26 l_22_26 l_22_27 5.008854e-04
Rlh_22_27 l_22_27 l_23_27 5.008854e-04
Rlv_22_27 l_22_27 l_22_28 5.008854e-04
Rlh_22_28 l_22_28 l_23_28 5.008854e-04
Rlv_22_28 l_22_28 l_22_29 5.008854e-04
Rlh_22_29 l_22_29 l_23_29 5.008854e-04
Rlv_22_29 l_22_29 l_22_30 5.008854e-04
Rlh_22_30 l_22_30 l_23_30 5.008854e-04
Rlv_22_30 l_22_30 l_22_31 5.008854e-04
Rlh_22_31 l_22_31 l_23_31 5.008854e-04
Rlv_22_31 l_22_31 l_22_32 5.008854e-04
Rlh_22_32 l_22_32 l_23_32 5.008854e-04
Rlv_22_32 l_22_32 l_22_33 5.008854e-04
Rlh_22_33 l_22_33 l_23_33 5.008854e-04
Rlv_22_33 l_22_33 l_22_34 5.008854e-04
Rlh_22_34 l_22_34 l_23_34 5.008854e-04
Rlv_22_34 l_22_34 l_22_35 5.008854e-04
Rlh_22_35 l_22_35 l_23_35 5.008854e-04
Rlv_22_35 l_22_35 l_22_36 5.008854e-04
Rlh_22_36 l_22_36 l_23_36 5.008854e-04
Rlv_22_36 l_22_36 l_22_37 5.008854e-04
Rlh_22_37 l_22_37 l_23_37 5.008854e-04
Rlv_22_37 l_22_37 l_22_38 5.008854e-04
Rlh_22_38 l_22_38 l_23_38 5.008854e-04
Rlv_22_38 l_22_38 l_22_39 5.008854e-04
Rlh_22_39 l_22_39 l_23_39 5.008854e-04
Rlv_22_39 l_22_39 l_22_40 5.008854e-04
Rlh_22_40 l_22_40 l_23_40 5.008854e-04
Rlv_22_40 l_22_40 l_22_41 5.008854e-04
Rlh_22_41 l_22_41 l_23_41 5.008854e-04
Rlv_22_41 l_22_41 l_22_42 5.008854e-04
Rlh_22_42 l_22_42 l_23_42 5.008854e-04
Rlv_22_42 l_22_42 l_22_43 5.008854e-04
Rlh_22_43 l_22_43 l_23_43 5.008854e-04
Rlv_22_43 l_22_43 l_22_44 5.008854e-04
Rlh_22_44 l_22_44 l_23_44 5.008854e-04
Rlv_22_44 l_22_44 l_22_45 5.008854e-04
Rlh_22_45 l_22_45 l_23_45 5.008854e-04
Rlv_22_45 l_22_45 l_22_46 5.008854e-04
Rlh_22_46 l_22_46 l_23_46 5.008854e-04
Rlv_22_46 l_22_46 l_22_47 5.008854e-04
Rlh_22_47 l_22_47 l_23_47 5.008854e-04
Rlv_22_47 l_22_47 l_22_48 5.008854e-04
Rlh_22_48 l_22_48 l_23_48 5.008854e-04
Rlv_22_48 l_22_48 l_22_49 5.008854e-04
Rlh_22_49 l_22_49 l_23_49 5.008854e-04
Rlv_22_49 l_22_49 l_22_50 5.008854e-04
Rlh_22_50 l_22_50 l_23_50 5.008854e-04
Rlv_22_50 l_22_50 l_22_51 5.008854e-04
Rlh_22_51 l_22_51 l_23_51 5.008854e-04
Rlv_22_51 l_22_51 l_22_52 5.008854e-04
Rlh_22_52 l_22_52 l_23_52 5.008854e-04
Rlv_22_52 l_22_52 l_22_53 5.008854e-04
Rlh_22_53 l_22_53 l_23_53 5.008854e-04
Rlv_22_53 l_22_53 l_22_54 5.008854e-04
Rlh_22_54 l_22_54 l_23_54 5.008854e-04
Rlv_22_54 l_22_54 l_22_55 5.008854e-04
Rlh_22_55 l_22_55 l_23_55 5.008854e-04
Rlv_22_55 l_22_55 l_22_56 5.008854e-04
Rlh_22_56 l_22_56 l_23_56 5.008854e-04
Rlv_22_56 l_22_56 l_22_57 5.008854e-04
Rlh_22_57 l_22_57 l_23_57 5.008854e-04
Rlv_22_57 l_22_57 l_22_58 5.008854e-04
Rlh_22_58 l_22_58 l_23_58 5.008854e-04
Rlv_22_58 l_22_58 l_22_59 5.008854e-04
Rlh_22_59 l_22_59 l_23_59 5.008854e-04
Rlv_22_59 l_22_59 l_22_60 5.008854e-04
Rlh_22_60 l_22_60 l_23_60 5.008854e-04
Rlv_22_60 l_22_60 l_22_61 5.008854e-04
Rlh_22_61 l_22_61 l_23_61 5.008854e-04
Rlv_22_61 l_22_61 l_22_62 5.008854e-04
Rlh_22_62 l_22_62 l_23_62 5.008854e-04
Rlv_22_62 l_22_62 l_22_63 5.008854e-04
Rlh_22_63 l_22_63 l_23_63 5.008854e-04
Rlv_22_63 l_22_63 l_22_64 5.008854e-04
Rlh_22_64 l_22_64 l_23_64 5.008854e-04
Rlv_22_64 l_22_64 l_22_65 5.008854e-04
Rlh_22_65 l_22_65 l_23_65 5.008854e-04
Rlv_22_65 l_22_65 l_22_66 5.008854e-04
Rlh_22_66 l_22_66 l_23_66 5.008854e-04
Rlv_22_66 l_22_66 l_22_67 5.008854e-04
Rlh_22_67 l_22_67 l_23_67 5.008854e-04
Rlv_22_67 l_22_67 l_22_68 5.008854e-04
Rlh_22_68 l_22_68 l_23_68 5.008854e-04
Rlv_22_68 l_22_68 l_22_69 5.008854e-04
Rlh_22_69 l_22_69 l_23_69 5.008854e-04
Rlv_22_69 l_22_69 l_22_70 5.008854e-04
Rlh_22_70 l_22_70 l_23_70 5.008854e-04
Rlv_22_70 l_22_70 l_22_71 5.008854e-04
Rlh_22_71 l_22_71 l_23_71 5.008854e-04
Rlh_23_0 l_23_0 l_24_0 5.008854e-04
Rlv_23_0 l_23_0 l_23_1 5.008854e-04
Rlh_23_1 l_23_1 l_24_1 5.008854e-04
Rlv_23_1 l_23_1 l_23_2 5.008854e-04
Rlh_23_2 l_23_2 l_24_2 5.008854e-04
Rlv_23_2 l_23_2 l_23_3 5.008854e-04
Rlh_23_3 l_23_3 l_24_3 5.008854e-04
Rlv_23_3 l_23_3 l_23_4 5.008854e-04
Rlh_23_4 l_23_4 l_24_4 5.008854e-04
Rlv_23_4 l_23_4 l_23_5 5.008854e-04
Rlh_23_5 l_23_5 l_24_5 5.008854e-04
Rlv_23_5 l_23_5 l_23_6 5.008854e-04
Rlh_23_6 l_23_6 l_24_6 5.008854e-04
Rlv_23_6 l_23_6 l_23_7 5.008854e-04
Rlh_23_7 l_23_7 l_24_7 5.008854e-04
Rlv_23_7 l_23_7 l_23_8 5.008854e-04
Rlh_23_8 l_23_8 l_24_8 5.008854e-04
Rlv_23_8 l_23_8 l_23_9 5.008854e-04
Rlh_23_9 l_23_9 l_24_9 5.008854e-04
Rlv_23_9 l_23_9 l_23_10 5.008854e-04
Rlh_23_10 l_23_10 l_24_10 5.008854e-04
Rlv_23_10 l_23_10 l_23_11 5.008854e-04
Rlh_23_11 l_23_11 l_24_11 5.008854e-04
Rlv_23_11 l_23_11 l_23_12 5.008854e-04
Rlh_23_12 l_23_12 l_24_12 5.008854e-04
Rlv_23_12 l_23_12 l_23_13 5.008854e-04
Rlh_23_13 l_23_13 l_24_13 5.008854e-04
Rlv_23_13 l_23_13 l_23_14 5.008854e-04
Rlh_23_14 l_23_14 l_24_14 5.008854e-04
Rlv_23_14 l_23_14 l_23_15 5.008854e-04
Rlh_23_15 l_23_15 l_24_15 5.008854e-04
Rlv_23_15 l_23_15 l_23_16 5.008854e-04
Rlh_23_16 l_23_16 l_24_16 5.008854e-04
Rlv_23_16 l_23_16 l_23_17 5.008854e-04
Rlh_23_17 l_23_17 l_24_17 5.008854e-04
Rlv_23_17 l_23_17 l_23_18 5.008854e-04
Rlh_23_18 l_23_18 l_24_18 5.008854e-04
Rlv_23_18 l_23_18 l_23_19 5.008854e-04
Rlh_23_19 l_23_19 l_24_19 5.008854e-04
Rlv_23_19 l_23_19 l_23_20 5.008854e-04
Rlh_23_20 l_23_20 l_24_20 5.008854e-04
Rlv_23_20 l_23_20 l_23_21 5.008854e-04
Rlh_23_21 l_23_21 l_24_21 5.008854e-04
Rlv_23_21 l_23_21 l_23_22 5.008854e-04
Rlh_23_22 l_23_22 l_24_22 5.008854e-04
Rlv_23_22 l_23_22 l_23_23 5.008854e-04
Rlh_23_23 l_23_23 l_24_23 5.008854e-04
Rlv_23_23 l_23_23 l_23_24 5.008854e-04
Rlh_23_24 l_23_24 l_24_24 5.008854e-04
Rlv_23_24 l_23_24 l_23_25 5.008854e-04
Rlh_23_25 l_23_25 l_24_25 5.008854e-04
Rlv_23_25 l_23_25 l_23_26 5.008854e-04
Rlh_23_26 l_23_26 l_24_26 5.008854e-04
Rlv_23_26 l_23_26 l_23_27 5.008854e-04
Rlh_23_27 l_23_27 l_24_27 5.008854e-04
Rlv_23_27 l_23_27 l_23_28 5.008854e-04
Rlh_23_28 l_23_28 l_24_28 5.008854e-04
Rlv_23_28 l_23_28 l_23_29 5.008854e-04
Rlh_23_29 l_23_29 l_24_29 5.008854e-04
Rlv_23_29 l_23_29 l_23_30 5.008854e-04
Rlh_23_30 l_23_30 l_24_30 5.008854e-04
Rlv_23_30 l_23_30 l_23_31 5.008854e-04
Rlh_23_31 l_23_31 l_24_31 5.008854e-04
Rlv_23_31 l_23_31 l_23_32 5.008854e-04
Rlh_23_32 l_23_32 l_24_32 5.008854e-04
Rlv_23_32 l_23_32 l_23_33 5.008854e-04
Rlh_23_33 l_23_33 l_24_33 5.008854e-04
Rlv_23_33 l_23_33 l_23_34 5.008854e-04
Rlh_23_34 l_23_34 l_24_34 5.008854e-04
Rlv_23_34 l_23_34 l_23_35 5.008854e-04
Rlh_23_35 l_23_35 l_24_35 5.008854e-04
Rlv_23_35 l_23_35 l_23_36 5.008854e-04
Rlh_23_36 l_23_36 l_24_36 5.008854e-04
Rlv_23_36 l_23_36 l_23_37 5.008854e-04
Rlh_23_37 l_23_37 l_24_37 5.008854e-04
Rlv_23_37 l_23_37 l_23_38 5.008854e-04
Rlh_23_38 l_23_38 l_24_38 5.008854e-04
Rlv_23_38 l_23_38 l_23_39 5.008854e-04
Rlh_23_39 l_23_39 l_24_39 5.008854e-04
Rlv_23_39 l_23_39 l_23_40 5.008854e-04
Rlh_23_40 l_23_40 l_24_40 5.008854e-04
Rlv_23_40 l_23_40 l_23_41 5.008854e-04
Rlh_23_41 l_23_41 l_24_41 5.008854e-04
Rlv_23_41 l_23_41 l_23_42 5.008854e-04
Rlh_23_42 l_23_42 l_24_42 5.008854e-04
Rlv_23_42 l_23_42 l_23_43 5.008854e-04
Rlh_23_43 l_23_43 l_24_43 5.008854e-04
Rlv_23_43 l_23_43 l_23_44 5.008854e-04
Rlh_23_44 l_23_44 l_24_44 5.008854e-04
Rlv_23_44 l_23_44 l_23_45 5.008854e-04
Rlh_23_45 l_23_45 l_24_45 5.008854e-04
Rlv_23_45 l_23_45 l_23_46 5.008854e-04
Rlh_23_46 l_23_46 l_24_46 5.008854e-04
Rlv_23_46 l_23_46 l_23_47 5.008854e-04
Rlh_23_47 l_23_47 l_24_47 5.008854e-04
Rlv_23_47 l_23_47 l_23_48 5.008854e-04
Rlh_23_48 l_23_48 l_24_48 5.008854e-04
Rlv_23_48 l_23_48 l_23_49 5.008854e-04
Rlh_23_49 l_23_49 l_24_49 5.008854e-04
Rlv_23_49 l_23_49 l_23_50 5.008854e-04
Rlh_23_50 l_23_50 l_24_50 5.008854e-04
Rlv_23_50 l_23_50 l_23_51 5.008854e-04
Rlh_23_51 l_23_51 l_24_51 5.008854e-04
Rlv_23_51 l_23_51 l_23_52 5.008854e-04
Rlh_23_52 l_23_52 l_24_52 5.008854e-04
Rlv_23_52 l_23_52 l_23_53 5.008854e-04
Rlh_23_53 l_23_53 l_24_53 5.008854e-04
Rlv_23_53 l_23_53 l_23_54 5.008854e-04
Rlh_23_54 l_23_54 l_24_54 5.008854e-04
Rlv_23_54 l_23_54 l_23_55 5.008854e-04
Rlh_23_55 l_23_55 l_24_55 5.008854e-04
Rlv_23_55 l_23_55 l_23_56 5.008854e-04
Rlh_23_56 l_23_56 l_24_56 5.008854e-04
Rlv_23_56 l_23_56 l_23_57 5.008854e-04
Rlh_23_57 l_23_57 l_24_57 5.008854e-04
Rlv_23_57 l_23_57 l_23_58 5.008854e-04
Rlh_23_58 l_23_58 l_24_58 5.008854e-04
Rlv_23_58 l_23_58 l_23_59 5.008854e-04
Rlh_23_59 l_23_59 l_24_59 5.008854e-04
Rlv_23_59 l_23_59 l_23_60 5.008854e-04
Rlh_23_60 l_23_60 l_24_60 5.008854e-04
Rlv_23_60 l_23_60 l_23_61 5.008854e-04
Rlh_23_61 l_23_61 l_24_61 5.008854e-04
Rlv_23_61 l_23_61 l_23_62 5.008854e-04
Rlh_23_62 l_23_62 l_24_62 5.008854e-04
Rlv_23_62 l_23_62 l_23_63 5.008854e-04
Rlh_23_63 l_23_63 l_24_63 5.008854e-04
Rlv_23_63 l_23_63 l_23_64 5.008854e-04
Rlh_23_64 l_23_64 l_24_64 5.008854e-04
Rlv_23_64 l_23_64 l_23_65 5.008854e-04
Rlh_23_65 l_23_65 l_24_65 5.008854e-04
Rlv_23_65 l_23_65 l_23_66 5.008854e-04
Rlh_23_66 l_23_66 l_24_66 5.008854e-04
Rlv_23_66 l_23_66 l_23_67 5.008854e-04
Rlh_23_67 l_23_67 l_24_67 5.008854e-04
Rlv_23_67 l_23_67 l_23_68 5.008854e-04
Rlh_23_68 l_23_68 l_24_68 5.008854e-04
Rlv_23_68 l_23_68 l_23_69 5.008854e-04
Rlh_23_69 l_23_69 l_24_69 5.008854e-04
Rlv_23_69 l_23_69 l_23_70 5.008854e-04
Rlh_23_70 l_23_70 l_24_70 5.008854e-04
Rlv_23_70 l_23_70 l_23_71 5.008854e-04
Rlh_23_71 l_23_71 l_24_71 5.008854e-04
Rlh_24_0 l_24_0 l_25_0 5.008854e-04
Rlv_24_0 l_24_0 l_24_1 5.008854e-04
Rlh_24_1 l_24_1 l_25_1 5.008854e-04
Rlv_24_1 l_24_1 l_24_2 5.008854e-04
Rlh_24_2 l_24_2 l_25_2 5.008854e-04
Rlv_24_2 l_24_2 l_24_3 5.008854e-04
Rlh_24_3 l_24_3 l_25_3 5.008854e-04
Rlv_24_3 l_24_3 l_24_4 5.008854e-04
Rlh_24_4 l_24_4 l_25_4 5.008854e-04
Rlv_24_4 l_24_4 l_24_5 5.008854e-04
Rlh_24_5 l_24_5 l_25_5 5.008854e-04
Rlv_24_5 l_24_5 l_24_6 5.008854e-04
Rlh_24_6 l_24_6 l_25_6 5.008854e-04
Rlv_24_6 l_24_6 l_24_7 5.008854e-04
Rlh_24_7 l_24_7 l_25_7 5.008854e-04
Rlv_24_7 l_24_7 l_24_8 5.008854e-04
Rlh_24_8 l_24_8 l_25_8 5.008854e-04
Rlv_24_8 l_24_8 l_24_9 5.008854e-04
Rlh_24_9 l_24_9 l_25_9 5.008854e-04
Rlv_24_9 l_24_9 l_24_10 5.008854e-04
Rlh_24_10 l_24_10 l_25_10 5.008854e-04
Rlv_24_10 l_24_10 l_24_11 5.008854e-04
Rlh_24_11 l_24_11 l_25_11 5.008854e-04
Rlv_24_11 l_24_11 l_24_12 5.008854e-04
Rlh_24_12 l_24_12 l_25_12 5.008854e-04
Rlv_24_12 l_24_12 l_24_13 5.008854e-04
Rlh_24_13 l_24_13 l_25_13 5.008854e-04
Rlv_24_13 l_24_13 l_24_14 5.008854e-04
Rlh_24_14 l_24_14 l_25_14 5.008854e-04
Rlv_24_14 l_24_14 l_24_15 5.008854e-04
Rlh_24_15 l_24_15 l_25_15 5.008854e-04
Rlv_24_15 l_24_15 l_24_16 5.008854e-04
Rlh_24_16 l_24_16 l_25_16 5.008854e-04
Rlv_24_16 l_24_16 l_24_17 5.008854e-04
Rlh_24_17 l_24_17 l_25_17 5.008854e-04
Rlv_24_17 l_24_17 l_24_18 5.008854e-04
Rlh_24_18 l_24_18 l_25_18 5.008854e-04
Rlv_24_18 l_24_18 l_24_19 5.008854e-04
Rlh_24_19 l_24_19 l_25_19 5.008854e-04
Rlv_24_19 l_24_19 l_24_20 5.008854e-04
Rlh_24_20 l_24_20 l_25_20 5.008854e-04
Rlv_24_20 l_24_20 l_24_21 5.008854e-04
Rlh_24_21 l_24_21 l_25_21 5.008854e-04
Rlv_24_21 l_24_21 l_24_22 5.008854e-04
Rlh_24_22 l_24_22 l_25_22 5.008854e-04
Rlv_24_22 l_24_22 l_24_23 5.008854e-04
Rlh_24_23 l_24_23 l_25_23 5.008854e-04
Rlv_24_23 l_24_23 l_24_24 5.008854e-04
Rlh_24_24 l_24_24 l_25_24 5.008854e-04
Rlv_24_24 l_24_24 l_24_25 5.008854e-04
Rlh_24_25 l_24_25 l_25_25 5.008854e-04
Rlv_24_25 l_24_25 l_24_26 5.008854e-04
Rlh_24_26 l_24_26 l_25_26 5.008854e-04
Rlv_24_26 l_24_26 l_24_27 5.008854e-04
Rlh_24_27 l_24_27 l_25_27 5.008854e-04
Rlv_24_27 l_24_27 l_24_28 5.008854e-04
Rlh_24_28 l_24_28 l_25_28 5.008854e-04
Rlv_24_28 l_24_28 l_24_29 5.008854e-04
Rlh_24_29 l_24_29 l_25_29 5.008854e-04
Rlv_24_29 l_24_29 l_24_30 5.008854e-04
Rlh_24_30 l_24_30 l_25_30 5.008854e-04
Rlv_24_30 l_24_30 l_24_31 5.008854e-04
Rlh_24_31 l_24_31 l_25_31 5.008854e-04
Rlv_24_31 l_24_31 l_24_32 5.008854e-04
Rlh_24_32 l_24_32 l_25_32 5.008854e-04
Rlv_24_32 l_24_32 l_24_33 5.008854e-04
Rlh_24_33 l_24_33 l_25_33 5.008854e-04
Rlv_24_33 l_24_33 l_24_34 5.008854e-04
Rlh_24_34 l_24_34 l_25_34 5.008854e-04
Rlv_24_34 l_24_34 l_24_35 5.008854e-04
Rlh_24_35 l_24_35 l_25_35 5.008854e-04
Rlv_24_35 l_24_35 l_24_36 5.008854e-04
Rlh_24_36 l_24_36 l_25_36 5.008854e-04
Rlv_24_36 l_24_36 l_24_37 5.008854e-04
Rlh_24_37 l_24_37 l_25_37 5.008854e-04
Rlv_24_37 l_24_37 l_24_38 5.008854e-04
Rlh_24_38 l_24_38 l_25_38 5.008854e-04
Rlv_24_38 l_24_38 l_24_39 5.008854e-04
Rlh_24_39 l_24_39 l_25_39 5.008854e-04
Rlv_24_39 l_24_39 l_24_40 5.008854e-04
Rlh_24_40 l_24_40 l_25_40 5.008854e-04
Rlv_24_40 l_24_40 l_24_41 5.008854e-04
Rlh_24_41 l_24_41 l_25_41 5.008854e-04
Rlv_24_41 l_24_41 l_24_42 5.008854e-04
Rlh_24_42 l_24_42 l_25_42 5.008854e-04
Rlv_24_42 l_24_42 l_24_43 5.008854e-04
Rlh_24_43 l_24_43 l_25_43 5.008854e-04
Rlv_24_43 l_24_43 l_24_44 5.008854e-04
Rlh_24_44 l_24_44 l_25_44 5.008854e-04
Rlv_24_44 l_24_44 l_24_45 5.008854e-04
Rlh_24_45 l_24_45 l_25_45 5.008854e-04
Rlv_24_45 l_24_45 l_24_46 5.008854e-04
Rlh_24_46 l_24_46 l_25_46 5.008854e-04
Rlv_24_46 l_24_46 l_24_47 5.008854e-04
Rlh_24_47 l_24_47 l_25_47 5.008854e-04
Rlv_24_47 l_24_47 l_24_48 5.008854e-04
Rlh_24_48 l_24_48 l_25_48 5.008854e-04
Rlv_24_48 l_24_48 l_24_49 5.008854e-04
Rlh_24_49 l_24_49 l_25_49 5.008854e-04
Rlv_24_49 l_24_49 l_24_50 5.008854e-04
Rlh_24_50 l_24_50 l_25_50 5.008854e-04
Rlv_24_50 l_24_50 l_24_51 5.008854e-04
Rlh_24_51 l_24_51 l_25_51 5.008854e-04
Rlv_24_51 l_24_51 l_24_52 5.008854e-04
Rlh_24_52 l_24_52 l_25_52 5.008854e-04
Rlv_24_52 l_24_52 l_24_53 5.008854e-04
Rlh_24_53 l_24_53 l_25_53 5.008854e-04
Rlv_24_53 l_24_53 l_24_54 5.008854e-04
Rlh_24_54 l_24_54 l_25_54 5.008854e-04
Rlv_24_54 l_24_54 l_24_55 5.008854e-04
Rlh_24_55 l_24_55 l_25_55 5.008854e-04
Rlv_24_55 l_24_55 l_24_56 5.008854e-04
Rlh_24_56 l_24_56 l_25_56 5.008854e-04
Rlv_24_56 l_24_56 l_24_57 5.008854e-04
Rlh_24_57 l_24_57 l_25_57 5.008854e-04
Rlv_24_57 l_24_57 l_24_58 5.008854e-04
Rlh_24_58 l_24_58 l_25_58 5.008854e-04
Rlv_24_58 l_24_58 l_24_59 5.008854e-04
Rlh_24_59 l_24_59 l_25_59 5.008854e-04
Rlv_24_59 l_24_59 l_24_60 5.008854e-04
Rlh_24_60 l_24_60 l_25_60 5.008854e-04
Rlv_24_60 l_24_60 l_24_61 5.008854e-04
Rlh_24_61 l_24_61 l_25_61 5.008854e-04
Rlv_24_61 l_24_61 l_24_62 5.008854e-04
Rlh_24_62 l_24_62 l_25_62 5.008854e-04
Rlv_24_62 l_24_62 l_24_63 5.008854e-04
Rlh_24_63 l_24_63 l_25_63 5.008854e-04
Rlv_24_63 l_24_63 l_24_64 5.008854e-04
Rlh_24_64 l_24_64 l_25_64 5.008854e-04
Rlv_24_64 l_24_64 l_24_65 5.008854e-04
Rlh_24_65 l_24_65 l_25_65 5.008854e-04
Rlv_24_65 l_24_65 l_24_66 5.008854e-04
Rlh_24_66 l_24_66 l_25_66 5.008854e-04
Rlv_24_66 l_24_66 l_24_67 5.008854e-04
Rlh_24_67 l_24_67 l_25_67 5.008854e-04
Rlv_24_67 l_24_67 l_24_68 5.008854e-04
Rlh_24_68 l_24_68 l_25_68 5.008854e-04
Rlv_24_68 l_24_68 l_24_69 5.008854e-04
Rlh_24_69 l_24_69 l_25_69 5.008854e-04
Rlv_24_69 l_24_69 l_24_70 5.008854e-04
Rlh_24_70 l_24_70 l_25_70 5.008854e-04
Rlv_24_70 l_24_70 l_24_71 5.008854e-04
Rlh_24_71 l_24_71 l_25_71 5.008854e-04
Rlh_25_0 l_25_0 l_26_0 5.008854e-04
Rlv_25_0 l_25_0 l_25_1 5.008854e-04
Rlh_25_1 l_25_1 l_26_1 5.008854e-04
Rlv_25_1 l_25_1 l_25_2 5.008854e-04
Rlh_25_2 l_25_2 l_26_2 5.008854e-04
Rlv_25_2 l_25_2 l_25_3 5.008854e-04
Rlh_25_3 l_25_3 l_26_3 5.008854e-04
Rlv_25_3 l_25_3 l_25_4 5.008854e-04
Rlh_25_4 l_25_4 l_26_4 5.008854e-04
Rlv_25_4 l_25_4 l_25_5 5.008854e-04
Rlh_25_5 l_25_5 l_26_5 5.008854e-04
Rlv_25_5 l_25_5 l_25_6 5.008854e-04
Rlh_25_6 l_25_6 l_26_6 5.008854e-04
Rlv_25_6 l_25_6 l_25_7 5.008854e-04
Rlh_25_7 l_25_7 l_26_7 5.008854e-04
Rlv_25_7 l_25_7 l_25_8 5.008854e-04
Rlh_25_8 l_25_8 l_26_8 5.008854e-04
Rlv_25_8 l_25_8 l_25_9 5.008854e-04
Rlh_25_9 l_25_9 l_26_9 5.008854e-04
Rlv_25_9 l_25_9 l_25_10 5.008854e-04
Rlh_25_10 l_25_10 l_26_10 5.008854e-04
Rlv_25_10 l_25_10 l_25_11 5.008854e-04
Rlh_25_11 l_25_11 l_26_11 5.008854e-04
Rlv_25_11 l_25_11 l_25_12 5.008854e-04
Rlh_25_12 l_25_12 l_26_12 5.008854e-04
Rlv_25_12 l_25_12 l_25_13 5.008854e-04
Rlh_25_13 l_25_13 l_26_13 5.008854e-04
Rlv_25_13 l_25_13 l_25_14 5.008854e-04
Rlh_25_14 l_25_14 l_26_14 5.008854e-04
Rlv_25_14 l_25_14 l_25_15 5.008854e-04
Rlh_25_15 l_25_15 l_26_15 5.008854e-04
Rlv_25_15 l_25_15 l_25_16 5.008854e-04
Rlh_25_16 l_25_16 l_26_16 5.008854e-04
Rlv_25_16 l_25_16 l_25_17 5.008854e-04
Rlh_25_17 l_25_17 l_26_17 5.008854e-04
Rlv_25_17 l_25_17 l_25_18 5.008854e-04
Rlh_25_18 l_25_18 l_26_18 5.008854e-04
Rlv_25_18 l_25_18 l_25_19 5.008854e-04
Rlh_25_19 l_25_19 l_26_19 5.008854e-04
Rlv_25_19 l_25_19 l_25_20 5.008854e-04
Rlh_25_20 l_25_20 l_26_20 5.008854e-04
Rlv_25_20 l_25_20 l_25_21 5.008854e-04
Rlh_25_21 l_25_21 l_26_21 5.008854e-04
Rlv_25_21 l_25_21 l_25_22 5.008854e-04
Rlh_25_22 l_25_22 l_26_22 5.008854e-04
Rlv_25_22 l_25_22 l_25_23 5.008854e-04
Rlh_25_23 l_25_23 l_26_23 5.008854e-04
Rlv_25_23 l_25_23 l_25_24 5.008854e-04
Rlh_25_24 l_25_24 l_26_24 5.008854e-04
Rlv_25_24 l_25_24 l_25_25 5.008854e-04
Rlh_25_25 l_25_25 l_26_25 5.008854e-04
Rlv_25_25 l_25_25 l_25_26 5.008854e-04
Rlh_25_26 l_25_26 l_26_26 5.008854e-04
Rlv_25_26 l_25_26 l_25_27 5.008854e-04
Rlh_25_27 l_25_27 l_26_27 5.008854e-04
Rlv_25_27 l_25_27 l_25_28 5.008854e-04
Rlh_25_28 l_25_28 l_26_28 5.008854e-04
Rlv_25_28 l_25_28 l_25_29 5.008854e-04
Rlh_25_29 l_25_29 l_26_29 5.008854e-04
Rlv_25_29 l_25_29 l_25_30 5.008854e-04
Rlh_25_30 l_25_30 l_26_30 5.008854e-04
Rlv_25_30 l_25_30 l_25_31 5.008854e-04
Rlh_25_31 l_25_31 l_26_31 5.008854e-04
Rlv_25_31 l_25_31 l_25_32 5.008854e-04
Rlh_25_32 l_25_32 l_26_32 5.008854e-04
Rlv_25_32 l_25_32 l_25_33 5.008854e-04
Rlh_25_33 l_25_33 l_26_33 5.008854e-04
Rlv_25_33 l_25_33 l_25_34 5.008854e-04
Rlh_25_34 l_25_34 l_26_34 5.008854e-04
Rlv_25_34 l_25_34 l_25_35 5.008854e-04
Rlh_25_35 l_25_35 l_26_35 5.008854e-04
Rlv_25_35 l_25_35 l_25_36 5.008854e-04
Rlh_25_36 l_25_36 l_26_36 5.008854e-04
Rlv_25_36 l_25_36 l_25_37 5.008854e-04
Rlh_25_37 l_25_37 l_26_37 5.008854e-04
Rlv_25_37 l_25_37 l_25_38 5.008854e-04
Rlh_25_38 l_25_38 l_26_38 5.008854e-04
Rlv_25_38 l_25_38 l_25_39 5.008854e-04
Rlh_25_39 l_25_39 l_26_39 5.008854e-04
Rlv_25_39 l_25_39 l_25_40 5.008854e-04
Rlh_25_40 l_25_40 l_26_40 5.008854e-04
Rlv_25_40 l_25_40 l_25_41 5.008854e-04
Rlh_25_41 l_25_41 l_26_41 5.008854e-04
Rlv_25_41 l_25_41 l_25_42 5.008854e-04
Rlh_25_42 l_25_42 l_26_42 5.008854e-04
Rlv_25_42 l_25_42 l_25_43 5.008854e-04
Rlh_25_43 l_25_43 l_26_43 5.008854e-04
Rlv_25_43 l_25_43 l_25_44 5.008854e-04
Rlh_25_44 l_25_44 l_26_44 5.008854e-04
Rlv_25_44 l_25_44 l_25_45 5.008854e-04
Rlh_25_45 l_25_45 l_26_45 5.008854e-04
Rlv_25_45 l_25_45 l_25_46 5.008854e-04
Rlh_25_46 l_25_46 l_26_46 5.008854e-04
Rlv_25_46 l_25_46 l_25_47 5.008854e-04
Rlh_25_47 l_25_47 l_26_47 5.008854e-04
Rlv_25_47 l_25_47 l_25_48 5.008854e-04
Rlh_25_48 l_25_48 l_26_48 5.008854e-04
Rlv_25_48 l_25_48 l_25_49 5.008854e-04
Rlh_25_49 l_25_49 l_26_49 5.008854e-04
Rlv_25_49 l_25_49 l_25_50 5.008854e-04
Rlh_25_50 l_25_50 l_26_50 5.008854e-04
Rlv_25_50 l_25_50 l_25_51 5.008854e-04
Rlh_25_51 l_25_51 l_26_51 5.008854e-04
Rlv_25_51 l_25_51 l_25_52 5.008854e-04
Rlh_25_52 l_25_52 l_26_52 5.008854e-04
Rlv_25_52 l_25_52 l_25_53 5.008854e-04
Rlh_25_53 l_25_53 l_26_53 5.008854e-04
Rlv_25_53 l_25_53 l_25_54 5.008854e-04
Rlh_25_54 l_25_54 l_26_54 5.008854e-04
Rlv_25_54 l_25_54 l_25_55 5.008854e-04
Rlh_25_55 l_25_55 l_26_55 5.008854e-04
Rlv_25_55 l_25_55 l_25_56 5.008854e-04
Rlh_25_56 l_25_56 l_26_56 5.008854e-04
Rlv_25_56 l_25_56 l_25_57 5.008854e-04
Rlh_25_57 l_25_57 l_26_57 5.008854e-04
Rlv_25_57 l_25_57 l_25_58 5.008854e-04
Rlh_25_58 l_25_58 l_26_58 5.008854e-04
Rlv_25_58 l_25_58 l_25_59 5.008854e-04
Rlh_25_59 l_25_59 l_26_59 5.008854e-04
Rlv_25_59 l_25_59 l_25_60 5.008854e-04
Rlh_25_60 l_25_60 l_26_60 5.008854e-04
Rlv_25_60 l_25_60 l_25_61 5.008854e-04
Rlh_25_61 l_25_61 l_26_61 5.008854e-04
Rlv_25_61 l_25_61 l_25_62 5.008854e-04
Rlh_25_62 l_25_62 l_26_62 5.008854e-04
Rlv_25_62 l_25_62 l_25_63 5.008854e-04
Rlh_25_63 l_25_63 l_26_63 5.008854e-04
Rlv_25_63 l_25_63 l_25_64 5.008854e-04
Rlh_25_64 l_25_64 l_26_64 5.008854e-04
Rlv_25_64 l_25_64 l_25_65 5.008854e-04
Rlh_25_65 l_25_65 l_26_65 5.008854e-04
Rlv_25_65 l_25_65 l_25_66 5.008854e-04
Rlh_25_66 l_25_66 l_26_66 5.008854e-04
Rlv_25_66 l_25_66 l_25_67 5.008854e-04
Rlh_25_67 l_25_67 l_26_67 5.008854e-04
Rlv_25_67 l_25_67 l_25_68 5.008854e-04
Rlh_25_68 l_25_68 l_26_68 5.008854e-04
Rlv_25_68 l_25_68 l_25_69 5.008854e-04
Rlh_25_69 l_25_69 l_26_69 5.008854e-04
Rlv_25_69 l_25_69 l_25_70 5.008854e-04
Rlh_25_70 l_25_70 l_26_70 5.008854e-04
Rlv_25_70 l_25_70 l_25_71 5.008854e-04
Rlh_25_71 l_25_71 l_26_71 5.008854e-04
Rlh_26_0 l_26_0 l_27_0 5.008854e-04
Rlv_26_0 l_26_0 l_26_1 5.008854e-04
Rlh_26_1 l_26_1 l_27_1 5.008854e-04
Rlv_26_1 l_26_1 l_26_2 5.008854e-04
Rlh_26_2 l_26_2 l_27_2 5.008854e-04
Rlv_26_2 l_26_2 l_26_3 5.008854e-04
Rlh_26_3 l_26_3 l_27_3 5.008854e-04
Rlv_26_3 l_26_3 l_26_4 5.008854e-04
Rlh_26_4 l_26_4 l_27_4 5.008854e-04
Rlv_26_4 l_26_4 l_26_5 5.008854e-04
Rlh_26_5 l_26_5 l_27_5 5.008854e-04
Rlv_26_5 l_26_5 l_26_6 5.008854e-04
Rlh_26_6 l_26_6 l_27_6 5.008854e-04
Rlv_26_6 l_26_6 l_26_7 5.008854e-04
Rlh_26_7 l_26_7 l_27_7 5.008854e-04
Rlv_26_7 l_26_7 l_26_8 5.008854e-04
Rlh_26_8 l_26_8 l_27_8 5.008854e-04
Rlv_26_8 l_26_8 l_26_9 5.008854e-04
Rlh_26_9 l_26_9 l_27_9 5.008854e-04
Rlv_26_9 l_26_9 l_26_10 5.008854e-04
Rlh_26_10 l_26_10 l_27_10 5.008854e-04
Rlv_26_10 l_26_10 l_26_11 5.008854e-04
Rlh_26_11 l_26_11 l_27_11 5.008854e-04
Rlv_26_11 l_26_11 l_26_12 5.008854e-04
Rlh_26_12 l_26_12 l_27_12 5.008854e-04
Rlv_26_12 l_26_12 l_26_13 5.008854e-04
Rlh_26_13 l_26_13 l_27_13 5.008854e-04
Rlv_26_13 l_26_13 l_26_14 5.008854e-04
Rlh_26_14 l_26_14 l_27_14 5.008854e-04
Rlv_26_14 l_26_14 l_26_15 5.008854e-04
Rlh_26_15 l_26_15 l_27_15 5.008854e-04
Rlv_26_15 l_26_15 l_26_16 5.008854e-04
Rlh_26_16 l_26_16 l_27_16 5.008854e-04
Rlv_26_16 l_26_16 l_26_17 5.008854e-04
Rlh_26_17 l_26_17 l_27_17 5.008854e-04
Rlv_26_17 l_26_17 l_26_18 5.008854e-04
Rlh_26_18 l_26_18 l_27_18 5.008854e-04
Rlv_26_18 l_26_18 l_26_19 5.008854e-04
Rlh_26_19 l_26_19 l_27_19 5.008854e-04
Rlv_26_19 l_26_19 l_26_20 5.008854e-04
Rlh_26_20 l_26_20 l_27_20 5.008854e-04
Rlv_26_20 l_26_20 l_26_21 5.008854e-04
Rlh_26_21 l_26_21 l_27_21 5.008854e-04
Rlv_26_21 l_26_21 l_26_22 5.008854e-04
Rlh_26_22 l_26_22 l_27_22 5.008854e-04
Rlv_26_22 l_26_22 l_26_23 5.008854e-04
Rlh_26_23 l_26_23 l_27_23 5.008854e-04
Rlv_26_23 l_26_23 l_26_24 5.008854e-04
Rlh_26_24 l_26_24 l_27_24 5.008854e-04
Rlv_26_24 l_26_24 l_26_25 5.008854e-04
Rlh_26_25 l_26_25 l_27_25 5.008854e-04
Rlv_26_25 l_26_25 l_26_26 5.008854e-04
Rlh_26_26 l_26_26 l_27_26 5.008854e-04
Rlv_26_26 l_26_26 l_26_27 5.008854e-04
Rlh_26_27 l_26_27 l_27_27 5.008854e-04
Rlv_26_27 l_26_27 l_26_28 5.008854e-04
Rlh_26_28 l_26_28 l_27_28 5.008854e-04
Rlv_26_28 l_26_28 l_26_29 5.008854e-04
Rlh_26_29 l_26_29 l_27_29 5.008854e-04
Rlv_26_29 l_26_29 l_26_30 5.008854e-04
Rlh_26_30 l_26_30 l_27_30 5.008854e-04
Rlv_26_30 l_26_30 l_26_31 5.008854e-04
Rlh_26_31 l_26_31 l_27_31 5.008854e-04
Rlv_26_31 l_26_31 l_26_32 5.008854e-04
Rlh_26_32 l_26_32 l_27_32 5.008854e-04
Rlv_26_32 l_26_32 l_26_33 5.008854e-04
Rlh_26_33 l_26_33 l_27_33 5.008854e-04
Rlv_26_33 l_26_33 l_26_34 5.008854e-04
Rlh_26_34 l_26_34 l_27_34 5.008854e-04
Rlv_26_34 l_26_34 l_26_35 5.008854e-04
Rlh_26_35 l_26_35 l_27_35 5.008854e-04
Rlv_26_35 l_26_35 l_26_36 5.008854e-04
Rlh_26_36 l_26_36 l_27_36 5.008854e-04
Rlv_26_36 l_26_36 l_26_37 5.008854e-04
Rlh_26_37 l_26_37 l_27_37 5.008854e-04
Rlv_26_37 l_26_37 l_26_38 5.008854e-04
Rlh_26_38 l_26_38 l_27_38 5.008854e-04
Rlv_26_38 l_26_38 l_26_39 5.008854e-04
Rlh_26_39 l_26_39 l_27_39 5.008854e-04
Rlv_26_39 l_26_39 l_26_40 5.008854e-04
Rlh_26_40 l_26_40 l_27_40 5.008854e-04
Rlv_26_40 l_26_40 l_26_41 5.008854e-04
Rlh_26_41 l_26_41 l_27_41 5.008854e-04
Rlv_26_41 l_26_41 l_26_42 5.008854e-04
Rlh_26_42 l_26_42 l_27_42 5.008854e-04
Rlv_26_42 l_26_42 l_26_43 5.008854e-04
Rlh_26_43 l_26_43 l_27_43 5.008854e-04
Rlv_26_43 l_26_43 l_26_44 5.008854e-04
Rlh_26_44 l_26_44 l_27_44 5.008854e-04
Rlv_26_44 l_26_44 l_26_45 5.008854e-04
Rlh_26_45 l_26_45 l_27_45 5.008854e-04
Rlv_26_45 l_26_45 l_26_46 5.008854e-04
Rlh_26_46 l_26_46 l_27_46 5.008854e-04
Rlv_26_46 l_26_46 l_26_47 5.008854e-04
Rlh_26_47 l_26_47 l_27_47 5.008854e-04
Rlv_26_47 l_26_47 l_26_48 5.008854e-04
Rlh_26_48 l_26_48 l_27_48 5.008854e-04
Rlv_26_48 l_26_48 l_26_49 5.008854e-04
Rlh_26_49 l_26_49 l_27_49 5.008854e-04
Rlv_26_49 l_26_49 l_26_50 5.008854e-04
Rlh_26_50 l_26_50 l_27_50 5.008854e-04
Rlv_26_50 l_26_50 l_26_51 5.008854e-04
Rlh_26_51 l_26_51 l_27_51 5.008854e-04
Rlv_26_51 l_26_51 l_26_52 5.008854e-04
Rlh_26_52 l_26_52 l_27_52 5.008854e-04
Rlv_26_52 l_26_52 l_26_53 5.008854e-04
Rlh_26_53 l_26_53 l_27_53 5.008854e-04
Rlv_26_53 l_26_53 l_26_54 5.008854e-04
Rlh_26_54 l_26_54 l_27_54 5.008854e-04
Rlv_26_54 l_26_54 l_26_55 5.008854e-04
Rlh_26_55 l_26_55 l_27_55 5.008854e-04
Rlv_26_55 l_26_55 l_26_56 5.008854e-04
Rlh_26_56 l_26_56 l_27_56 5.008854e-04
Rlv_26_56 l_26_56 l_26_57 5.008854e-04
Rlh_26_57 l_26_57 l_27_57 5.008854e-04
Rlv_26_57 l_26_57 l_26_58 5.008854e-04
Rlh_26_58 l_26_58 l_27_58 5.008854e-04
Rlv_26_58 l_26_58 l_26_59 5.008854e-04
Rlh_26_59 l_26_59 l_27_59 5.008854e-04
Rlv_26_59 l_26_59 l_26_60 5.008854e-04
Rlh_26_60 l_26_60 l_27_60 5.008854e-04
Rlv_26_60 l_26_60 l_26_61 5.008854e-04
Rlh_26_61 l_26_61 l_27_61 5.008854e-04
Rlv_26_61 l_26_61 l_26_62 5.008854e-04
Rlh_26_62 l_26_62 l_27_62 5.008854e-04
Rlv_26_62 l_26_62 l_26_63 5.008854e-04
Rlh_26_63 l_26_63 l_27_63 5.008854e-04
Rlv_26_63 l_26_63 l_26_64 5.008854e-04
Rlh_26_64 l_26_64 l_27_64 5.008854e-04
Rlv_26_64 l_26_64 l_26_65 5.008854e-04
Rlh_26_65 l_26_65 l_27_65 5.008854e-04
Rlv_26_65 l_26_65 l_26_66 5.008854e-04
Rlh_26_66 l_26_66 l_27_66 5.008854e-04
Rlv_26_66 l_26_66 l_26_67 5.008854e-04
Rlh_26_67 l_26_67 l_27_67 5.008854e-04
Rlv_26_67 l_26_67 l_26_68 5.008854e-04
Rlh_26_68 l_26_68 l_27_68 5.008854e-04
Rlv_26_68 l_26_68 l_26_69 5.008854e-04
Rlh_26_69 l_26_69 l_27_69 5.008854e-04
Rlv_26_69 l_26_69 l_26_70 5.008854e-04
Rlh_26_70 l_26_70 l_27_70 5.008854e-04
Rlv_26_70 l_26_70 l_26_71 5.008854e-04
Rlh_26_71 l_26_71 l_27_71 5.008854e-04
Rlh_27_0 l_27_0 l_28_0 5.008854e-04
Rlv_27_0 l_27_0 l_27_1 5.008854e-04
Rlh_27_1 l_27_1 l_28_1 5.008854e-04
Rlv_27_1 l_27_1 l_27_2 5.008854e-04
Rlh_27_2 l_27_2 l_28_2 5.008854e-04
Rlv_27_2 l_27_2 l_27_3 5.008854e-04
Rlh_27_3 l_27_3 l_28_3 5.008854e-04
Rlv_27_3 l_27_3 l_27_4 5.008854e-04
Rlh_27_4 l_27_4 l_28_4 5.008854e-04
Rlv_27_4 l_27_4 l_27_5 5.008854e-04
Rlh_27_5 l_27_5 l_28_5 5.008854e-04
Rlv_27_5 l_27_5 l_27_6 5.008854e-04
Rlh_27_6 l_27_6 l_28_6 5.008854e-04
Rlv_27_6 l_27_6 l_27_7 5.008854e-04
Rlh_27_7 l_27_7 l_28_7 5.008854e-04
Rlv_27_7 l_27_7 l_27_8 5.008854e-04
Rlh_27_8 l_27_8 l_28_8 5.008854e-04
Rlv_27_8 l_27_8 l_27_9 5.008854e-04
Rlh_27_9 l_27_9 l_28_9 5.008854e-04
Rlv_27_9 l_27_9 l_27_10 5.008854e-04
Rlh_27_10 l_27_10 l_28_10 5.008854e-04
Rlv_27_10 l_27_10 l_27_11 5.008854e-04
Rlh_27_11 l_27_11 l_28_11 5.008854e-04
Rlv_27_11 l_27_11 l_27_12 5.008854e-04
Rlh_27_12 l_27_12 l_28_12 5.008854e-04
Rlv_27_12 l_27_12 l_27_13 5.008854e-04
Rlh_27_13 l_27_13 l_28_13 5.008854e-04
Rlv_27_13 l_27_13 l_27_14 5.008854e-04
Rlh_27_14 l_27_14 l_28_14 5.008854e-04
Rlv_27_14 l_27_14 l_27_15 5.008854e-04
Rlh_27_15 l_27_15 l_28_15 5.008854e-04
Rlv_27_15 l_27_15 l_27_16 5.008854e-04
Rlh_27_16 l_27_16 l_28_16 5.008854e-04
Rlv_27_16 l_27_16 l_27_17 5.008854e-04
Rlh_27_17 l_27_17 l_28_17 5.008854e-04
Rlv_27_17 l_27_17 l_27_18 5.008854e-04
Rlh_27_18 l_27_18 l_28_18 5.008854e-04
Rlv_27_18 l_27_18 l_27_19 5.008854e-04
Rlh_27_19 l_27_19 l_28_19 5.008854e-04
Rlv_27_19 l_27_19 l_27_20 5.008854e-04
Rlh_27_20 l_27_20 l_28_20 5.008854e-04
Rlv_27_20 l_27_20 l_27_21 5.008854e-04
Rlh_27_21 l_27_21 l_28_21 5.008854e-04
Rlv_27_21 l_27_21 l_27_22 5.008854e-04
Rlh_27_22 l_27_22 l_28_22 5.008854e-04
Rlv_27_22 l_27_22 l_27_23 5.008854e-04
Rlh_27_23 l_27_23 l_28_23 5.008854e-04
Rlv_27_23 l_27_23 l_27_24 5.008854e-04
Rlh_27_24 l_27_24 l_28_24 5.008854e-04
Rlv_27_24 l_27_24 l_27_25 5.008854e-04
Rlh_27_25 l_27_25 l_28_25 5.008854e-04
Rlv_27_25 l_27_25 l_27_26 5.008854e-04
Rlh_27_26 l_27_26 l_28_26 5.008854e-04
Rlv_27_26 l_27_26 l_27_27 5.008854e-04
Rlh_27_27 l_27_27 l_28_27 5.008854e-04
Rlv_27_27 l_27_27 l_27_28 5.008854e-04
Rlh_27_28 l_27_28 l_28_28 5.008854e-04
Rlv_27_28 l_27_28 l_27_29 5.008854e-04
Rlh_27_29 l_27_29 l_28_29 5.008854e-04
Rlv_27_29 l_27_29 l_27_30 5.008854e-04
Rlh_27_30 l_27_30 l_28_30 5.008854e-04
Rlv_27_30 l_27_30 l_27_31 5.008854e-04
Rlh_27_31 l_27_31 l_28_31 5.008854e-04
Rlv_27_31 l_27_31 l_27_32 5.008854e-04
Rlh_27_32 l_27_32 l_28_32 5.008854e-04
Rlv_27_32 l_27_32 l_27_33 5.008854e-04
Rlh_27_33 l_27_33 l_28_33 5.008854e-04
Rlv_27_33 l_27_33 l_27_34 5.008854e-04
Rlh_27_34 l_27_34 l_28_34 5.008854e-04
Rlv_27_34 l_27_34 l_27_35 5.008854e-04
Rlh_27_35 l_27_35 l_28_35 5.008854e-04
Rlv_27_35 l_27_35 l_27_36 5.008854e-04
Rlh_27_36 l_27_36 l_28_36 5.008854e-04
Rlv_27_36 l_27_36 l_27_37 5.008854e-04
Rlh_27_37 l_27_37 l_28_37 5.008854e-04
Rlv_27_37 l_27_37 l_27_38 5.008854e-04
Rlh_27_38 l_27_38 l_28_38 5.008854e-04
Rlv_27_38 l_27_38 l_27_39 5.008854e-04
Rlh_27_39 l_27_39 l_28_39 5.008854e-04
Rlv_27_39 l_27_39 l_27_40 5.008854e-04
Rlh_27_40 l_27_40 l_28_40 5.008854e-04
Rlv_27_40 l_27_40 l_27_41 5.008854e-04
Rlh_27_41 l_27_41 l_28_41 5.008854e-04
Rlv_27_41 l_27_41 l_27_42 5.008854e-04
Rlh_27_42 l_27_42 l_28_42 5.008854e-04
Rlv_27_42 l_27_42 l_27_43 5.008854e-04
Rlh_27_43 l_27_43 l_28_43 5.008854e-04
Rlv_27_43 l_27_43 l_27_44 5.008854e-04
Rlh_27_44 l_27_44 l_28_44 5.008854e-04
Rlv_27_44 l_27_44 l_27_45 5.008854e-04
Rlh_27_45 l_27_45 l_28_45 5.008854e-04
Rlv_27_45 l_27_45 l_27_46 5.008854e-04
Rlh_27_46 l_27_46 l_28_46 5.008854e-04
Rlv_27_46 l_27_46 l_27_47 5.008854e-04
Rlh_27_47 l_27_47 l_28_47 5.008854e-04
Rlv_27_47 l_27_47 l_27_48 5.008854e-04
Rlh_27_48 l_27_48 l_28_48 5.008854e-04
Rlv_27_48 l_27_48 l_27_49 5.008854e-04
Rlh_27_49 l_27_49 l_28_49 5.008854e-04
Rlv_27_49 l_27_49 l_27_50 5.008854e-04
Rlh_27_50 l_27_50 l_28_50 5.008854e-04
Rlv_27_50 l_27_50 l_27_51 5.008854e-04
Rlh_27_51 l_27_51 l_28_51 5.008854e-04
Rlv_27_51 l_27_51 l_27_52 5.008854e-04
Rlh_27_52 l_27_52 l_28_52 5.008854e-04
Rlv_27_52 l_27_52 l_27_53 5.008854e-04
Rlh_27_53 l_27_53 l_28_53 5.008854e-04
Rlv_27_53 l_27_53 l_27_54 5.008854e-04
Rlh_27_54 l_27_54 l_28_54 5.008854e-04
Rlv_27_54 l_27_54 l_27_55 5.008854e-04
Rlh_27_55 l_27_55 l_28_55 5.008854e-04
Rlv_27_55 l_27_55 l_27_56 5.008854e-04
Rlh_27_56 l_27_56 l_28_56 5.008854e-04
Rlv_27_56 l_27_56 l_27_57 5.008854e-04
Rlh_27_57 l_27_57 l_28_57 5.008854e-04
Rlv_27_57 l_27_57 l_27_58 5.008854e-04
Rlh_27_58 l_27_58 l_28_58 5.008854e-04
Rlv_27_58 l_27_58 l_27_59 5.008854e-04
Rlh_27_59 l_27_59 l_28_59 5.008854e-04
Rlv_27_59 l_27_59 l_27_60 5.008854e-04
Rlh_27_60 l_27_60 l_28_60 5.008854e-04
Rlv_27_60 l_27_60 l_27_61 5.008854e-04
Rlh_27_61 l_27_61 l_28_61 5.008854e-04
Rlv_27_61 l_27_61 l_27_62 5.008854e-04
Rlh_27_62 l_27_62 l_28_62 5.008854e-04
Rlv_27_62 l_27_62 l_27_63 5.008854e-04
Rlh_27_63 l_27_63 l_28_63 5.008854e-04
Rlv_27_63 l_27_63 l_27_64 5.008854e-04
Rlh_27_64 l_27_64 l_28_64 5.008854e-04
Rlv_27_64 l_27_64 l_27_65 5.008854e-04
Rlh_27_65 l_27_65 l_28_65 5.008854e-04
Rlv_27_65 l_27_65 l_27_66 5.008854e-04
Rlh_27_66 l_27_66 l_28_66 5.008854e-04
Rlv_27_66 l_27_66 l_27_67 5.008854e-04
Rlh_27_67 l_27_67 l_28_67 5.008854e-04
Rlv_27_67 l_27_67 l_27_68 5.008854e-04
Rlh_27_68 l_27_68 l_28_68 5.008854e-04
Rlv_27_68 l_27_68 l_27_69 5.008854e-04
Rlh_27_69 l_27_69 l_28_69 5.008854e-04
Rlv_27_69 l_27_69 l_27_70 5.008854e-04
Rlh_27_70 l_27_70 l_28_70 5.008854e-04
Rlv_27_70 l_27_70 l_27_71 5.008854e-04
Rlh_27_71 l_27_71 l_28_71 5.008854e-04
Rlh_28_0 l_28_0 l_29_0 5.008854e-04
Rlv_28_0 l_28_0 l_28_1 5.008854e-04
Rlh_28_1 l_28_1 l_29_1 5.008854e-04
Rlv_28_1 l_28_1 l_28_2 5.008854e-04
Rlh_28_2 l_28_2 l_29_2 5.008854e-04
Rlv_28_2 l_28_2 l_28_3 5.008854e-04
Rlh_28_3 l_28_3 l_29_3 5.008854e-04
Rlv_28_3 l_28_3 l_28_4 5.008854e-04
Rlh_28_4 l_28_4 l_29_4 5.008854e-04
Rlv_28_4 l_28_4 l_28_5 5.008854e-04
Rlh_28_5 l_28_5 l_29_5 5.008854e-04
Rlv_28_5 l_28_5 l_28_6 5.008854e-04
Rlh_28_6 l_28_6 l_29_6 5.008854e-04
Rlv_28_6 l_28_6 l_28_7 5.008854e-04
Rlh_28_7 l_28_7 l_29_7 5.008854e-04
Rlv_28_7 l_28_7 l_28_8 5.008854e-04
Rlh_28_8 l_28_8 l_29_8 5.008854e-04
Rlv_28_8 l_28_8 l_28_9 5.008854e-04
Rlh_28_9 l_28_9 l_29_9 5.008854e-04
Rlv_28_9 l_28_9 l_28_10 5.008854e-04
Rlh_28_10 l_28_10 l_29_10 5.008854e-04
Rlv_28_10 l_28_10 l_28_11 5.008854e-04
Rlh_28_11 l_28_11 l_29_11 5.008854e-04
Rlv_28_11 l_28_11 l_28_12 5.008854e-04
Rlh_28_12 l_28_12 l_29_12 5.008854e-04
Rlv_28_12 l_28_12 l_28_13 5.008854e-04
Rlh_28_13 l_28_13 l_29_13 5.008854e-04
Rlv_28_13 l_28_13 l_28_14 5.008854e-04
Rlh_28_14 l_28_14 l_29_14 5.008854e-04
Rlv_28_14 l_28_14 l_28_15 5.008854e-04
Rlh_28_15 l_28_15 l_29_15 5.008854e-04
Rlv_28_15 l_28_15 l_28_16 5.008854e-04
Rlh_28_16 l_28_16 l_29_16 5.008854e-04
Rlv_28_16 l_28_16 l_28_17 5.008854e-04
Rlh_28_17 l_28_17 l_29_17 5.008854e-04
Rlv_28_17 l_28_17 l_28_18 5.008854e-04
Rlh_28_18 l_28_18 l_29_18 5.008854e-04
Rlv_28_18 l_28_18 l_28_19 5.008854e-04
Rlh_28_19 l_28_19 l_29_19 5.008854e-04
Rlv_28_19 l_28_19 l_28_20 5.008854e-04
Rlh_28_20 l_28_20 l_29_20 5.008854e-04
Rlv_28_20 l_28_20 l_28_21 5.008854e-04
Rlh_28_21 l_28_21 l_29_21 5.008854e-04
Rlv_28_21 l_28_21 l_28_22 5.008854e-04
Rlh_28_22 l_28_22 l_29_22 5.008854e-04
Rlv_28_22 l_28_22 l_28_23 5.008854e-04
Rlh_28_23 l_28_23 l_29_23 5.008854e-04
Rlv_28_23 l_28_23 l_28_24 5.008854e-04
Rlh_28_24 l_28_24 l_29_24 5.008854e-04
Rlv_28_24 l_28_24 l_28_25 5.008854e-04
Rlh_28_25 l_28_25 l_29_25 5.008854e-04
Rlv_28_25 l_28_25 l_28_26 5.008854e-04
Rlh_28_26 l_28_26 l_29_26 5.008854e-04
Rlv_28_26 l_28_26 l_28_27 5.008854e-04
Rlh_28_27 l_28_27 l_29_27 5.008854e-04
Rlv_28_27 l_28_27 l_28_28 5.008854e-04
Rlh_28_28 l_28_28 l_29_28 5.008854e-04
Rlv_28_28 l_28_28 l_28_29 5.008854e-04
Rlh_28_29 l_28_29 l_29_29 5.008854e-04
Rlv_28_29 l_28_29 l_28_30 5.008854e-04
Rlh_28_30 l_28_30 l_29_30 5.008854e-04
Rlv_28_30 l_28_30 l_28_31 5.008854e-04
Rlh_28_31 l_28_31 l_29_31 5.008854e-04
Rlv_28_31 l_28_31 l_28_32 5.008854e-04
Rlh_28_32 l_28_32 l_29_32 5.008854e-04
Rlv_28_32 l_28_32 l_28_33 5.008854e-04
Rlh_28_33 l_28_33 l_29_33 5.008854e-04
Rlv_28_33 l_28_33 l_28_34 5.008854e-04
Rlh_28_34 l_28_34 l_29_34 5.008854e-04
Rlv_28_34 l_28_34 l_28_35 5.008854e-04
Rlh_28_35 l_28_35 l_29_35 5.008854e-04
Rlv_28_35 l_28_35 l_28_36 5.008854e-04
Rlh_28_36 l_28_36 l_29_36 5.008854e-04
Rlv_28_36 l_28_36 l_28_37 5.008854e-04
Rlh_28_37 l_28_37 l_29_37 5.008854e-04
Rlv_28_37 l_28_37 l_28_38 5.008854e-04
Rlh_28_38 l_28_38 l_29_38 5.008854e-04
Rlv_28_38 l_28_38 l_28_39 5.008854e-04
Rlh_28_39 l_28_39 l_29_39 5.008854e-04
Rlv_28_39 l_28_39 l_28_40 5.008854e-04
Rlh_28_40 l_28_40 l_29_40 5.008854e-04
Rlv_28_40 l_28_40 l_28_41 5.008854e-04
Rlh_28_41 l_28_41 l_29_41 5.008854e-04
Rlv_28_41 l_28_41 l_28_42 5.008854e-04
Rlh_28_42 l_28_42 l_29_42 5.008854e-04
Rlv_28_42 l_28_42 l_28_43 5.008854e-04
Rlh_28_43 l_28_43 l_29_43 5.008854e-04
Rlv_28_43 l_28_43 l_28_44 5.008854e-04
Rlh_28_44 l_28_44 l_29_44 5.008854e-04
Rlv_28_44 l_28_44 l_28_45 5.008854e-04
Rlh_28_45 l_28_45 l_29_45 5.008854e-04
Rlv_28_45 l_28_45 l_28_46 5.008854e-04
Rlh_28_46 l_28_46 l_29_46 5.008854e-04
Rlv_28_46 l_28_46 l_28_47 5.008854e-04
Rlh_28_47 l_28_47 l_29_47 5.008854e-04
Rlv_28_47 l_28_47 l_28_48 5.008854e-04
Rlh_28_48 l_28_48 l_29_48 5.008854e-04
Rlv_28_48 l_28_48 l_28_49 5.008854e-04
Rlh_28_49 l_28_49 l_29_49 5.008854e-04
Rlv_28_49 l_28_49 l_28_50 5.008854e-04
Rlh_28_50 l_28_50 l_29_50 5.008854e-04
Rlv_28_50 l_28_50 l_28_51 5.008854e-04
Rlh_28_51 l_28_51 l_29_51 5.008854e-04
Rlv_28_51 l_28_51 l_28_52 5.008854e-04
Rlh_28_52 l_28_52 l_29_52 5.008854e-04
Rlv_28_52 l_28_52 l_28_53 5.008854e-04
Rlh_28_53 l_28_53 l_29_53 5.008854e-04
Rlv_28_53 l_28_53 l_28_54 5.008854e-04
Rlh_28_54 l_28_54 l_29_54 5.008854e-04
Rlv_28_54 l_28_54 l_28_55 5.008854e-04
Rlh_28_55 l_28_55 l_29_55 5.008854e-04
Rlv_28_55 l_28_55 l_28_56 5.008854e-04
Rlh_28_56 l_28_56 l_29_56 5.008854e-04
Rlv_28_56 l_28_56 l_28_57 5.008854e-04
Rlh_28_57 l_28_57 l_29_57 5.008854e-04
Rlv_28_57 l_28_57 l_28_58 5.008854e-04
Rlh_28_58 l_28_58 l_29_58 5.008854e-04
Rlv_28_58 l_28_58 l_28_59 5.008854e-04
Rlh_28_59 l_28_59 l_29_59 5.008854e-04
Rlv_28_59 l_28_59 l_28_60 5.008854e-04
Rlh_28_60 l_28_60 l_29_60 5.008854e-04
Rlv_28_60 l_28_60 l_28_61 5.008854e-04
Rlh_28_61 l_28_61 l_29_61 5.008854e-04
Rlv_28_61 l_28_61 l_28_62 5.008854e-04
Rlh_28_62 l_28_62 l_29_62 5.008854e-04
Rlv_28_62 l_28_62 l_28_63 5.008854e-04
Rlh_28_63 l_28_63 l_29_63 5.008854e-04
Rlv_28_63 l_28_63 l_28_64 5.008854e-04
Rlh_28_64 l_28_64 l_29_64 5.008854e-04
Rlv_28_64 l_28_64 l_28_65 5.008854e-04
Rlh_28_65 l_28_65 l_29_65 5.008854e-04
Rlv_28_65 l_28_65 l_28_66 5.008854e-04
Rlh_28_66 l_28_66 l_29_66 5.008854e-04
Rlv_28_66 l_28_66 l_28_67 5.008854e-04
Rlh_28_67 l_28_67 l_29_67 5.008854e-04
Rlv_28_67 l_28_67 l_28_68 5.008854e-04
Rlh_28_68 l_28_68 l_29_68 5.008854e-04
Rlv_28_68 l_28_68 l_28_69 5.008854e-04
Rlh_28_69 l_28_69 l_29_69 5.008854e-04
Rlv_28_69 l_28_69 l_28_70 5.008854e-04
Rlh_28_70 l_28_70 l_29_70 5.008854e-04
Rlv_28_70 l_28_70 l_28_71 5.008854e-04
Rlh_28_71 l_28_71 l_29_71 5.008854e-04
Rlh_29_0 l_29_0 l_30_0 5.008854e-04
Rlv_29_0 l_29_0 l_29_1 5.008854e-04
Rlh_29_1 l_29_1 l_30_1 5.008854e-04
Rlv_29_1 l_29_1 l_29_2 5.008854e-04
Rlh_29_2 l_29_2 l_30_2 5.008854e-04
Rlv_29_2 l_29_2 l_29_3 5.008854e-04
Rlh_29_3 l_29_3 l_30_3 5.008854e-04
Rlv_29_3 l_29_3 l_29_4 5.008854e-04
Rlh_29_4 l_29_4 l_30_4 5.008854e-04
Rlv_29_4 l_29_4 l_29_5 5.008854e-04
Rlh_29_5 l_29_5 l_30_5 5.008854e-04
Rlv_29_5 l_29_5 l_29_6 5.008854e-04
Rlh_29_6 l_29_6 l_30_6 5.008854e-04
Rlv_29_6 l_29_6 l_29_7 5.008854e-04
Rlh_29_7 l_29_7 l_30_7 5.008854e-04
Rlv_29_7 l_29_7 l_29_8 5.008854e-04
Rlh_29_8 l_29_8 l_30_8 5.008854e-04
Rlv_29_8 l_29_8 l_29_9 5.008854e-04
Rlh_29_9 l_29_9 l_30_9 5.008854e-04
Rlv_29_9 l_29_9 l_29_10 5.008854e-04
Rlh_29_10 l_29_10 l_30_10 5.008854e-04
Rlv_29_10 l_29_10 l_29_11 5.008854e-04
Rlh_29_11 l_29_11 l_30_11 5.008854e-04
Rlv_29_11 l_29_11 l_29_12 5.008854e-04
Rlh_29_12 l_29_12 l_30_12 5.008854e-04
Rlv_29_12 l_29_12 l_29_13 5.008854e-04
Rlh_29_13 l_29_13 l_30_13 5.008854e-04
Rlv_29_13 l_29_13 l_29_14 5.008854e-04
Rlh_29_14 l_29_14 l_30_14 5.008854e-04
Rlv_29_14 l_29_14 l_29_15 5.008854e-04
Rlh_29_15 l_29_15 l_30_15 5.008854e-04
Rlv_29_15 l_29_15 l_29_16 5.008854e-04
Rlh_29_16 l_29_16 l_30_16 5.008854e-04
Rlv_29_16 l_29_16 l_29_17 5.008854e-04
Rlh_29_17 l_29_17 l_30_17 5.008854e-04
Rlv_29_17 l_29_17 l_29_18 5.008854e-04
Rlh_29_18 l_29_18 l_30_18 5.008854e-04
Rlv_29_18 l_29_18 l_29_19 5.008854e-04
Rlh_29_19 l_29_19 l_30_19 5.008854e-04
Rlv_29_19 l_29_19 l_29_20 5.008854e-04
Rlh_29_20 l_29_20 l_30_20 5.008854e-04
Rlv_29_20 l_29_20 l_29_21 5.008854e-04
Rlh_29_21 l_29_21 l_30_21 5.008854e-04
Rlv_29_21 l_29_21 l_29_22 5.008854e-04
Rlh_29_22 l_29_22 l_30_22 5.008854e-04
Rlv_29_22 l_29_22 l_29_23 5.008854e-04
Rlh_29_23 l_29_23 l_30_23 5.008854e-04
Rlv_29_23 l_29_23 l_29_24 5.008854e-04
Rlh_29_24 l_29_24 l_30_24 5.008854e-04
Rlv_29_24 l_29_24 l_29_25 5.008854e-04
Rlh_29_25 l_29_25 l_30_25 5.008854e-04
Rlv_29_25 l_29_25 l_29_26 5.008854e-04
Rlh_29_26 l_29_26 l_30_26 5.008854e-04
Rlv_29_26 l_29_26 l_29_27 5.008854e-04
Rlh_29_27 l_29_27 l_30_27 5.008854e-04
Rlv_29_27 l_29_27 l_29_28 5.008854e-04
Rlh_29_28 l_29_28 l_30_28 5.008854e-04
Rlv_29_28 l_29_28 l_29_29 5.008854e-04
Rlh_29_29 l_29_29 l_30_29 5.008854e-04
Rlv_29_29 l_29_29 l_29_30 5.008854e-04
Rlh_29_30 l_29_30 l_30_30 5.008854e-04
Rlv_29_30 l_29_30 l_29_31 5.008854e-04
Rlh_29_31 l_29_31 l_30_31 5.008854e-04
Rlv_29_31 l_29_31 l_29_32 5.008854e-04
Rlh_29_32 l_29_32 l_30_32 5.008854e-04
Rlv_29_32 l_29_32 l_29_33 5.008854e-04
Rlh_29_33 l_29_33 l_30_33 5.008854e-04
Rlv_29_33 l_29_33 l_29_34 5.008854e-04
Rlh_29_34 l_29_34 l_30_34 5.008854e-04
Rlv_29_34 l_29_34 l_29_35 5.008854e-04
Rlh_29_35 l_29_35 l_30_35 5.008854e-04
Rlv_29_35 l_29_35 l_29_36 5.008854e-04
Rlh_29_36 l_29_36 l_30_36 5.008854e-04
Rlv_29_36 l_29_36 l_29_37 5.008854e-04
Rlh_29_37 l_29_37 l_30_37 5.008854e-04
Rlv_29_37 l_29_37 l_29_38 5.008854e-04
Rlh_29_38 l_29_38 l_30_38 5.008854e-04
Rlv_29_38 l_29_38 l_29_39 5.008854e-04
Rlh_29_39 l_29_39 l_30_39 5.008854e-04
Rlv_29_39 l_29_39 l_29_40 5.008854e-04
Rlh_29_40 l_29_40 l_30_40 5.008854e-04
Rlv_29_40 l_29_40 l_29_41 5.008854e-04
Rlh_29_41 l_29_41 l_30_41 5.008854e-04
Rlv_29_41 l_29_41 l_29_42 5.008854e-04
Rlh_29_42 l_29_42 l_30_42 5.008854e-04
Rlv_29_42 l_29_42 l_29_43 5.008854e-04
Rlh_29_43 l_29_43 l_30_43 5.008854e-04
Rlv_29_43 l_29_43 l_29_44 5.008854e-04
Rlh_29_44 l_29_44 l_30_44 5.008854e-04
Rlv_29_44 l_29_44 l_29_45 5.008854e-04
Rlh_29_45 l_29_45 l_30_45 5.008854e-04
Rlv_29_45 l_29_45 l_29_46 5.008854e-04
Rlh_29_46 l_29_46 l_30_46 5.008854e-04
Rlv_29_46 l_29_46 l_29_47 5.008854e-04
Rlh_29_47 l_29_47 l_30_47 5.008854e-04
Rlv_29_47 l_29_47 l_29_48 5.008854e-04
Rlh_29_48 l_29_48 l_30_48 5.008854e-04
Rlv_29_48 l_29_48 l_29_49 5.008854e-04
Rlh_29_49 l_29_49 l_30_49 5.008854e-04
Rlv_29_49 l_29_49 l_29_50 5.008854e-04
Rlh_29_50 l_29_50 l_30_50 5.008854e-04
Rlv_29_50 l_29_50 l_29_51 5.008854e-04
Rlh_29_51 l_29_51 l_30_51 5.008854e-04
Rlv_29_51 l_29_51 l_29_52 5.008854e-04
Rlh_29_52 l_29_52 l_30_52 5.008854e-04
Rlv_29_52 l_29_52 l_29_53 5.008854e-04
Rlh_29_53 l_29_53 l_30_53 5.008854e-04
Rlv_29_53 l_29_53 l_29_54 5.008854e-04
Rlh_29_54 l_29_54 l_30_54 5.008854e-04
Rlv_29_54 l_29_54 l_29_55 5.008854e-04
Rlh_29_55 l_29_55 l_30_55 5.008854e-04
Rlv_29_55 l_29_55 l_29_56 5.008854e-04
Rlh_29_56 l_29_56 l_30_56 5.008854e-04
Rlv_29_56 l_29_56 l_29_57 5.008854e-04
Rlh_29_57 l_29_57 l_30_57 5.008854e-04
Rlv_29_57 l_29_57 l_29_58 5.008854e-04
Rlh_29_58 l_29_58 l_30_58 5.008854e-04
Rlv_29_58 l_29_58 l_29_59 5.008854e-04
Rlh_29_59 l_29_59 l_30_59 5.008854e-04
Rlv_29_59 l_29_59 l_29_60 5.008854e-04
Rlh_29_60 l_29_60 l_30_60 5.008854e-04
Rlv_29_60 l_29_60 l_29_61 5.008854e-04
Rlh_29_61 l_29_61 l_30_61 5.008854e-04
Rlv_29_61 l_29_61 l_29_62 5.008854e-04
Rlh_29_62 l_29_62 l_30_62 5.008854e-04
Rlv_29_62 l_29_62 l_29_63 5.008854e-04
Rlh_29_63 l_29_63 l_30_63 5.008854e-04
Rlv_29_63 l_29_63 l_29_64 5.008854e-04
Rlh_29_64 l_29_64 l_30_64 5.008854e-04
Rlv_29_64 l_29_64 l_29_65 5.008854e-04
Rlh_29_65 l_29_65 l_30_65 5.008854e-04
Rlv_29_65 l_29_65 l_29_66 5.008854e-04
Rlh_29_66 l_29_66 l_30_66 5.008854e-04
Rlv_29_66 l_29_66 l_29_67 5.008854e-04
Rlh_29_67 l_29_67 l_30_67 5.008854e-04
Rlv_29_67 l_29_67 l_29_68 5.008854e-04
Rlh_29_68 l_29_68 l_30_68 5.008854e-04
Rlv_29_68 l_29_68 l_29_69 5.008854e-04
Rlh_29_69 l_29_69 l_30_69 5.008854e-04
Rlv_29_69 l_29_69 l_29_70 5.008854e-04
Rlh_29_70 l_29_70 l_30_70 5.008854e-04
Rlv_29_70 l_29_70 l_29_71 5.008854e-04
Rlh_29_71 l_29_71 l_30_71 5.008854e-04
Rlh_30_0 l_30_0 l_31_0 5.008854e-04
Rlv_30_0 l_30_0 l_30_1 5.008854e-04
Rlh_30_1 l_30_1 l_31_1 5.008854e-04
Rlv_30_1 l_30_1 l_30_2 5.008854e-04
Rlh_30_2 l_30_2 l_31_2 5.008854e-04
Rlv_30_2 l_30_2 l_30_3 5.008854e-04
Rlh_30_3 l_30_3 l_31_3 5.008854e-04
Rlv_30_3 l_30_3 l_30_4 5.008854e-04
Rlh_30_4 l_30_4 l_31_4 5.008854e-04
Rlv_30_4 l_30_4 l_30_5 5.008854e-04
Rlh_30_5 l_30_5 l_31_5 5.008854e-04
Rlv_30_5 l_30_5 l_30_6 5.008854e-04
Rlh_30_6 l_30_6 l_31_6 5.008854e-04
Rlv_30_6 l_30_6 l_30_7 5.008854e-04
Rlh_30_7 l_30_7 l_31_7 5.008854e-04
Rlv_30_7 l_30_7 l_30_8 5.008854e-04
Rlh_30_8 l_30_8 l_31_8 5.008854e-04
Rlv_30_8 l_30_8 l_30_9 5.008854e-04
Rlh_30_9 l_30_9 l_31_9 5.008854e-04
Rlv_30_9 l_30_9 l_30_10 5.008854e-04
Rlh_30_10 l_30_10 l_31_10 5.008854e-04
Rlv_30_10 l_30_10 l_30_11 5.008854e-04
Rlh_30_11 l_30_11 l_31_11 5.008854e-04
Rlv_30_11 l_30_11 l_30_12 5.008854e-04
Rlh_30_12 l_30_12 l_31_12 5.008854e-04
Rlv_30_12 l_30_12 l_30_13 5.008854e-04
Rlh_30_13 l_30_13 l_31_13 5.008854e-04
Rlv_30_13 l_30_13 l_30_14 5.008854e-04
Rlh_30_14 l_30_14 l_31_14 5.008854e-04
Rlv_30_14 l_30_14 l_30_15 5.008854e-04
Rlh_30_15 l_30_15 l_31_15 5.008854e-04
Rlv_30_15 l_30_15 l_30_16 5.008854e-04
Rlh_30_16 l_30_16 l_31_16 5.008854e-04
Rlv_30_16 l_30_16 l_30_17 5.008854e-04
Rlh_30_17 l_30_17 l_31_17 5.008854e-04
Rlv_30_17 l_30_17 l_30_18 5.008854e-04
Rlh_30_18 l_30_18 l_31_18 5.008854e-04
Rlv_30_18 l_30_18 l_30_19 5.008854e-04
Rlh_30_19 l_30_19 l_31_19 5.008854e-04
Rlv_30_19 l_30_19 l_30_20 5.008854e-04
Rlh_30_20 l_30_20 l_31_20 5.008854e-04
Rlv_30_20 l_30_20 l_30_21 5.008854e-04
Rlh_30_21 l_30_21 l_31_21 5.008854e-04
Rlv_30_21 l_30_21 l_30_22 5.008854e-04
Rlh_30_22 l_30_22 l_31_22 5.008854e-04
Rlv_30_22 l_30_22 l_30_23 5.008854e-04
Rlh_30_23 l_30_23 l_31_23 5.008854e-04
Rlv_30_23 l_30_23 l_30_24 5.008854e-04
Rlh_30_24 l_30_24 l_31_24 5.008854e-04
Rlv_30_24 l_30_24 l_30_25 5.008854e-04
Rlh_30_25 l_30_25 l_31_25 5.008854e-04
Rlv_30_25 l_30_25 l_30_26 5.008854e-04
Rlh_30_26 l_30_26 l_31_26 5.008854e-04
Rlv_30_26 l_30_26 l_30_27 5.008854e-04
Rlh_30_27 l_30_27 l_31_27 5.008854e-04
Rlv_30_27 l_30_27 l_30_28 5.008854e-04
Rlh_30_28 l_30_28 l_31_28 5.008854e-04
Rlv_30_28 l_30_28 l_30_29 5.008854e-04
Rlh_30_29 l_30_29 l_31_29 5.008854e-04
Rlv_30_29 l_30_29 l_30_30 5.008854e-04
Rlh_30_30 l_30_30 l_31_30 5.008854e-04
Rlv_30_30 l_30_30 l_30_31 5.008854e-04
Rlh_30_31 l_30_31 l_31_31 5.008854e-04
Rlv_30_31 l_30_31 l_30_32 5.008854e-04
Rlh_30_32 l_30_32 l_31_32 5.008854e-04
Rlv_30_32 l_30_32 l_30_33 5.008854e-04
Rlh_30_33 l_30_33 l_31_33 5.008854e-04
Rlv_30_33 l_30_33 l_30_34 5.008854e-04
Rlh_30_34 l_30_34 l_31_34 5.008854e-04
Rlv_30_34 l_30_34 l_30_35 5.008854e-04
Rlh_30_35 l_30_35 l_31_35 5.008854e-04
Rlv_30_35 l_30_35 l_30_36 5.008854e-04
Rlh_30_36 l_30_36 l_31_36 5.008854e-04
Rlv_30_36 l_30_36 l_30_37 5.008854e-04
Rlh_30_37 l_30_37 l_31_37 5.008854e-04
Rlv_30_37 l_30_37 l_30_38 5.008854e-04
Rlh_30_38 l_30_38 l_31_38 5.008854e-04
Rlv_30_38 l_30_38 l_30_39 5.008854e-04
Rlh_30_39 l_30_39 l_31_39 5.008854e-04
Rlv_30_39 l_30_39 l_30_40 5.008854e-04
Rlh_30_40 l_30_40 l_31_40 5.008854e-04
Rlv_30_40 l_30_40 l_30_41 5.008854e-04
Rlh_30_41 l_30_41 l_31_41 5.008854e-04
Rlv_30_41 l_30_41 l_30_42 5.008854e-04
Rlh_30_42 l_30_42 l_31_42 5.008854e-04
Rlv_30_42 l_30_42 l_30_43 5.008854e-04
Rlh_30_43 l_30_43 l_31_43 5.008854e-04
Rlv_30_43 l_30_43 l_30_44 5.008854e-04
Rlh_30_44 l_30_44 l_31_44 5.008854e-04
Rlv_30_44 l_30_44 l_30_45 5.008854e-04
Rlh_30_45 l_30_45 l_31_45 5.008854e-04
Rlv_30_45 l_30_45 l_30_46 5.008854e-04
Rlh_30_46 l_30_46 l_31_46 5.008854e-04
Rlv_30_46 l_30_46 l_30_47 5.008854e-04
Rlh_30_47 l_30_47 l_31_47 5.008854e-04
Rlv_30_47 l_30_47 l_30_48 5.008854e-04
Rlh_30_48 l_30_48 l_31_48 5.008854e-04
Rlv_30_48 l_30_48 l_30_49 5.008854e-04
Rlh_30_49 l_30_49 l_31_49 5.008854e-04
Rlv_30_49 l_30_49 l_30_50 5.008854e-04
Rlh_30_50 l_30_50 l_31_50 5.008854e-04
Rlv_30_50 l_30_50 l_30_51 5.008854e-04
Rlh_30_51 l_30_51 l_31_51 5.008854e-04
Rlv_30_51 l_30_51 l_30_52 5.008854e-04
Rlh_30_52 l_30_52 l_31_52 5.008854e-04
Rlv_30_52 l_30_52 l_30_53 5.008854e-04
Rlh_30_53 l_30_53 l_31_53 5.008854e-04
Rlv_30_53 l_30_53 l_30_54 5.008854e-04
Rlh_30_54 l_30_54 l_31_54 5.008854e-04
Rlv_30_54 l_30_54 l_30_55 5.008854e-04
Rlh_30_55 l_30_55 l_31_55 5.008854e-04
Rlv_30_55 l_30_55 l_30_56 5.008854e-04
Rlh_30_56 l_30_56 l_31_56 5.008854e-04
Rlv_30_56 l_30_56 l_30_57 5.008854e-04
Rlh_30_57 l_30_57 l_31_57 5.008854e-04
Rlv_30_57 l_30_57 l_30_58 5.008854e-04
Rlh_30_58 l_30_58 l_31_58 5.008854e-04
Rlv_30_58 l_30_58 l_30_59 5.008854e-04
Rlh_30_59 l_30_59 l_31_59 5.008854e-04
Rlv_30_59 l_30_59 l_30_60 5.008854e-04
Rlh_30_60 l_30_60 l_31_60 5.008854e-04
Rlv_30_60 l_30_60 l_30_61 5.008854e-04
Rlh_30_61 l_30_61 l_31_61 5.008854e-04
Rlv_30_61 l_30_61 l_30_62 5.008854e-04
Rlh_30_62 l_30_62 l_31_62 5.008854e-04
Rlv_30_62 l_30_62 l_30_63 5.008854e-04
Rlh_30_63 l_30_63 l_31_63 5.008854e-04
Rlv_30_63 l_30_63 l_30_64 5.008854e-04
Rlh_30_64 l_30_64 l_31_64 5.008854e-04
Rlv_30_64 l_30_64 l_30_65 5.008854e-04
Rlh_30_65 l_30_65 l_31_65 5.008854e-04
Rlv_30_65 l_30_65 l_30_66 5.008854e-04
Rlh_30_66 l_30_66 l_31_66 5.008854e-04
Rlv_30_66 l_30_66 l_30_67 5.008854e-04
Rlh_30_67 l_30_67 l_31_67 5.008854e-04
Rlv_30_67 l_30_67 l_30_68 5.008854e-04
Rlh_30_68 l_30_68 l_31_68 5.008854e-04
Rlv_30_68 l_30_68 l_30_69 5.008854e-04
Rlh_30_69 l_30_69 l_31_69 5.008854e-04
Rlv_30_69 l_30_69 l_30_70 5.008854e-04
Rlh_30_70 l_30_70 l_31_70 5.008854e-04
Rlv_30_70 l_30_70 l_30_71 5.008854e-04
Rlh_30_71 l_30_71 l_31_71 5.008854e-04
Rlh_31_0 l_31_0 l_32_0 5.008854e-04
Rlv_31_0 l_31_0 l_31_1 5.008854e-04
Rlh_31_1 l_31_1 l_32_1 5.008854e-04
Rlv_31_1 l_31_1 l_31_2 5.008854e-04
Rlh_31_2 l_31_2 l_32_2 5.008854e-04
Rlv_31_2 l_31_2 l_31_3 5.008854e-04
Rlh_31_3 l_31_3 l_32_3 5.008854e-04
Rlv_31_3 l_31_3 l_31_4 5.008854e-04
Rlh_31_4 l_31_4 l_32_4 5.008854e-04
Rlv_31_4 l_31_4 l_31_5 5.008854e-04
Rlh_31_5 l_31_5 l_32_5 5.008854e-04
Rlv_31_5 l_31_5 l_31_6 5.008854e-04
Rlh_31_6 l_31_6 l_32_6 5.008854e-04
Rlv_31_6 l_31_6 l_31_7 5.008854e-04
Rlh_31_7 l_31_7 l_32_7 5.008854e-04
Rlv_31_7 l_31_7 l_31_8 5.008854e-04
Rlh_31_8 l_31_8 l_32_8 5.008854e-04
Rlv_31_8 l_31_8 l_31_9 5.008854e-04
Rlh_31_9 l_31_9 l_32_9 5.008854e-04
Rlv_31_9 l_31_9 l_31_10 5.008854e-04
Rlh_31_10 l_31_10 l_32_10 5.008854e-04
Rlv_31_10 l_31_10 l_31_11 5.008854e-04
Rlh_31_11 l_31_11 l_32_11 5.008854e-04
Rlv_31_11 l_31_11 l_31_12 5.008854e-04
Rlh_31_12 l_31_12 l_32_12 5.008854e-04
Rlv_31_12 l_31_12 l_31_13 5.008854e-04
Rlh_31_13 l_31_13 l_32_13 5.008854e-04
Rlv_31_13 l_31_13 l_31_14 5.008854e-04
Rlh_31_14 l_31_14 l_32_14 5.008854e-04
Rlv_31_14 l_31_14 l_31_15 5.008854e-04
Rlh_31_15 l_31_15 l_32_15 5.008854e-04
Rlv_31_15 l_31_15 l_31_16 5.008854e-04
Rlh_31_16 l_31_16 l_32_16 5.008854e-04
Rlv_31_16 l_31_16 l_31_17 5.008854e-04
Rlh_31_17 l_31_17 l_32_17 5.008854e-04
Rlv_31_17 l_31_17 l_31_18 5.008854e-04
Rlh_31_18 l_31_18 l_32_18 5.008854e-04
Rlv_31_18 l_31_18 l_31_19 5.008854e-04
Rlh_31_19 l_31_19 l_32_19 5.008854e-04
Rlv_31_19 l_31_19 l_31_20 5.008854e-04
Rlh_31_20 l_31_20 l_32_20 5.008854e-04
Rlv_31_20 l_31_20 l_31_21 5.008854e-04
Rlh_31_21 l_31_21 l_32_21 5.008854e-04
Rlv_31_21 l_31_21 l_31_22 5.008854e-04
Rlh_31_22 l_31_22 l_32_22 5.008854e-04
Rlv_31_22 l_31_22 l_31_23 5.008854e-04
Rlh_31_23 l_31_23 l_32_23 5.008854e-04
Rlv_31_23 l_31_23 l_31_24 5.008854e-04
Rlh_31_24 l_31_24 l_32_24 5.008854e-04
Rlv_31_24 l_31_24 l_31_25 5.008854e-04
Rlh_31_25 l_31_25 l_32_25 5.008854e-04
Rlv_31_25 l_31_25 l_31_26 5.008854e-04
Rlh_31_26 l_31_26 l_32_26 5.008854e-04
Rlv_31_26 l_31_26 l_31_27 5.008854e-04
Rlh_31_27 l_31_27 l_32_27 5.008854e-04
Rlv_31_27 l_31_27 l_31_28 5.008854e-04
Rlh_31_28 l_31_28 l_32_28 5.008854e-04
Rlv_31_28 l_31_28 l_31_29 5.008854e-04
Rlh_31_29 l_31_29 l_32_29 5.008854e-04
Rlv_31_29 l_31_29 l_31_30 5.008854e-04
Rlh_31_30 l_31_30 l_32_30 5.008854e-04
Rlv_31_30 l_31_30 l_31_31 5.008854e-04
Rlh_31_31 l_31_31 l_32_31 5.008854e-04
Rlv_31_31 l_31_31 l_31_32 5.008854e-04
Rlh_31_32 l_31_32 l_32_32 5.008854e-04
Rlv_31_32 l_31_32 l_31_33 5.008854e-04
Rlh_31_33 l_31_33 l_32_33 5.008854e-04
Rlv_31_33 l_31_33 l_31_34 5.008854e-04
Rlh_31_34 l_31_34 l_32_34 5.008854e-04
Rlv_31_34 l_31_34 l_31_35 5.008854e-04
Rlh_31_35 l_31_35 l_32_35 5.008854e-04
Rlv_31_35 l_31_35 l_31_36 5.008854e-04
Rlh_31_36 l_31_36 l_32_36 5.008854e-04
Rlv_31_36 l_31_36 l_31_37 5.008854e-04
Rlh_31_37 l_31_37 l_32_37 5.008854e-04
Rlv_31_37 l_31_37 l_31_38 5.008854e-04
Rlh_31_38 l_31_38 l_32_38 5.008854e-04
Rlv_31_38 l_31_38 l_31_39 5.008854e-04
Rlh_31_39 l_31_39 l_32_39 5.008854e-04
Rlv_31_39 l_31_39 l_31_40 5.008854e-04
Rlh_31_40 l_31_40 l_32_40 5.008854e-04
Rlv_31_40 l_31_40 l_31_41 5.008854e-04
Rlh_31_41 l_31_41 l_32_41 5.008854e-04
Rlv_31_41 l_31_41 l_31_42 5.008854e-04
Rlh_31_42 l_31_42 l_32_42 5.008854e-04
Rlv_31_42 l_31_42 l_31_43 5.008854e-04
Rlh_31_43 l_31_43 l_32_43 5.008854e-04
Rlv_31_43 l_31_43 l_31_44 5.008854e-04
Rlh_31_44 l_31_44 l_32_44 5.008854e-04
Rlv_31_44 l_31_44 l_31_45 5.008854e-04
Rlh_31_45 l_31_45 l_32_45 5.008854e-04
Rlv_31_45 l_31_45 l_31_46 5.008854e-04
Rlh_31_46 l_31_46 l_32_46 5.008854e-04
Rlv_31_46 l_31_46 l_31_47 5.008854e-04
Rlh_31_47 l_31_47 l_32_47 5.008854e-04
Rlv_31_47 l_31_47 l_31_48 5.008854e-04
Rlh_31_48 l_31_48 l_32_48 5.008854e-04
Rlv_31_48 l_31_48 l_31_49 5.008854e-04
Rlh_31_49 l_31_49 l_32_49 5.008854e-04
Rlv_31_49 l_31_49 l_31_50 5.008854e-04
Rlh_31_50 l_31_50 l_32_50 5.008854e-04
Rlv_31_50 l_31_50 l_31_51 5.008854e-04
Rlh_31_51 l_31_51 l_32_51 5.008854e-04
Rlv_31_51 l_31_51 l_31_52 5.008854e-04
Rlh_31_52 l_31_52 l_32_52 5.008854e-04
Rlv_31_52 l_31_52 l_31_53 5.008854e-04
Rlh_31_53 l_31_53 l_32_53 5.008854e-04
Rlv_31_53 l_31_53 l_31_54 5.008854e-04
Rlh_31_54 l_31_54 l_32_54 5.008854e-04
Rlv_31_54 l_31_54 l_31_55 5.008854e-04
Rlh_31_55 l_31_55 l_32_55 5.008854e-04
Rlv_31_55 l_31_55 l_31_56 5.008854e-04
Rlh_31_56 l_31_56 l_32_56 5.008854e-04
Rlv_31_56 l_31_56 l_31_57 5.008854e-04
Rlh_31_57 l_31_57 l_32_57 5.008854e-04
Rlv_31_57 l_31_57 l_31_58 5.008854e-04
Rlh_31_58 l_31_58 l_32_58 5.008854e-04
Rlv_31_58 l_31_58 l_31_59 5.008854e-04
Rlh_31_59 l_31_59 l_32_59 5.008854e-04
Rlv_31_59 l_31_59 l_31_60 5.008854e-04
Rlh_31_60 l_31_60 l_32_60 5.008854e-04
Rlv_31_60 l_31_60 l_31_61 5.008854e-04
Rlh_31_61 l_31_61 l_32_61 5.008854e-04
Rlv_31_61 l_31_61 l_31_62 5.008854e-04
Rlh_31_62 l_31_62 l_32_62 5.008854e-04
Rlv_31_62 l_31_62 l_31_63 5.008854e-04
Rlh_31_63 l_31_63 l_32_63 5.008854e-04
Rlv_31_63 l_31_63 l_31_64 5.008854e-04
Rlh_31_64 l_31_64 l_32_64 5.008854e-04
Rlv_31_64 l_31_64 l_31_65 5.008854e-04
Rlh_31_65 l_31_65 l_32_65 5.008854e-04
Rlv_31_65 l_31_65 l_31_66 5.008854e-04
Rlh_31_66 l_31_66 l_32_66 5.008854e-04
Rlv_31_66 l_31_66 l_31_67 5.008854e-04
Rlh_31_67 l_31_67 l_32_67 5.008854e-04
Rlv_31_67 l_31_67 l_31_68 5.008854e-04
Rlh_31_68 l_31_68 l_32_68 5.008854e-04
Rlv_31_68 l_31_68 l_31_69 5.008854e-04
Rlh_31_69 l_31_69 l_32_69 5.008854e-04
Rlv_31_69 l_31_69 l_31_70 5.008854e-04
Rlh_31_70 l_31_70 l_32_70 5.008854e-04
Rlv_31_70 l_31_70 l_31_71 5.008854e-04
Rlh_31_71 l_31_71 l_32_71 5.008854e-04
Rlh_32_0 l_32_0 l_33_0 5.008854e-04
Rlv_32_0 l_32_0 l_32_1 5.008854e-04
Rlh_32_1 l_32_1 l_33_1 5.008854e-04
Rlv_32_1 l_32_1 l_32_2 5.008854e-04
Rlh_32_2 l_32_2 l_33_2 5.008854e-04
Rlv_32_2 l_32_2 l_32_3 5.008854e-04
Rlh_32_3 l_32_3 l_33_3 5.008854e-04
Rlv_32_3 l_32_3 l_32_4 5.008854e-04
Rlh_32_4 l_32_4 l_33_4 5.008854e-04
Rlv_32_4 l_32_4 l_32_5 5.008854e-04
Rlh_32_5 l_32_5 l_33_5 5.008854e-04
Rlv_32_5 l_32_5 l_32_6 5.008854e-04
Rlh_32_6 l_32_6 l_33_6 5.008854e-04
Rlv_32_6 l_32_6 l_32_7 5.008854e-04
Rlh_32_7 l_32_7 l_33_7 5.008854e-04
Rlv_32_7 l_32_7 l_32_8 5.008854e-04
Rlh_32_8 l_32_8 l_33_8 5.008854e-04
Rlv_32_8 l_32_8 l_32_9 5.008854e-04
Rlh_32_9 l_32_9 l_33_9 5.008854e-04
Rlv_32_9 l_32_9 l_32_10 5.008854e-04
Rlh_32_10 l_32_10 l_33_10 5.008854e-04
Rlv_32_10 l_32_10 l_32_11 5.008854e-04
Rlh_32_11 l_32_11 l_33_11 5.008854e-04
Rlv_32_11 l_32_11 l_32_12 5.008854e-04
Rlh_32_12 l_32_12 l_33_12 5.008854e-04
Rlv_32_12 l_32_12 l_32_13 5.008854e-04
Rlh_32_13 l_32_13 l_33_13 5.008854e-04
Rlv_32_13 l_32_13 l_32_14 5.008854e-04
Rlh_32_14 l_32_14 l_33_14 5.008854e-04
Rlv_32_14 l_32_14 l_32_15 5.008854e-04
Rlh_32_15 l_32_15 l_33_15 5.008854e-04
Rlv_32_15 l_32_15 l_32_16 5.008854e-04
Rlh_32_16 l_32_16 l_33_16 5.008854e-04
Rlv_32_16 l_32_16 l_32_17 5.008854e-04
Rlh_32_17 l_32_17 l_33_17 5.008854e-04
Rlv_32_17 l_32_17 l_32_18 5.008854e-04
Rlh_32_18 l_32_18 l_33_18 5.008854e-04
Rlv_32_18 l_32_18 l_32_19 5.008854e-04
Rlh_32_19 l_32_19 l_33_19 5.008854e-04
Rlv_32_19 l_32_19 l_32_20 5.008854e-04
Rlh_32_20 l_32_20 l_33_20 5.008854e-04
Rlv_32_20 l_32_20 l_32_21 5.008854e-04
Rlh_32_21 l_32_21 l_33_21 5.008854e-04
Rlv_32_21 l_32_21 l_32_22 5.008854e-04
Rlh_32_22 l_32_22 l_33_22 5.008854e-04
Rlv_32_22 l_32_22 l_32_23 5.008854e-04
Rlh_32_23 l_32_23 l_33_23 5.008854e-04
Rlv_32_23 l_32_23 l_32_24 5.008854e-04
Rlh_32_24 l_32_24 l_33_24 5.008854e-04
Rlv_32_24 l_32_24 l_32_25 5.008854e-04
Rlh_32_25 l_32_25 l_33_25 5.008854e-04
Rlv_32_25 l_32_25 l_32_26 5.008854e-04
Rlh_32_26 l_32_26 l_33_26 5.008854e-04
Rlv_32_26 l_32_26 l_32_27 5.008854e-04
Rlh_32_27 l_32_27 l_33_27 5.008854e-04
Rlv_32_27 l_32_27 l_32_28 5.008854e-04
Rlh_32_28 l_32_28 l_33_28 5.008854e-04
Rlv_32_28 l_32_28 l_32_29 5.008854e-04
Rlh_32_29 l_32_29 l_33_29 5.008854e-04
Rlv_32_29 l_32_29 l_32_30 5.008854e-04
Rlh_32_30 l_32_30 l_33_30 5.008854e-04
Rlv_32_30 l_32_30 l_32_31 5.008854e-04
Rlh_32_31 l_32_31 l_33_31 5.008854e-04
Rlv_32_31 l_32_31 l_32_32 5.008854e-04
Rlh_32_32 l_32_32 l_33_32 5.008854e-04
Rlv_32_32 l_32_32 l_32_33 5.008854e-04
Rlh_32_33 l_32_33 l_33_33 5.008854e-04
Rlv_32_33 l_32_33 l_32_34 5.008854e-04
Rlh_32_34 l_32_34 l_33_34 5.008854e-04
Rlv_32_34 l_32_34 l_32_35 5.008854e-04
Rlh_32_35 l_32_35 l_33_35 5.008854e-04
Rlv_32_35 l_32_35 l_32_36 5.008854e-04
Rlh_32_36 l_32_36 l_33_36 5.008854e-04
Rlv_32_36 l_32_36 l_32_37 5.008854e-04
Rlh_32_37 l_32_37 l_33_37 5.008854e-04
Rlv_32_37 l_32_37 l_32_38 5.008854e-04
Rlh_32_38 l_32_38 l_33_38 5.008854e-04
Rlv_32_38 l_32_38 l_32_39 5.008854e-04
Rlh_32_39 l_32_39 l_33_39 5.008854e-04
Rlv_32_39 l_32_39 l_32_40 5.008854e-04
Rlh_32_40 l_32_40 l_33_40 5.008854e-04
Rlv_32_40 l_32_40 l_32_41 5.008854e-04
Rlh_32_41 l_32_41 l_33_41 5.008854e-04
Rlv_32_41 l_32_41 l_32_42 5.008854e-04
Rlh_32_42 l_32_42 l_33_42 5.008854e-04
Rlv_32_42 l_32_42 l_32_43 5.008854e-04
Rlh_32_43 l_32_43 l_33_43 5.008854e-04
Rlv_32_43 l_32_43 l_32_44 5.008854e-04
Rlh_32_44 l_32_44 l_33_44 5.008854e-04
Rlv_32_44 l_32_44 l_32_45 5.008854e-04
Rlh_32_45 l_32_45 l_33_45 5.008854e-04
Rlv_32_45 l_32_45 l_32_46 5.008854e-04
Rlh_32_46 l_32_46 l_33_46 5.008854e-04
Rlv_32_46 l_32_46 l_32_47 5.008854e-04
Rlh_32_47 l_32_47 l_33_47 5.008854e-04
Rlv_32_47 l_32_47 l_32_48 5.008854e-04
Rlh_32_48 l_32_48 l_33_48 5.008854e-04
Rlv_32_48 l_32_48 l_32_49 5.008854e-04
Rlh_32_49 l_32_49 l_33_49 5.008854e-04
Rlv_32_49 l_32_49 l_32_50 5.008854e-04
Rlh_32_50 l_32_50 l_33_50 5.008854e-04
Rlv_32_50 l_32_50 l_32_51 5.008854e-04
Rlh_32_51 l_32_51 l_33_51 5.008854e-04
Rlv_32_51 l_32_51 l_32_52 5.008854e-04
Rlh_32_52 l_32_52 l_33_52 5.008854e-04
Rlv_32_52 l_32_52 l_32_53 5.008854e-04
Rlh_32_53 l_32_53 l_33_53 5.008854e-04
Rlv_32_53 l_32_53 l_32_54 5.008854e-04
Rlh_32_54 l_32_54 l_33_54 5.008854e-04
Rlv_32_54 l_32_54 l_32_55 5.008854e-04
Rlh_32_55 l_32_55 l_33_55 5.008854e-04
Rlv_32_55 l_32_55 l_32_56 5.008854e-04
Rlh_32_56 l_32_56 l_33_56 5.008854e-04
Rlv_32_56 l_32_56 l_32_57 5.008854e-04
Rlh_32_57 l_32_57 l_33_57 5.008854e-04
Rlv_32_57 l_32_57 l_32_58 5.008854e-04
Rlh_32_58 l_32_58 l_33_58 5.008854e-04
Rlv_32_58 l_32_58 l_32_59 5.008854e-04
Rlh_32_59 l_32_59 l_33_59 5.008854e-04
Rlv_32_59 l_32_59 l_32_60 5.008854e-04
Rlh_32_60 l_32_60 l_33_60 5.008854e-04
Rlv_32_60 l_32_60 l_32_61 5.008854e-04
Rlh_32_61 l_32_61 l_33_61 5.008854e-04
Rlv_32_61 l_32_61 l_32_62 5.008854e-04
Rlh_32_62 l_32_62 l_33_62 5.008854e-04
Rlv_32_62 l_32_62 l_32_63 5.008854e-04
Rlh_32_63 l_32_63 l_33_63 5.008854e-04
Rlv_32_63 l_32_63 l_32_64 5.008854e-04
Rlh_32_64 l_32_64 l_33_64 5.008854e-04
Rlv_32_64 l_32_64 l_32_65 5.008854e-04
Rlh_32_65 l_32_65 l_33_65 5.008854e-04
Rlv_32_65 l_32_65 l_32_66 5.008854e-04
Rlh_32_66 l_32_66 l_33_66 5.008854e-04
Rlv_32_66 l_32_66 l_32_67 5.008854e-04
Rlh_32_67 l_32_67 l_33_67 5.008854e-04
Rlv_32_67 l_32_67 l_32_68 5.008854e-04
Rlh_32_68 l_32_68 l_33_68 5.008854e-04
Rlv_32_68 l_32_68 l_32_69 5.008854e-04
Rlh_32_69 l_32_69 l_33_69 5.008854e-04
Rlv_32_69 l_32_69 l_32_70 5.008854e-04
Rlh_32_70 l_32_70 l_33_70 5.008854e-04
Rlv_32_70 l_32_70 l_32_71 5.008854e-04
Rlh_32_71 l_32_71 l_33_71 5.008854e-04
Rlh_33_0 l_33_0 l_34_0 5.008854e-04
Rlv_33_0 l_33_0 l_33_1 5.008854e-04
Rlh_33_1 l_33_1 l_34_1 5.008854e-04
Rlv_33_1 l_33_1 l_33_2 5.008854e-04
Rlh_33_2 l_33_2 l_34_2 5.008854e-04
Rlv_33_2 l_33_2 l_33_3 5.008854e-04
Rlh_33_3 l_33_3 l_34_3 5.008854e-04
Rlv_33_3 l_33_3 l_33_4 5.008854e-04
Rlh_33_4 l_33_4 l_34_4 5.008854e-04
Rlv_33_4 l_33_4 l_33_5 5.008854e-04
Rlh_33_5 l_33_5 l_34_5 5.008854e-04
Rlv_33_5 l_33_5 l_33_6 5.008854e-04
Rlh_33_6 l_33_6 l_34_6 5.008854e-04
Rlv_33_6 l_33_6 l_33_7 5.008854e-04
Rlh_33_7 l_33_7 l_34_7 5.008854e-04
Rlv_33_7 l_33_7 l_33_8 5.008854e-04
Rlh_33_8 l_33_8 l_34_8 5.008854e-04
Rlv_33_8 l_33_8 l_33_9 5.008854e-04
Rlh_33_9 l_33_9 l_34_9 5.008854e-04
Rlv_33_9 l_33_9 l_33_10 5.008854e-04
Rlh_33_10 l_33_10 l_34_10 5.008854e-04
Rlv_33_10 l_33_10 l_33_11 5.008854e-04
Rlh_33_11 l_33_11 l_34_11 5.008854e-04
Rlv_33_11 l_33_11 l_33_12 5.008854e-04
Rlh_33_12 l_33_12 l_34_12 5.008854e-04
Rlv_33_12 l_33_12 l_33_13 5.008854e-04
Rlh_33_13 l_33_13 l_34_13 5.008854e-04
Rlv_33_13 l_33_13 l_33_14 5.008854e-04
Rlh_33_14 l_33_14 l_34_14 5.008854e-04
Rlv_33_14 l_33_14 l_33_15 5.008854e-04
Rlh_33_15 l_33_15 l_34_15 5.008854e-04
Rlv_33_15 l_33_15 l_33_16 5.008854e-04
Rlh_33_16 l_33_16 l_34_16 5.008854e-04
Rlv_33_16 l_33_16 l_33_17 5.008854e-04
Rlh_33_17 l_33_17 l_34_17 5.008854e-04
Rlv_33_17 l_33_17 l_33_18 5.008854e-04
Rlh_33_18 l_33_18 l_34_18 5.008854e-04
Rlv_33_18 l_33_18 l_33_19 5.008854e-04
Rlh_33_19 l_33_19 l_34_19 5.008854e-04
Rlv_33_19 l_33_19 l_33_20 5.008854e-04
Rlh_33_20 l_33_20 l_34_20 5.008854e-04
Rlv_33_20 l_33_20 l_33_21 5.008854e-04
Rlh_33_21 l_33_21 l_34_21 5.008854e-04
Rlv_33_21 l_33_21 l_33_22 5.008854e-04
Rlh_33_22 l_33_22 l_34_22 5.008854e-04
Rlv_33_22 l_33_22 l_33_23 5.008854e-04
Rlh_33_23 l_33_23 l_34_23 5.008854e-04
Rlv_33_23 l_33_23 l_33_24 5.008854e-04
Rlh_33_24 l_33_24 l_34_24 5.008854e-04
Rlv_33_24 l_33_24 l_33_25 5.008854e-04
Rlh_33_25 l_33_25 l_34_25 5.008854e-04
Rlv_33_25 l_33_25 l_33_26 5.008854e-04
Rlh_33_26 l_33_26 l_34_26 5.008854e-04
Rlv_33_26 l_33_26 l_33_27 5.008854e-04
Rlh_33_27 l_33_27 l_34_27 5.008854e-04
Rlv_33_27 l_33_27 l_33_28 5.008854e-04
Rlh_33_28 l_33_28 l_34_28 5.008854e-04
Rlv_33_28 l_33_28 l_33_29 5.008854e-04
Rlh_33_29 l_33_29 l_34_29 5.008854e-04
Rlv_33_29 l_33_29 l_33_30 5.008854e-04
Rlh_33_30 l_33_30 l_34_30 5.008854e-04
Rlv_33_30 l_33_30 l_33_31 5.008854e-04
Rlh_33_31 l_33_31 l_34_31 5.008854e-04
Rlv_33_31 l_33_31 l_33_32 5.008854e-04
Rlh_33_32 l_33_32 l_34_32 5.008854e-04
Rlv_33_32 l_33_32 l_33_33 5.008854e-04
Rlh_33_33 l_33_33 l_34_33 5.008854e-04
Rlv_33_33 l_33_33 l_33_34 5.008854e-04
Rlh_33_34 l_33_34 l_34_34 5.008854e-04
Rlv_33_34 l_33_34 l_33_35 5.008854e-04
Rlh_33_35 l_33_35 l_34_35 5.008854e-04
Rlv_33_35 l_33_35 l_33_36 5.008854e-04
Rlh_33_36 l_33_36 l_34_36 5.008854e-04
Rlv_33_36 l_33_36 l_33_37 5.008854e-04
Rlh_33_37 l_33_37 l_34_37 5.008854e-04
Rlv_33_37 l_33_37 l_33_38 5.008854e-04
Rlh_33_38 l_33_38 l_34_38 5.008854e-04
Rlv_33_38 l_33_38 l_33_39 5.008854e-04
Rlh_33_39 l_33_39 l_34_39 5.008854e-04
Rlv_33_39 l_33_39 l_33_40 5.008854e-04
Rlh_33_40 l_33_40 l_34_40 5.008854e-04
Rlv_33_40 l_33_40 l_33_41 5.008854e-04
Rlh_33_41 l_33_41 l_34_41 5.008854e-04
Rlv_33_41 l_33_41 l_33_42 5.008854e-04
Rlh_33_42 l_33_42 l_34_42 5.008854e-04
Rlv_33_42 l_33_42 l_33_43 5.008854e-04
Rlh_33_43 l_33_43 l_34_43 5.008854e-04
Rlv_33_43 l_33_43 l_33_44 5.008854e-04
Rlh_33_44 l_33_44 l_34_44 5.008854e-04
Rlv_33_44 l_33_44 l_33_45 5.008854e-04
Rlh_33_45 l_33_45 l_34_45 5.008854e-04
Rlv_33_45 l_33_45 l_33_46 5.008854e-04
Rlh_33_46 l_33_46 l_34_46 5.008854e-04
Rlv_33_46 l_33_46 l_33_47 5.008854e-04
Rlh_33_47 l_33_47 l_34_47 5.008854e-04
Rlv_33_47 l_33_47 l_33_48 5.008854e-04
Rlh_33_48 l_33_48 l_34_48 5.008854e-04
Rlv_33_48 l_33_48 l_33_49 5.008854e-04
Rlh_33_49 l_33_49 l_34_49 5.008854e-04
Rlv_33_49 l_33_49 l_33_50 5.008854e-04
Rlh_33_50 l_33_50 l_34_50 5.008854e-04
Rlv_33_50 l_33_50 l_33_51 5.008854e-04
Rlh_33_51 l_33_51 l_34_51 5.008854e-04
Rlv_33_51 l_33_51 l_33_52 5.008854e-04
Rlh_33_52 l_33_52 l_34_52 5.008854e-04
Rlv_33_52 l_33_52 l_33_53 5.008854e-04
Rlh_33_53 l_33_53 l_34_53 5.008854e-04
Rlv_33_53 l_33_53 l_33_54 5.008854e-04
Rlh_33_54 l_33_54 l_34_54 5.008854e-04
Rlv_33_54 l_33_54 l_33_55 5.008854e-04
Rlh_33_55 l_33_55 l_34_55 5.008854e-04
Rlv_33_55 l_33_55 l_33_56 5.008854e-04
Rlh_33_56 l_33_56 l_34_56 5.008854e-04
Rlv_33_56 l_33_56 l_33_57 5.008854e-04
Rlh_33_57 l_33_57 l_34_57 5.008854e-04
Rlv_33_57 l_33_57 l_33_58 5.008854e-04
Rlh_33_58 l_33_58 l_34_58 5.008854e-04
Rlv_33_58 l_33_58 l_33_59 5.008854e-04
Rlh_33_59 l_33_59 l_34_59 5.008854e-04
Rlv_33_59 l_33_59 l_33_60 5.008854e-04
Rlh_33_60 l_33_60 l_34_60 5.008854e-04
Rlv_33_60 l_33_60 l_33_61 5.008854e-04
Rlh_33_61 l_33_61 l_34_61 5.008854e-04
Rlv_33_61 l_33_61 l_33_62 5.008854e-04
Rlh_33_62 l_33_62 l_34_62 5.008854e-04
Rlv_33_62 l_33_62 l_33_63 5.008854e-04
Rlh_33_63 l_33_63 l_34_63 5.008854e-04
Rlv_33_63 l_33_63 l_33_64 5.008854e-04
Rlh_33_64 l_33_64 l_34_64 5.008854e-04
Rlv_33_64 l_33_64 l_33_65 5.008854e-04
Rlh_33_65 l_33_65 l_34_65 5.008854e-04
Rlv_33_65 l_33_65 l_33_66 5.008854e-04
Rlh_33_66 l_33_66 l_34_66 5.008854e-04
Rlv_33_66 l_33_66 l_33_67 5.008854e-04
Rlh_33_67 l_33_67 l_34_67 5.008854e-04
Rlv_33_67 l_33_67 l_33_68 5.008854e-04
Rlh_33_68 l_33_68 l_34_68 5.008854e-04
Rlv_33_68 l_33_68 l_33_69 5.008854e-04
Rlh_33_69 l_33_69 l_34_69 5.008854e-04
Rlv_33_69 l_33_69 l_33_70 5.008854e-04
Rlh_33_70 l_33_70 l_34_70 5.008854e-04
Rlv_33_70 l_33_70 l_33_71 5.008854e-04
Rlh_33_71 l_33_71 l_34_71 5.008854e-04
Rlh_34_0 l_34_0 l_35_0 5.008854e-04
Rlv_34_0 l_34_0 l_34_1 5.008854e-04
Rlh_34_1 l_34_1 l_35_1 5.008854e-04
Rlv_34_1 l_34_1 l_34_2 5.008854e-04
Rlh_34_2 l_34_2 l_35_2 5.008854e-04
Rlv_34_2 l_34_2 l_34_3 5.008854e-04
Rlh_34_3 l_34_3 l_35_3 5.008854e-04
Rlv_34_3 l_34_3 l_34_4 5.008854e-04
Rlh_34_4 l_34_4 l_35_4 5.008854e-04
Rlv_34_4 l_34_4 l_34_5 5.008854e-04
Rlh_34_5 l_34_5 l_35_5 5.008854e-04
Rlv_34_5 l_34_5 l_34_6 5.008854e-04
Rlh_34_6 l_34_6 l_35_6 5.008854e-04
Rlv_34_6 l_34_6 l_34_7 5.008854e-04
Rlh_34_7 l_34_7 l_35_7 5.008854e-04
Rlv_34_7 l_34_7 l_34_8 5.008854e-04
Rlh_34_8 l_34_8 l_35_8 5.008854e-04
Rlv_34_8 l_34_8 l_34_9 5.008854e-04
Rlh_34_9 l_34_9 l_35_9 5.008854e-04
Rlv_34_9 l_34_9 l_34_10 5.008854e-04
Rlh_34_10 l_34_10 l_35_10 5.008854e-04
Rlv_34_10 l_34_10 l_34_11 5.008854e-04
Rlh_34_11 l_34_11 l_35_11 5.008854e-04
Rlv_34_11 l_34_11 l_34_12 5.008854e-04
Rlh_34_12 l_34_12 l_35_12 5.008854e-04
Rlv_34_12 l_34_12 l_34_13 5.008854e-04
Rlh_34_13 l_34_13 l_35_13 5.008854e-04
Rlv_34_13 l_34_13 l_34_14 5.008854e-04
Rlh_34_14 l_34_14 l_35_14 5.008854e-04
Rlv_34_14 l_34_14 l_34_15 5.008854e-04
Rlh_34_15 l_34_15 l_35_15 5.008854e-04
Rlv_34_15 l_34_15 l_34_16 5.008854e-04
Rlh_34_16 l_34_16 l_35_16 5.008854e-04
Rlv_34_16 l_34_16 l_34_17 5.008854e-04
Rlh_34_17 l_34_17 l_35_17 5.008854e-04
Rlv_34_17 l_34_17 l_34_18 5.008854e-04
Rlh_34_18 l_34_18 l_35_18 5.008854e-04
Rlv_34_18 l_34_18 l_34_19 5.008854e-04
Rlh_34_19 l_34_19 l_35_19 5.008854e-04
Rlv_34_19 l_34_19 l_34_20 5.008854e-04
Rlh_34_20 l_34_20 l_35_20 5.008854e-04
Rlv_34_20 l_34_20 l_34_21 5.008854e-04
Rlh_34_21 l_34_21 l_35_21 5.008854e-04
Rlv_34_21 l_34_21 l_34_22 5.008854e-04
Rlh_34_22 l_34_22 l_35_22 5.008854e-04
Rlv_34_22 l_34_22 l_34_23 5.008854e-04
Rlh_34_23 l_34_23 l_35_23 5.008854e-04
Rlv_34_23 l_34_23 l_34_24 5.008854e-04
Rlh_34_24 l_34_24 l_35_24 5.008854e-04
Rlv_34_24 l_34_24 l_34_25 5.008854e-04
Rlh_34_25 l_34_25 l_35_25 5.008854e-04
Rlv_34_25 l_34_25 l_34_26 5.008854e-04
Rlh_34_26 l_34_26 l_35_26 5.008854e-04
Rlv_34_26 l_34_26 l_34_27 5.008854e-04
Rlh_34_27 l_34_27 l_35_27 5.008854e-04
Rlv_34_27 l_34_27 l_34_28 5.008854e-04
Rlh_34_28 l_34_28 l_35_28 5.008854e-04
Rlv_34_28 l_34_28 l_34_29 5.008854e-04
Rlh_34_29 l_34_29 l_35_29 5.008854e-04
Rlv_34_29 l_34_29 l_34_30 5.008854e-04
Rlh_34_30 l_34_30 l_35_30 5.008854e-04
Rlv_34_30 l_34_30 l_34_31 5.008854e-04
Rlh_34_31 l_34_31 l_35_31 5.008854e-04
Rlv_34_31 l_34_31 l_34_32 5.008854e-04
Rlh_34_32 l_34_32 l_35_32 5.008854e-04
Rlv_34_32 l_34_32 l_34_33 5.008854e-04
Rlh_34_33 l_34_33 l_35_33 5.008854e-04
Rlv_34_33 l_34_33 l_34_34 5.008854e-04
Rlh_34_34 l_34_34 l_35_34 5.008854e-04
Rlv_34_34 l_34_34 l_34_35 5.008854e-04
Rlh_34_35 l_34_35 l_35_35 5.008854e-04
Rlv_34_35 l_34_35 l_34_36 5.008854e-04
Rlh_34_36 l_34_36 l_35_36 5.008854e-04
Rlv_34_36 l_34_36 l_34_37 5.008854e-04
Rlh_34_37 l_34_37 l_35_37 5.008854e-04
Rlv_34_37 l_34_37 l_34_38 5.008854e-04
Rlh_34_38 l_34_38 l_35_38 5.008854e-04
Rlv_34_38 l_34_38 l_34_39 5.008854e-04
Rlh_34_39 l_34_39 l_35_39 5.008854e-04
Rlv_34_39 l_34_39 l_34_40 5.008854e-04
Rlh_34_40 l_34_40 l_35_40 5.008854e-04
Rlv_34_40 l_34_40 l_34_41 5.008854e-04
Rlh_34_41 l_34_41 l_35_41 5.008854e-04
Rlv_34_41 l_34_41 l_34_42 5.008854e-04
Rlh_34_42 l_34_42 l_35_42 5.008854e-04
Rlv_34_42 l_34_42 l_34_43 5.008854e-04
Rlh_34_43 l_34_43 l_35_43 5.008854e-04
Rlv_34_43 l_34_43 l_34_44 5.008854e-04
Rlh_34_44 l_34_44 l_35_44 5.008854e-04
Rlv_34_44 l_34_44 l_34_45 5.008854e-04
Rlh_34_45 l_34_45 l_35_45 5.008854e-04
Rlv_34_45 l_34_45 l_34_46 5.008854e-04
Rlh_34_46 l_34_46 l_35_46 5.008854e-04
Rlv_34_46 l_34_46 l_34_47 5.008854e-04
Rlh_34_47 l_34_47 l_35_47 5.008854e-04
Rlv_34_47 l_34_47 l_34_48 5.008854e-04
Rlh_34_48 l_34_48 l_35_48 5.008854e-04
Rlv_34_48 l_34_48 l_34_49 5.008854e-04
Rlh_34_49 l_34_49 l_35_49 5.008854e-04
Rlv_34_49 l_34_49 l_34_50 5.008854e-04
Rlh_34_50 l_34_50 l_35_50 5.008854e-04
Rlv_34_50 l_34_50 l_34_51 5.008854e-04
Rlh_34_51 l_34_51 l_35_51 5.008854e-04
Rlv_34_51 l_34_51 l_34_52 5.008854e-04
Rlh_34_52 l_34_52 l_35_52 5.008854e-04
Rlv_34_52 l_34_52 l_34_53 5.008854e-04
Rlh_34_53 l_34_53 l_35_53 5.008854e-04
Rlv_34_53 l_34_53 l_34_54 5.008854e-04
Rlh_34_54 l_34_54 l_35_54 5.008854e-04
Rlv_34_54 l_34_54 l_34_55 5.008854e-04
Rlh_34_55 l_34_55 l_35_55 5.008854e-04
Rlv_34_55 l_34_55 l_34_56 5.008854e-04
Rlh_34_56 l_34_56 l_35_56 5.008854e-04
Rlv_34_56 l_34_56 l_34_57 5.008854e-04
Rlh_34_57 l_34_57 l_35_57 5.008854e-04
Rlv_34_57 l_34_57 l_34_58 5.008854e-04
Rlh_34_58 l_34_58 l_35_58 5.008854e-04
Rlv_34_58 l_34_58 l_34_59 5.008854e-04
Rlh_34_59 l_34_59 l_35_59 5.008854e-04
Rlv_34_59 l_34_59 l_34_60 5.008854e-04
Rlh_34_60 l_34_60 l_35_60 5.008854e-04
Rlv_34_60 l_34_60 l_34_61 5.008854e-04
Rlh_34_61 l_34_61 l_35_61 5.008854e-04
Rlv_34_61 l_34_61 l_34_62 5.008854e-04
Rlh_34_62 l_34_62 l_35_62 5.008854e-04
Rlv_34_62 l_34_62 l_34_63 5.008854e-04
Rlh_34_63 l_34_63 l_35_63 5.008854e-04
Rlv_34_63 l_34_63 l_34_64 5.008854e-04
Rlh_34_64 l_34_64 l_35_64 5.008854e-04
Rlv_34_64 l_34_64 l_34_65 5.008854e-04
Rlh_34_65 l_34_65 l_35_65 5.008854e-04
Rlv_34_65 l_34_65 l_34_66 5.008854e-04
Rlh_34_66 l_34_66 l_35_66 5.008854e-04
Rlv_34_66 l_34_66 l_34_67 5.008854e-04
Rlh_34_67 l_34_67 l_35_67 5.008854e-04
Rlv_34_67 l_34_67 l_34_68 5.008854e-04
Rlh_34_68 l_34_68 l_35_68 5.008854e-04
Rlv_34_68 l_34_68 l_34_69 5.008854e-04
Rlh_34_69 l_34_69 l_35_69 5.008854e-04
Rlv_34_69 l_34_69 l_34_70 5.008854e-04
Rlh_34_70 l_34_70 l_35_70 5.008854e-04
Rlv_34_70 l_34_70 l_34_71 5.008854e-04
Rlh_34_71 l_34_71 l_35_71 5.008854e-04
Rlh_35_0 l_35_0 l_36_0 5.008854e-04
Rlv_35_0 l_35_0 l_35_1 5.008854e-04
Rlh_35_1 l_35_1 l_36_1 5.008854e-04
Rlv_35_1 l_35_1 l_35_2 5.008854e-04
Rlh_35_2 l_35_2 l_36_2 5.008854e-04
Rlv_35_2 l_35_2 l_35_3 5.008854e-04
Rlh_35_3 l_35_3 l_36_3 5.008854e-04
Rlv_35_3 l_35_3 l_35_4 5.008854e-04
Rlh_35_4 l_35_4 l_36_4 5.008854e-04
Rlv_35_4 l_35_4 l_35_5 5.008854e-04
Rlh_35_5 l_35_5 l_36_5 5.008854e-04
Rlv_35_5 l_35_5 l_35_6 5.008854e-04
Rlh_35_6 l_35_6 l_36_6 5.008854e-04
Rlv_35_6 l_35_6 l_35_7 5.008854e-04
Rlh_35_7 l_35_7 l_36_7 5.008854e-04
Rlv_35_7 l_35_7 l_35_8 5.008854e-04
Rlh_35_8 l_35_8 l_36_8 5.008854e-04
Rlv_35_8 l_35_8 l_35_9 5.008854e-04
Rlh_35_9 l_35_9 l_36_9 5.008854e-04
Rlv_35_9 l_35_9 l_35_10 5.008854e-04
Rlh_35_10 l_35_10 l_36_10 5.008854e-04
Rlv_35_10 l_35_10 l_35_11 5.008854e-04
Rlh_35_11 l_35_11 l_36_11 5.008854e-04
Rlv_35_11 l_35_11 l_35_12 5.008854e-04
Rlh_35_12 l_35_12 l_36_12 5.008854e-04
Rlv_35_12 l_35_12 l_35_13 5.008854e-04
Rlh_35_13 l_35_13 l_36_13 5.008854e-04
Rlv_35_13 l_35_13 l_35_14 5.008854e-04
Rlh_35_14 l_35_14 l_36_14 5.008854e-04
Rlv_35_14 l_35_14 l_35_15 5.008854e-04
Rlh_35_15 l_35_15 l_36_15 5.008854e-04
Rlv_35_15 l_35_15 l_35_16 5.008854e-04
Rlh_35_16 l_35_16 l_36_16 5.008854e-04
Rlv_35_16 l_35_16 l_35_17 5.008854e-04
Rlh_35_17 l_35_17 l_36_17 5.008854e-04
Rlv_35_17 l_35_17 l_35_18 5.008854e-04
Rlh_35_18 l_35_18 l_36_18 5.008854e-04
Rlv_35_18 l_35_18 l_35_19 5.008854e-04
Rlh_35_19 l_35_19 l_36_19 5.008854e-04
Rlv_35_19 l_35_19 l_35_20 5.008854e-04
Rlh_35_20 l_35_20 l_36_20 5.008854e-04
Rlv_35_20 l_35_20 l_35_21 5.008854e-04
Rlh_35_21 l_35_21 l_36_21 5.008854e-04
Rlv_35_21 l_35_21 l_35_22 5.008854e-04
Rlh_35_22 l_35_22 l_36_22 5.008854e-04
Rlv_35_22 l_35_22 l_35_23 5.008854e-04
Rlh_35_23 l_35_23 l_36_23 5.008854e-04
Rlv_35_23 l_35_23 l_35_24 5.008854e-04
Rlh_35_24 l_35_24 l_36_24 5.008854e-04
Rlv_35_24 l_35_24 l_35_25 5.008854e-04
Rlh_35_25 l_35_25 l_36_25 5.008854e-04
Rlv_35_25 l_35_25 l_35_26 5.008854e-04
Rlh_35_26 l_35_26 l_36_26 5.008854e-04
Rlv_35_26 l_35_26 l_35_27 5.008854e-04
Rlh_35_27 l_35_27 l_36_27 5.008854e-04
Rlv_35_27 l_35_27 l_35_28 5.008854e-04
Rlh_35_28 l_35_28 l_36_28 5.008854e-04
Rlv_35_28 l_35_28 l_35_29 5.008854e-04
Rlh_35_29 l_35_29 l_36_29 5.008854e-04
Rlv_35_29 l_35_29 l_35_30 5.008854e-04
Rlh_35_30 l_35_30 l_36_30 5.008854e-04
Rlv_35_30 l_35_30 l_35_31 5.008854e-04
Rlh_35_31 l_35_31 l_36_31 5.008854e-04
Rlv_35_31 l_35_31 l_35_32 5.008854e-04
Rlh_35_32 l_35_32 l_36_32 5.008854e-04
Rlv_35_32 l_35_32 l_35_33 5.008854e-04
Rlh_35_33 l_35_33 l_36_33 5.008854e-04
Rlv_35_33 l_35_33 l_35_34 5.008854e-04
Rlh_35_34 l_35_34 l_36_34 5.008854e-04
Rlv_35_34 l_35_34 l_35_35 5.008854e-04
Rlh_35_35 l_35_35 l_36_35 5.008854e-04
Rlv_35_35 l_35_35 l_35_36 5.008854e-04
Rlh_35_36 l_35_36 l_36_36 5.008854e-04
Rlv_35_36 l_35_36 l_35_37 5.008854e-04
Rlh_35_37 l_35_37 l_36_37 5.008854e-04
Rlv_35_37 l_35_37 l_35_38 5.008854e-04
Rlh_35_38 l_35_38 l_36_38 5.008854e-04
Rlv_35_38 l_35_38 l_35_39 5.008854e-04
Rlh_35_39 l_35_39 l_36_39 5.008854e-04
Rlv_35_39 l_35_39 l_35_40 5.008854e-04
Rlh_35_40 l_35_40 l_36_40 5.008854e-04
Rlv_35_40 l_35_40 l_35_41 5.008854e-04
Rlh_35_41 l_35_41 l_36_41 5.008854e-04
Rlv_35_41 l_35_41 l_35_42 5.008854e-04
Rlh_35_42 l_35_42 l_36_42 5.008854e-04
Rlv_35_42 l_35_42 l_35_43 5.008854e-04
Rlh_35_43 l_35_43 l_36_43 5.008854e-04
Rlv_35_43 l_35_43 l_35_44 5.008854e-04
Rlh_35_44 l_35_44 l_36_44 5.008854e-04
Rlv_35_44 l_35_44 l_35_45 5.008854e-04
Rlh_35_45 l_35_45 l_36_45 5.008854e-04
Rlv_35_45 l_35_45 l_35_46 5.008854e-04
Rlh_35_46 l_35_46 l_36_46 5.008854e-04
Rlv_35_46 l_35_46 l_35_47 5.008854e-04
Rlh_35_47 l_35_47 l_36_47 5.008854e-04
Rlv_35_47 l_35_47 l_35_48 5.008854e-04
Rlh_35_48 l_35_48 l_36_48 5.008854e-04
Rlv_35_48 l_35_48 l_35_49 5.008854e-04
Rlh_35_49 l_35_49 l_36_49 5.008854e-04
Rlv_35_49 l_35_49 l_35_50 5.008854e-04
Rlh_35_50 l_35_50 l_36_50 5.008854e-04
Rlv_35_50 l_35_50 l_35_51 5.008854e-04
Rlh_35_51 l_35_51 l_36_51 5.008854e-04
Rlv_35_51 l_35_51 l_35_52 5.008854e-04
Rlh_35_52 l_35_52 l_36_52 5.008854e-04
Rlv_35_52 l_35_52 l_35_53 5.008854e-04
Rlh_35_53 l_35_53 l_36_53 5.008854e-04
Rlv_35_53 l_35_53 l_35_54 5.008854e-04
Rlh_35_54 l_35_54 l_36_54 5.008854e-04
Rlv_35_54 l_35_54 l_35_55 5.008854e-04
Rlh_35_55 l_35_55 l_36_55 5.008854e-04
Rlv_35_55 l_35_55 l_35_56 5.008854e-04
Rlh_35_56 l_35_56 l_36_56 5.008854e-04
Rlv_35_56 l_35_56 l_35_57 5.008854e-04
Rlh_35_57 l_35_57 l_36_57 5.008854e-04
Rlv_35_57 l_35_57 l_35_58 5.008854e-04
Rlh_35_58 l_35_58 l_36_58 5.008854e-04
Rlv_35_58 l_35_58 l_35_59 5.008854e-04
Rlh_35_59 l_35_59 l_36_59 5.008854e-04
Rlv_35_59 l_35_59 l_35_60 5.008854e-04
Rlh_35_60 l_35_60 l_36_60 5.008854e-04
Rlv_35_60 l_35_60 l_35_61 5.008854e-04
Rlh_35_61 l_35_61 l_36_61 5.008854e-04
Rlv_35_61 l_35_61 l_35_62 5.008854e-04
Rlh_35_62 l_35_62 l_36_62 5.008854e-04
Rlv_35_62 l_35_62 l_35_63 5.008854e-04
Rlh_35_63 l_35_63 l_36_63 5.008854e-04
Rlv_35_63 l_35_63 l_35_64 5.008854e-04
Rlh_35_64 l_35_64 l_36_64 5.008854e-04
Rlv_35_64 l_35_64 l_35_65 5.008854e-04
Rlh_35_65 l_35_65 l_36_65 5.008854e-04
Rlv_35_65 l_35_65 l_35_66 5.008854e-04
Rlh_35_66 l_35_66 l_36_66 5.008854e-04
Rlv_35_66 l_35_66 l_35_67 5.008854e-04
Rlh_35_67 l_35_67 l_36_67 5.008854e-04
Rlv_35_67 l_35_67 l_35_68 5.008854e-04
Rlh_35_68 l_35_68 l_36_68 5.008854e-04
Rlv_35_68 l_35_68 l_35_69 5.008854e-04
Rlh_35_69 l_35_69 l_36_69 5.008854e-04
Rlv_35_69 l_35_69 l_35_70 5.008854e-04
Rlh_35_70 l_35_70 l_36_70 5.008854e-04
Rlv_35_70 l_35_70 l_35_71 5.008854e-04
Rlh_35_71 l_35_71 l_36_71 5.008854e-04
Rlh_36_0 l_36_0 l_37_0 5.008854e-04
Rlv_36_0 l_36_0 l_36_1 5.008854e-04
Rlh_36_1 l_36_1 l_37_1 5.008854e-04
Rlv_36_1 l_36_1 l_36_2 5.008854e-04
Rlh_36_2 l_36_2 l_37_2 5.008854e-04
Rlv_36_2 l_36_2 l_36_3 5.008854e-04
Rlh_36_3 l_36_3 l_37_3 5.008854e-04
Rlv_36_3 l_36_3 l_36_4 5.008854e-04
Rlh_36_4 l_36_4 l_37_4 5.008854e-04
Rlv_36_4 l_36_4 l_36_5 5.008854e-04
Rlh_36_5 l_36_5 l_37_5 5.008854e-04
Rlv_36_5 l_36_5 l_36_6 5.008854e-04
Rlh_36_6 l_36_6 l_37_6 5.008854e-04
Rlv_36_6 l_36_6 l_36_7 5.008854e-04
Rlh_36_7 l_36_7 l_37_7 5.008854e-04
Rlv_36_7 l_36_7 l_36_8 5.008854e-04
Rlh_36_8 l_36_8 l_37_8 5.008854e-04
Rlv_36_8 l_36_8 l_36_9 5.008854e-04
Rlh_36_9 l_36_9 l_37_9 5.008854e-04
Rlv_36_9 l_36_9 l_36_10 5.008854e-04
Rlh_36_10 l_36_10 l_37_10 5.008854e-04
Rlv_36_10 l_36_10 l_36_11 5.008854e-04
Rlh_36_11 l_36_11 l_37_11 5.008854e-04
Rlv_36_11 l_36_11 l_36_12 5.008854e-04
Rlh_36_12 l_36_12 l_37_12 5.008854e-04
Rlv_36_12 l_36_12 l_36_13 5.008854e-04
Rlh_36_13 l_36_13 l_37_13 5.008854e-04
Rlv_36_13 l_36_13 l_36_14 5.008854e-04
Rlh_36_14 l_36_14 l_37_14 5.008854e-04
Rlv_36_14 l_36_14 l_36_15 5.008854e-04
Rlh_36_15 l_36_15 l_37_15 5.008854e-04
Rlv_36_15 l_36_15 l_36_16 5.008854e-04
Rlh_36_16 l_36_16 l_37_16 5.008854e-04
Rlv_36_16 l_36_16 l_36_17 5.008854e-04
Rlh_36_17 l_36_17 l_37_17 5.008854e-04
Rlv_36_17 l_36_17 l_36_18 5.008854e-04
Rlh_36_18 l_36_18 l_37_18 5.008854e-04
Rlv_36_18 l_36_18 l_36_19 5.008854e-04
Rlh_36_19 l_36_19 l_37_19 5.008854e-04
Rlv_36_19 l_36_19 l_36_20 5.008854e-04
Rlh_36_20 l_36_20 l_37_20 5.008854e-04
Rlv_36_20 l_36_20 l_36_21 5.008854e-04
Rlh_36_21 l_36_21 l_37_21 5.008854e-04
Rlv_36_21 l_36_21 l_36_22 5.008854e-04
Rlh_36_22 l_36_22 l_37_22 5.008854e-04
Rlv_36_22 l_36_22 l_36_23 5.008854e-04
Rlh_36_23 l_36_23 l_37_23 5.008854e-04
Rlv_36_23 l_36_23 l_36_24 5.008854e-04
Rlh_36_24 l_36_24 l_37_24 5.008854e-04
Rlv_36_24 l_36_24 l_36_25 5.008854e-04
Rlh_36_25 l_36_25 l_37_25 5.008854e-04
Rlv_36_25 l_36_25 l_36_26 5.008854e-04
Rlh_36_26 l_36_26 l_37_26 5.008854e-04
Rlv_36_26 l_36_26 l_36_27 5.008854e-04
Rlh_36_27 l_36_27 l_37_27 5.008854e-04
Rlv_36_27 l_36_27 l_36_28 5.008854e-04
Rlh_36_28 l_36_28 l_37_28 5.008854e-04
Rlv_36_28 l_36_28 l_36_29 5.008854e-04
Rlh_36_29 l_36_29 l_37_29 5.008854e-04
Rlv_36_29 l_36_29 l_36_30 5.008854e-04
Rlh_36_30 l_36_30 l_37_30 5.008854e-04
Rlv_36_30 l_36_30 l_36_31 5.008854e-04
Rlh_36_31 l_36_31 l_37_31 5.008854e-04
Rlv_36_31 l_36_31 l_36_32 5.008854e-04
Rlh_36_32 l_36_32 l_37_32 5.008854e-04
Rlv_36_32 l_36_32 l_36_33 5.008854e-04
Rlh_36_33 l_36_33 l_37_33 5.008854e-04
Rlv_36_33 l_36_33 l_36_34 5.008854e-04
Rlh_36_34 l_36_34 l_37_34 5.008854e-04
Rlv_36_34 l_36_34 l_36_35 5.008854e-04
Rlh_36_35 l_36_35 l_37_35 5.008854e-04
Rlv_36_35 l_36_35 l_36_36 5.008854e-04
Rlh_36_36 l_36_36 l_37_36 5.008854e-04
Rlv_36_36 l_36_36 l_36_37 5.008854e-04
Rlh_36_37 l_36_37 l_37_37 5.008854e-04
Rlv_36_37 l_36_37 l_36_38 5.008854e-04
Rlh_36_38 l_36_38 l_37_38 5.008854e-04
Rlv_36_38 l_36_38 l_36_39 5.008854e-04
Rlh_36_39 l_36_39 l_37_39 5.008854e-04
Rlv_36_39 l_36_39 l_36_40 5.008854e-04
Rlh_36_40 l_36_40 l_37_40 5.008854e-04
Rlv_36_40 l_36_40 l_36_41 5.008854e-04
Rlh_36_41 l_36_41 l_37_41 5.008854e-04
Rlv_36_41 l_36_41 l_36_42 5.008854e-04
Rlh_36_42 l_36_42 l_37_42 5.008854e-04
Rlv_36_42 l_36_42 l_36_43 5.008854e-04
Rlh_36_43 l_36_43 l_37_43 5.008854e-04
Rlv_36_43 l_36_43 l_36_44 5.008854e-04
Rlh_36_44 l_36_44 l_37_44 5.008854e-04
Rlv_36_44 l_36_44 l_36_45 5.008854e-04
Rlh_36_45 l_36_45 l_37_45 5.008854e-04
Rlv_36_45 l_36_45 l_36_46 5.008854e-04
Rlh_36_46 l_36_46 l_37_46 5.008854e-04
Rlv_36_46 l_36_46 l_36_47 5.008854e-04
Rlh_36_47 l_36_47 l_37_47 5.008854e-04
Rlv_36_47 l_36_47 l_36_48 5.008854e-04
Rlh_36_48 l_36_48 l_37_48 5.008854e-04
Rlv_36_48 l_36_48 l_36_49 5.008854e-04
Rlh_36_49 l_36_49 l_37_49 5.008854e-04
Rlv_36_49 l_36_49 l_36_50 5.008854e-04
Rlh_36_50 l_36_50 l_37_50 5.008854e-04
Rlv_36_50 l_36_50 l_36_51 5.008854e-04
Rlh_36_51 l_36_51 l_37_51 5.008854e-04
Rlv_36_51 l_36_51 l_36_52 5.008854e-04
Rlh_36_52 l_36_52 l_37_52 5.008854e-04
Rlv_36_52 l_36_52 l_36_53 5.008854e-04
Rlh_36_53 l_36_53 l_37_53 5.008854e-04
Rlv_36_53 l_36_53 l_36_54 5.008854e-04
Rlh_36_54 l_36_54 l_37_54 5.008854e-04
Rlv_36_54 l_36_54 l_36_55 5.008854e-04
Rlh_36_55 l_36_55 l_37_55 5.008854e-04
Rlv_36_55 l_36_55 l_36_56 5.008854e-04
Rlh_36_56 l_36_56 l_37_56 5.008854e-04
Rlv_36_56 l_36_56 l_36_57 5.008854e-04
Rlh_36_57 l_36_57 l_37_57 5.008854e-04
Rlv_36_57 l_36_57 l_36_58 5.008854e-04
Rlh_36_58 l_36_58 l_37_58 5.008854e-04
Rlv_36_58 l_36_58 l_36_59 5.008854e-04
Rlh_36_59 l_36_59 l_37_59 5.008854e-04
Rlv_36_59 l_36_59 l_36_60 5.008854e-04
Rlh_36_60 l_36_60 l_37_60 5.008854e-04
Rlv_36_60 l_36_60 l_36_61 5.008854e-04
Rlh_36_61 l_36_61 l_37_61 5.008854e-04
Rlv_36_61 l_36_61 l_36_62 5.008854e-04
Rlh_36_62 l_36_62 l_37_62 5.008854e-04
Rlv_36_62 l_36_62 l_36_63 5.008854e-04
Rlh_36_63 l_36_63 l_37_63 5.008854e-04
Rlv_36_63 l_36_63 l_36_64 5.008854e-04
Rlh_36_64 l_36_64 l_37_64 5.008854e-04
Rlv_36_64 l_36_64 l_36_65 5.008854e-04
Rlh_36_65 l_36_65 l_37_65 5.008854e-04
Rlv_36_65 l_36_65 l_36_66 5.008854e-04
Rlh_36_66 l_36_66 l_37_66 5.008854e-04
Rlv_36_66 l_36_66 l_36_67 5.008854e-04
Rlh_36_67 l_36_67 l_37_67 5.008854e-04
Rlv_36_67 l_36_67 l_36_68 5.008854e-04
Rlh_36_68 l_36_68 l_37_68 5.008854e-04
Rlv_36_68 l_36_68 l_36_69 5.008854e-04
Rlh_36_69 l_36_69 l_37_69 5.008854e-04
Rlv_36_69 l_36_69 l_36_70 5.008854e-04
Rlh_36_70 l_36_70 l_37_70 5.008854e-04
Rlv_36_70 l_36_70 l_36_71 5.008854e-04
Rlh_36_71 l_36_71 l_37_71 5.008854e-04
Rlh_37_0 l_37_0 l_38_0 5.008854e-04
Rlv_37_0 l_37_0 l_37_1 5.008854e-04
Rlh_37_1 l_37_1 l_38_1 5.008854e-04
Rlv_37_1 l_37_1 l_37_2 5.008854e-04
Rlh_37_2 l_37_2 l_38_2 5.008854e-04
Rlv_37_2 l_37_2 l_37_3 5.008854e-04
Rlh_37_3 l_37_3 l_38_3 5.008854e-04
Rlv_37_3 l_37_3 l_37_4 5.008854e-04
Rlh_37_4 l_37_4 l_38_4 5.008854e-04
Rlv_37_4 l_37_4 l_37_5 5.008854e-04
Rlh_37_5 l_37_5 l_38_5 5.008854e-04
Rlv_37_5 l_37_5 l_37_6 5.008854e-04
Rlh_37_6 l_37_6 l_38_6 5.008854e-04
Rlv_37_6 l_37_6 l_37_7 5.008854e-04
Rlh_37_7 l_37_7 l_38_7 5.008854e-04
Rlv_37_7 l_37_7 l_37_8 5.008854e-04
Rlh_37_8 l_37_8 l_38_8 5.008854e-04
Rlv_37_8 l_37_8 l_37_9 5.008854e-04
Rlh_37_9 l_37_9 l_38_9 5.008854e-04
Rlv_37_9 l_37_9 l_37_10 5.008854e-04
Rlh_37_10 l_37_10 l_38_10 5.008854e-04
Rlv_37_10 l_37_10 l_37_11 5.008854e-04
Rlh_37_11 l_37_11 l_38_11 5.008854e-04
Rlv_37_11 l_37_11 l_37_12 5.008854e-04
Rlh_37_12 l_37_12 l_38_12 5.008854e-04
Rlv_37_12 l_37_12 l_37_13 5.008854e-04
Rlh_37_13 l_37_13 l_38_13 5.008854e-04
Rlv_37_13 l_37_13 l_37_14 5.008854e-04
Rlh_37_14 l_37_14 l_38_14 5.008854e-04
Rlv_37_14 l_37_14 l_37_15 5.008854e-04
Rlh_37_15 l_37_15 l_38_15 5.008854e-04
Rlv_37_15 l_37_15 l_37_16 5.008854e-04
Rlh_37_16 l_37_16 l_38_16 5.008854e-04
Rlv_37_16 l_37_16 l_37_17 5.008854e-04
Rlh_37_17 l_37_17 l_38_17 5.008854e-04
Rlv_37_17 l_37_17 l_37_18 5.008854e-04
Rlh_37_18 l_37_18 l_38_18 5.008854e-04
Rlv_37_18 l_37_18 l_37_19 5.008854e-04
Rlh_37_19 l_37_19 l_38_19 5.008854e-04
Rlv_37_19 l_37_19 l_37_20 5.008854e-04
Rlh_37_20 l_37_20 l_38_20 5.008854e-04
Rlv_37_20 l_37_20 l_37_21 5.008854e-04
Rlh_37_21 l_37_21 l_38_21 5.008854e-04
Rlv_37_21 l_37_21 l_37_22 5.008854e-04
Rlh_37_22 l_37_22 l_38_22 5.008854e-04
Rlv_37_22 l_37_22 l_37_23 5.008854e-04
Rlh_37_23 l_37_23 l_38_23 5.008854e-04
Rlv_37_23 l_37_23 l_37_24 5.008854e-04
Rlh_37_24 l_37_24 l_38_24 5.008854e-04
Rlv_37_24 l_37_24 l_37_25 5.008854e-04
Rlh_37_25 l_37_25 l_38_25 5.008854e-04
Rlv_37_25 l_37_25 l_37_26 5.008854e-04
Rlh_37_26 l_37_26 l_38_26 5.008854e-04
Rlv_37_26 l_37_26 l_37_27 5.008854e-04
Rlh_37_27 l_37_27 l_38_27 5.008854e-04
Rlv_37_27 l_37_27 l_37_28 5.008854e-04
Rlh_37_28 l_37_28 l_38_28 5.008854e-04
Rlv_37_28 l_37_28 l_37_29 5.008854e-04
Rlh_37_29 l_37_29 l_38_29 5.008854e-04
Rlv_37_29 l_37_29 l_37_30 5.008854e-04
Rlh_37_30 l_37_30 l_38_30 5.008854e-04
Rlv_37_30 l_37_30 l_37_31 5.008854e-04
Rlh_37_31 l_37_31 l_38_31 5.008854e-04
Rlv_37_31 l_37_31 l_37_32 5.008854e-04
Rlh_37_32 l_37_32 l_38_32 5.008854e-04
Rlv_37_32 l_37_32 l_37_33 5.008854e-04
Rlh_37_33 l_37_33 l_38_33 5.008854e-04
Rlv_37_33 l_37_33 l_37_34 5.008854e-04
Rlh_37_34 l_37_34 l_38_34 5.008854e-04
Rlv_37_34 l_37_34 l_37_35 5.008854e-04
Rlh_37_35 l_37_35 l_38_35 5.008854e-04
Rlv_37_35 l_37_35 l_37_36 5.008854e-04
Rlh_37_36 l_37_36 l_38_36 5.008854e-04
Rlv_37_36 l_37_36 l_37_37 5.008854e-04
Rlh_37_37 l_37_37 l_38_37 5.008854e-04
Rlv_37_37 l_37_37 l_37_38 5.008854e-04
Rlh_37_38 l_37_38 l_38_38 5.008854e-04
Rlv_37_38 l_37_38 l_37_39 5.008854e-04
Rlh_37_39 l_37_39 l_38_39 5.008854e-04
Rlv_37_39 l_37_39 l_37_40 5.008854e-04
Rlh_37_40 l_37_40 l_38_40 5.008854e-04
Rlv_37_40 l_37_40 l_37_41 5.008854e-04
Rlh_37_41 l_37_41 l_38_41 5.008854e-04
Rlv_37_41 l_37_41 l_37_42 5.008854e-04
Rlh_37_42 l_37_42 l_38_42 5.008854e-04
Rlv_37_42 l_37_42 l_37_43 5.008854e-04
Rlh_37_43 l_37_43 l_38_43 5.008854e-04
Rlv_37_43 l_37_43 l_37_44 5.008854e-04
Rlh_37_44 l_37_44 l_38_44 5.008854e-04
Rlv_37_44 l_37_44 l_37_45 5.008854e-04
Rlh_37_45 l_37_45 l_38_45 5.008854e-04
Rlv_37_45 l_37_45 l_37_46 5.008854e-04
Rlh_37_46 l_37_46 l_38_46 5.008854e-04
Rlv_37_46 l_37_46 l_37_47 5.008854e-04
Rlh_37_47 l_37_47 l_38_47 5.008854e-04
Rlv_37_47 l_37_47 l_37_48 5.008854e-04
Rlh_37_48 l_37_48 l_38_48 5.008854e-04
Rlv_37_48 l_37_48 l_37_49 5.008854e-04
Rlh_37_49 l_37_49 l_38_49 5.008854e-04
Rlv_37_49 l_37_49 l_37_50 5.008854e-04
Rlh_37_50 l_37_50 l_38_50 5.008854e-04
Rlv_37_50 l_37_50 l_37_51 5.008854e-04
Rlh_37_51 l_37_51 l_38_51 5.008854e-04
Rlv_37_51 l_37_51 l_37_52 5.008854e-04
Rlh_37_52 l_37_52 l_38_52 5.008854e-04
Rlv_37_52 l_37_52 l_37_53 5.008854e-04
Rlh_37_53 l_37_53 l_38_53 5.008854e-04
Rlv_37_53 l_37_53 l_37_54 5.008854e-04
Rlh_37_54 l_37_54 l_38_54 5.008854e-04
Rlv_37_54 l_37_54 l_37_55 5.008854e-04
Rlh_37_55 l_37_55 l_38_55 5.008854e-04
Rlv_37_55 l_37_55 l_37_56 5.008854e-04
Rlh_37_56 l_37_56 l_38_56 5.008854e-04
Rlv_37_56 l_37_56 l_37_57 5.008854e-04
Rlh_37_57 l_37_57 l_38_57 5.008854e-04
Rlv_37_57 l_37_57 l_37_58 5.008854e-04
Rlh_37_58 l_37_58 l_38_58 5.008854e-04
Rlv_37_58 l_37_58 l_37_59 5.008854e-04
Rlh_37_59 l_37_59 l_38_59 5.008854e-04
Rlv_37_59 l_37_59 l_37_60 5.008854e-04
Rlh_37_60 l_37_60 l_38_60 5.008854e-04
Rlv_37_60 l_37_60 l_37_61 5.008854e-04
Rlh_37_61 l_37_61 l_38_61 5.008854e-04
Rlv_37_61 l_37_61 l_37_62 5.008854e-04
Rlh_37_62 l_37_62 l_38_62 5.008854e-04
Rlv_37_62 l_37_62 l_37_63 5.008854e-04
Rlh_37_63 l_37_63 l_38_63 5.008854e-04
Rlv_37_63 l_37_63 l_37_64 5.008854e-04
Rlh_37_64 l_37_64 l_38_64 5.008854e-04
Rlv_37_64 l_37_64 l_37_65 5.008854e-04
Rlh_37_65 l_37_65 l_38_65 5.008854e-04
Rlv_37_65 l_37_65 l_37_66 5.008854e-04
Rlh_37_66 l_37_66 l_38_66 5.008854e-04
Rlv_37_66 l_37_66 l_37_67 5.008854e-04
Rlh_37_67 l_37_67 l_38_67 5.008854e-04
Rlv_37_67 l_37_67 l_37_68 5.008854e-04
Rlh_37_68 l_37_68 l_38_68 5.008854e-04
Rlv_37_68 l_37_68 l_37_69 5.008854e-04
Rlh_37_69 l_37_69 l_38_69 5.008854e-04
Rlv_37_69 l_37_69 l_37_70 5.008854e-04
Rlh_37_70 l_37_70 l_38_70 5.008854e-04
Rlv_37_70 l_37_70 l_37_71 5.008854e-04
Rlh_37_71 l_37_71 l_38_71 5.008854e-04
Rlh_38_0 l_38_0 l_39_0 5.008854e-04
Rlv_38_0 l_38_0 l_38_1 5.008854e-04
Rlh_38_1 l_38_1 l_39_1 5.008854e-04
Rlv_38_1 l_38_1 l_38_2 5.008854e-04
Rlh_38_2 l_38_2 l_39_2 5.008854e-04
Rlv_38_2 l_38_2 l_38_3 5.008854e-04
Rlh_38_3 l_38_3 l_39_3 5.008854e-04
Rlv_38_3 l_38_3 l_38_4 5.008854e-04
Rlh_38_4 l_38_4 l_39_4 5.008854e-04
Rlv_38_4 l_38_4 l_38_5 5.008854e-04
Rlh_38_5 l_38_5 l_39_5 5.008854e-04
Rlv_38_5 l_38_5 l_38_6 5.008854e-04
Rlh_38_6 l_38_6 l_39_6 5.008854e-04
Rlv_38_6 l_38_6 l_38_7 5.008854e-04
Rlh_38_7 l_38_7 l_39_7 5.008854e-04
Rlv_38_7 l_38_7 l_38_8 5.008854e-04
Rlh_38_8 l_38_8 l_39_8 5.008854e-04
Rlv_38_8 l_38_8 l_38_9 5.008854e-04
Rlh_38_9 l_38_9 l_39_9 5.008854e-04
Rlv_38_9 l_38_9 l_38_10 5.008854e-04
Rlh_38_10 l_38_10 l_39_10 5.008854e-04
Rlv_38_10 l_38_10 l_38_11 5.008854e-04
Rlh_38_11 l_38_11 l_39_11 5.008854e-04
Rlv_38_11 l_38_11 l_38_12 5.008854e-04
Rlh_38_12 l_38_12 l_39_12 5.008854e-04
Rlv_38_12 l_38_12 l_38_13 5.008854e-04
Rlh_38_13 l_38_13 l_39_13 5.008854e-04
Rlv_38_13 l_38_13 l_38_14 5.008854e-04
Rlh_38_14 l_38_14 l_39_14 5.008854e-04
Rlv_38_14 l_38_14 l_38_15 5.008854e-04
Rlh_38_15 l_38_15 l_39_15 5.008854e-04
Rlv_38_15 l_38_15 l_38_16 5.008854e-04
Rlh_38_16 l_38_16 l_39_16 5.008854e-04
Rlv_38_16 l_38_16 l_38_17 5.008854e-04
Rlh_38_17 l_38_17 l_39_17 5.008854e-04
Rlv_38_17 l_38_17 l_38_18 5.008854e-04
Rlh_38_18 l_38_18 l_39_18 5.008854e-04
Rlv_38_18 l_38_18 l_38_19 5.008854e-04
Rlh_38_19 l_38_19 l_39_19 5.008854e-04
Rlv_38_19 l_38_19 l_38_20 5.008854e-04
Rlh_38_20 l_38_20 l_39_20 5.008854e-04
Rlv_38_20 l_38_20 l_38_21 5.008854e-04
Rlh_38_21 l_38_21 l_39_21 5.008854e-04
Rlv_38_21 l_38_21 l_38_22 5.008854e-04
Rlh_38_22 l_38_22 l_39_22 5.008854e-04
Rlv_38_22 l_38_22 l_38_23 5.008854e-04
Rlh_38_23 l_38_23 l_39_23 5.008854e-04
Rlv_38_23 l_38_23 l_38_24 5.008854e-04
Rlh_38_24 l_38_24 l_39_24 5.008854e-04
Rlv_38_24 l_38_24 l_38_25 5.008854e-04
Rlh_38_25 l_38_25 l_39_25 5.008854e-04
Rlv_38_25 l_38_25 l_38_26 5.008854e-04
Rlh_38_26 l_38_26 l_39_26 5.008854e-04
Rlv_38_26 l_38_26 l_38_27 5.008854e-04
Rlh_38_27 l_38_27 l_39_27 5.008854e-04
Rlv_38_27 l_38_27 l_38_28 5.008854e-04
Rlh_38_28 l_38_28 l_39_28 5.008854e-04
Rlv_38_28 l_38_28 l_38_29 5.008854e-04
Rlh_38_29 l_38_29 l_39_29 5.008854e-04
Rlv_38_29 l_38_29 l_38_30 5.008854e-04
Rlh_38_30 l_38_30 l_39_30 5.008854e-04
Rlv_38_30 l_38_30 l_38_31 5.008854e-04
Rlh_38_31 l_38_31 l_39_31 5.008854e-04
Rlv_38_31 l_38_31 l_38_32 5.008854e-04
Rlh_38_32 l_38_32 l_39_32 5.008854e-04
Rlv_38_32 l_38_32 l_38_33 5.008854e-04
Rlh_38_33 l_38_33 l_39_33 5.008854e-04
Rlv_38_33 l_38_33 l_38_34 5.008854e-04
Rlh_38_34 l_38_34 l_39_34 5.008854e-04
Rlv_38_34 l_38_34 l_38_35 5.008854e-04
Rlh_38_35 l_38_35 l_39_35 5.008854e-04
Rlv_38_35 l_38_35 l_38_36 5.008854e-04
Rlh_38_36 l_38_36 l_39_36 5.008854e-04
Rlv_38_36 l_38_36 l_38_37 5.008854e-04
Rlh_38_37 l_38_37 l_39_37 5.008854e-04
Rlv_38_37 l_38_37 l_38_38 5.008854e-04
Rlh_38_38 l_38_38 l_39_38 5.008854e-04
Rlv_38_38 l_38_38 l_38_39 5.008854e-04
Rlh_38_39 l_38_39 l_39_39 5.008854e-04
Rlv_38_39 l_38_39 l_38_40 5.008854e-04
Rlh_38_40 l_38_40 l_39_40 5.008854e-04
Rlv_38_40 l_38_40 l_38_41 5.008854e-04
Rlh_38_41 l_38_41 l_39_41 5.008854e-04
Rlv_38_41 l_38_41 l_38_42 5.008854e-04
Rlh_38_42 l_38_42 l_39_42 5.008854e-04
Rlv_38_42 l_38_42 l_38_43 5.008854e-04
Rlh_38_43 l_38_43 l_39_43 5.008854e-04
Rlv_38_43 l_38_43 l_38_44 5.008854e-04
Rlh_38_44 l_38_44 l_39_44 5.008854e-04
Rlv_38_44 l_38_44 l_38_45 5.008854e-04
Rlh_38_45 l_38_45 l_39_45 5.008854e-04
Rlv_38_45 l_38_45 l_38_46 5.008854e-04
Rlh_38_46 l_38_46 l_39_46 5.008854e-04
Rlv_38_46 l_38_46 l_38_47 5.008854e-04
Rlh_38_47 l_38_47 l_39_47 5.008854e-04
Rlv_38_47 l_38_47 l_38_48 5.008854e-04
Rlh_38_48 l_38_48 l_39_48 5.008854e-04
Rlv_38_48 l_38_48 l_38_49 5.008854e-04
Rlh_38_49 l_38_49 l_39_49 5.008854e-04
Rlv_38_49 l_38_49 l_38_50 5.008854e-04
Rlh_38_50 l_38_50 l_39_50 5.008854e-04
Rlv_38_50 l_38_50 l_38_51 5.008854e-04
Rlh_38_51 l_38_51 l_39_51 5.008854e-04
Rlv_38_51 l_38_51 l_38_52 5.008854e-04
Rlh_38_52 l_38_52 l_39_52 5.008854e-04
Rlv_38_52 l_38_52 l_38_53 5.008854e-04
Rlh_38_53 l_38_53 l_39_53 5.008854e-04
Rlv_38_53 l_38_53 l_38_54 5.008854e-04
Rlh_38_54 l_38_54 l_39_54 5.008854e-04
Rlv_38_54 l_38_54 l_38_55 5.008854e-04
Rlh_38_55 l_38_55 l_39_55 5.008854e-04
Rlv_38_55 l_38_55 l_38_56 5.008854e-04
Rlh_38_56 l_38_56 l_39_56 5.008854e-04
Rlv_38_56 l_38_56 l_38_57 5.008854e-04
Rlh_38_57 l_38_57 l_39_57 5.008854e-04
Rlv_38_57 l_38_57 l_38_58 5.008854e-04
Rlh_38_58 l_38_58 l_39_58 5.008854e-04
Rlv_38_58 l_38_58 l_38_59 5.008854e-04
Rlh_38_59 l_38_59 l_39_59 5.008854e-04
Rlv_38_59 l_38_59 l_38_60 5.008854e-04
Rlh_38_60 l_38_60 l_39_60 5.008854e-04
Rlv_38_60 l_38_60 l_38_61 5.008854e-04
Rlh_38_61 l_38_61 l_39_61 5.008854e-04
Rlv_38_61 l_38_61 l_38_62 5.008854e-04
Rlh_38_62 l_38_62 l_39_62 5.008854e-04
Rlv_38_62 l_38_62 l_38_63 5.008854e-04
Rlh_38_63 l_38_63 l_39_63 5.008854e-04
Rlv_38_63 l_38_63 l_38_64 5.008854e-04
Rlh_38_64 l_38_64 l_39_64 5.008854e-04
Rlv_38_64 l_38_64 l_38_65 5.008854e-04
Rlh_38_65 l_38_65 l_39_65 5.008854e-04
Rlv_38_65 l_38_65 l_38_66 5.008854e-04
Rlh_38_66 l_38_66 l_39_66 5.008854e-04
Rlv_38_66 l_38_66 l_38_67 5.008854e-04
Rlh_38_67 l_38_67 l_39_67 5.008854e-04
Rlv_38_67 l_38_67 l_38_68 5.008854e-04
Rlh_38_68 l_38_68 l_39_68 5.008854e-04
Rlv_38_68 l_38_68 l_38_69 5.008854e-04
Rlh_38_69 l_38_69 l_39_69 5.008854e-04
Rlv_38_69 l_38_69 l_38_70 5.008854e-04
Rlh_38_70 l_38_70 l_39_70 5.008854e-04
Rlv_38_70 l_38_70 l_38_71 5.008854e-04
Rlh_38_71 l_38_71 l_39_71 5.008854e-04
Rlh_39_0 l_39_0 l_40_0 5.008854e-04
Rlv_39_0 l_39_0 l_39_1 5.008854e-04
Rlh_39_1 l_39_1 l_40_1 5.008854e-04
Rlv_39_1 l_39_1 l_39_2 5.008854e-04
Rlh_39_2 l_39_2 l_40_2 5.008854e-04
Rlv_39_2 l_39_2 l_39_3 5.008854e-04
Rlh_39_3 l_39_3 l_40_3 5.008854e-04
Rlv_39_3 l_39_3 l_39_4 5.008854e-04
Rlh_39_4 l_39_4 l_40_4 5.008854e-04
Rlv_39_4 l_39_4 l_39_5 5.008854e-04
Rlh_39_5 l_39_5 l_40_5 5.008854e-04
Rlv_39_5 l_39_5 l_39_6 5.008854e-04
Rlh_39_6 l_39_6 l_40_6 5.008854e-04
Rlv_39_6 l_39_6 l_39_7 5.008854e-04
Rlh_39_7 l_39_7 l_40_7 5.008854e-04
Rlv_39_7 l_39_7 l_39_8 5.008854e-04
Rlh_39_8 l_39_8 l_40_8 5.008854e-04
Rlv_39_8 l_39_8 l_39_9 5.008854e-04
Rlh_39_9 l_39_9 l_40_9 5.008854e-04
Rlv_39_9 l_39_9 l_39_10 5.008854e-04
Rlh_39_10 l_39_10 l_40_10 5.008854e-04
Rlv_39_10 l_39_10 l_39_11 5.008854e-04
Rlh_39_11 l_39_11 l_40_11 5.008854e-04
Rlv_39_11 l_39_11 l_39_12 5.008854e-04
Rlh_39_12 l_39_12 l_40_12 5.008854e-04
Rlv_39_12 l_39_12 l_39_13 5.008854e-04
Rlh_39_13 l_39_13 l_40_13 5.008854e-04
Rlv_39_13 l_39_13 l_39_14 5.008854e-04
Rlh_39_14 l_39_14 l_40_14 5.008854e-04
Rlv_39_14 l_39_14 l_39_15 5.008854e-04
Rlh_39_15 l_39_15 l_40_15 5.008854e-04
Rlv_39_15 l_39_15 l_39_16 5.008854e-04
Rlh_39_16 l_39_16 l_40_16 5.008854e-04
Rlv_39_16 l_39_16 l_39_17 5.008854e-04
Rlh_39_17 l_39_17 l_40_17 5.008854e-04
Rlv_39_17 l_39_17 l_39_18 5.008854e-04
Rlh_39_18 l_39_18 l_40_18 5.008854e-04
Rlv_39_18 l_39_18 l_39_19 5.008854e-04
Rlh_39_19 l_39_19 l_40_19 5.008854e-04
Rlv_39_19 l_39_19 l_39_20 5.008854e-04
Rlh_39_20 l_39_20 l_40_20 5.008854e-04
Rlv_39_20 l_39_20 l_39_21 5.008854e-04
Rlh_39_21 l_39_21 l_40_21 5.008854e-04
Rlv_39_21 l_39_21 l_39_22 5.008854e-04
Rlh_39_22 l_39_22 l_40_22 5.008854e-04
Rlv_39_22 l_39_22 l_39_23 5.008854e-04
Rlh_39_23 l_39_23 l_40_23 5.008854e-04
Rlv_39_23 l_39_23 l_39_24 5.008854e-04
Rlh_39_24 l_39_24 l_40_24 5.008854e-04
Rlv_39_24 l_39_24 l_39_25 5.008854e-04
Rlh_39_25 l_39_25 l_40_25 5.008854e-04
Rlv_39_25 l_39_25 l_39_26 5.008854e-04
Rlh_39_26 l_39_26 l_40_26 5.008854e-04
Rlv_39_26 l_39_26 l_39_27 5.008854e-04
Rlh_39_27 l_39_27 l_40_27 5.008854e-04
Rlv_39_27 l_39_27 l_39_28 5.008854e-04
Rlh_39_28 l_39_28 l_40_28 5.008854e-04
Rlv_39_28 l_39_28 l_39_29 5.008854e-04
Rlh_39_29 l_39_29 l_40_29 5.008854e-04
Rlv_39_29 l_39_29 l_39_30 5.008854e-04
Rlh_39_30 l_39_30 l_40_30 5.008854e-04
Rlv_39_30 l_39_30 l_39_31 5.008854e-04
Rlh_39_31 l_39_31 l_40_31 5.008854e-04
Rlv_39_31 l_39_31 l_39_32 5.008854e-04
Rlh_39_32 l_39_32 l_40_32 5.008854e-04
Rlv_39_32 l_39_32 l_39_33 5.008854e-04
Rlh_39_33 l_39_33 l_40_33 5.008854e-04
Rlv_39_33 l_39_33 l_39_34 5.008854e-04
Rlh_39_34 l_39_34 l_40_34 5.008854e-04
Rlv_39_34 l_39_34 l_39_35 5.008854e-04
Rlh_39_35 l_39_35 l_40_35 5.008854e-04
Rlv_39_35 l_39_35 l_39_36 5.008854e-04
Rlh_39_36 l_39_36 l_40_36 5.008854e-04
Rlv_39_36 l_39_36 l_39_37 5.008854e-04
Rlh_39_37 l_39_37 l_40_37 5.008854e-04
Rlv_39_37 l_39_37 l_39_38 5.008854e-04
Rlh_39_38 l_39_38 l_40_38 5.008854e-04
Rlv_39_38 l_39_38 l_39_39 5.008854e-04
Rlh_39_39 l_39_39 l_40_39 5.008854e-04
Rlv_39_39 l_39_39 l_39_40 5.008854e-04
Rlh_39_40 l_39_40 l_40_40 5.008854e-04
Rlv_39_40 l_39_40 l_39_41 5.008854e-04
Rlh_39_41 l_39_41 l_40_41 5.008854e-04
Rlv_39_41 l_39_41 l_39_42 5.008854e-04
Rlh_39_42 l_39_42 l_40_42 5.008854e-04
Rlv_39_42 l_39_42 l_39_43 5.008854e-04
Rlh_39_43 l_39_43 l_40_43 5.008854e-04
Rlv_39_43 l_39_43 l_39_44 5.008854e-04
Rlh_39_44 l_39_44 l_40_44 5.008854e-04
Rlv_39_44 l_39_44 l_39_45 5.008854e-04
Rlh_39_45 l_39_45 l_40_45 5.008854e-04
Rlv_39_45 l_39_45 l_39_46 5.008854e-04
Rlh_39_46 l_39_46 l_40_46 5.008854e-04
Rlv_39_46 l_39_46 l_39_47 5.008854e-04
Rlh_39_47 l_39_47 l_40_47 5.008854e-04
Rlv_39_47 l_39_47 l_39_48 5.008854e-04
Rlh_39_48 l_39_48 l_40_48 5.008854e-04
Rlv_39_48 l_39_48 l_39_49 5.008854e-04
Rlh_39_49 l_39_49 l_40_49 5.008854e-04
Rlv_39_49 l_39_49 l_39_50 5.008854e-04
Rlh_39_50 l_39_50 l_40_50 5.008854e-04
Rlv_39_50 l_39_50 l_39_51 5.008854e-04
Rlh_39_51 l_39_51 l_40_51 5.008854e-04
Rlv_39_51 l_39_51 l_39_52 5.008854e-04
Rlh_39_52 l_39_52 l_40_52 5.008854e-04
Rlv_39_52 l_39_52 l_39_53 5.008854e-04
Rlh_39_53 l_39_53 l_40_53 5.008854e-04
Rlv_39_53 l_39_53 l_39_54 5.008854e-04
Rlh_39_54 l_39_54 l_40_54 5.008854e-04
Rlv_39_54 l_39_54 l_39_55 5.008854e-04
Rlh_39_55 l_39_55 l_40_55 5.008854e-04
Rlv_39_55 l_39_55 l_39_56 5.008854e-04
Rlh_39_56 l_39_56 l_40_56 5.008854e-04
Rlv_39_56 l_39_56 l_39_57 5.008854e-04
Rlh_39_57 l_39_57 l_40_57 5.008854e-04
Rlv_39_57 l_39_57 l_39_58 5.008854e-04
Rlh_39_58 l_39_58 l_40_58 5.008854e-04
Rlv_39_58 l_39_58 l_39_59 5.008854e-04
Rlh_39_59 l_39_59 l_40_59 5.008854e-04
Rlv_39_59 l_39_59 l_39_60 5.008854e-04
Rlh_39_60 l_39_60 l_40_60 5.008854e-04
Rlv_39_60 l_39_60 l_39_61 5.008854e-04
Rlh_39_61 l_39_61 l_40_61 5.008854e-04
Rlv_39_61 l_39_61 l_39_62 5.008854e-04
Rlh_39_62 l_39_62 l_40_62 5.008854e-04
Rlv_39_62 l_39_62 l_39_63 5.008854e-04
Rlh_39_63 l_39_63 l_40_63 5.008854e-04
Rlv_39_63 l_39_63 l_39_64 5.008854e-04
Rlh_39_64 l_39_64 l_40_64 5.008854e-04
Rlv_39_64 l_39_64 l_39_65 5.008854e-04
Rlh_39_65 l_39_65 l_40_65 5.008854e-04
Rlv_39_65 l_39_65 l_39_66 5.008854e-04
Rlh_39_66 l_39_66 l_40_66 5.008854e-04
Rlv_39_66 l_39_66 l_39_67 5.008854e-04
Rlh_39_67 l_39_67 l_40_67 5.008854e-04
Rlv_39_67 l_39_67 l_39_68 5.008854e-04
Rlh_39_68 l_39_68 l_40_68 5.008854e-04
Rlv_39_68 l_39_68 l_39_69 5.008854e-04
Rlh_39_69 l_39_69 l_40_69 5.008854e-04
Rlv_39_69 l_39_69 l_39_70 5.008854e-04
Rlh_39_70 l_39_70 l_40_70 5.008854e-04
Rlv_39_70 l_39_70 l_39_71 5.008854e-04
Rlh_39_71 l_39_71 l_40_71 5.008854e-04
Rlh_40_0 l_40_0 l_41_0 5.008854e-04
Rlv_40_0 l_40_0 l_40_1 5.008854e-04
Rlh_40_1 l_40_1 l_41_1 5.008854e-04
Rlv_40_1 l_40_1 l_40_2 5.008854e-04
Rlh_40_2 l_40_2 l_41_2 5.008854e-04
Rlv_40_2 l_40_2 l_40_3 5.008854e-04
Rlh_40_3 l_40_3 l_41_3 5.008854e-04
Rlv_40_3 l_40_3 l_40_4 5.008854e-04
Rlh_40_4 l_40_4 l_41_4 5.008854e-04
Rlv_40_4 l_40_4 l_40_5 5.008854e-04
Rlh_40_5 l_40_5 l_41_5 5.008854e-04
Rlv_40_5 l_40_5 l_40_6 5.008854e-04
Rlh_40_6 l_40_6 l_41_6 5.008854e-04
Rlv_40_6 l_40_6 l_40_7 5.008854e-04
Rlh_40_7 l_40_7 l_41_7 5.008854e-04
Rlv_40_7 l_40_7 l_40_8 5.008854e-04
Rlh_40_8 l_40_8 l_41_8 5.008854e-04
Rlv_40_8 l_40_8 l_40_9 5.008854e-04
Rlh_40_9 l_40_9 l_41_9 5.008854e-04
Rlv_40_9 l_40_9 l_40_10 5.008854e-04
Rlh_40_10 l_40_10 l_41_10 5.008854e-04
Rlv_40_10 l_40_10 l_40_11 5.008854e-04
Rlh_40_11 l_40_11 l_41_11 5.008854e-04
Rlv_40_11 l_40_11 l_40_12 5.008854e-04
Rlh_40_12 l_40_12 l_41_12 5.008854e-04
Rlv_40_12 l_40_12 l_40_13 5.008854e-04
Rlh_40_13 l_40_13 l_41_13 5.008854e-04
Rlv_40_13 l_40_13 l_40_14 5.008854e-04
Rlh_40_14 l_40_14 l_41_14 5.008854e-04
Rlv_40_14 l_40_14 l_40_15 5.008854e-04
Rlh_40_15 l_40_15 l_41_15 5.008854e-04
Rlv_40_15 l_40_15 l_40_16 5.008854e-04
Rlh_40_16 l_40_16 l_41_16 5.008854e-04
Rlv_40_16 l_40_16 l_40_17 5.008854e-04
Rlh_40_17 l_40_17 l_41_17 5.008854e-04
Rlv_40_17 l_40_17 l_40_18 5.008854e-04
Rlh_40_18 l_40_18 l_41_18 5.008854e-04
Rlv_40_18 l_40_18 l_40_19 5.008854e-04
Rlh_40_19 l_40_19 l_41_19 5.008854e-04
Rlv_40_19 l_40_19 l_40_20 5.008854e-04
Rlh_40_20 l_40_20 l_41_20 5.008854e-04
Rlv_40_20 l_40_20 l_40_21 5.008854e-04
Rlh_40_21 l_40_21 l_41_21 5.008854e-04
Rlv_40_21 l_40_21 l_40_22 5.008854e-04
Rlh_40_22 l_40_22 l_41_22 5.008854e-04
Rlv_40_22 l_40_22 l_40_23 5.008854e-04
Rlh_40_23 l_40_23 l_41_23 5.008854e-04
Rlv_40_23 l_40_23 l_40_24 5.008854e-04
Rlh_40_24 l_40_24 l_41_24 5.008854e-04
Rlv_40_24 l_40_24 l_40_25 5.008854e-04
Rlh_40_25 l_40_25 l_41_25 5.008854e-04
Rlv_40_25 l_40_25 l_40_26 5.008854e-04
Rlh_40_26 l_40_26 l_41_26 5.008854e-04
Rlv_40_26 l_40_26 l_40_27 5.008854e-04
Rlh_40_27 l_40_27 l_41_27 5.008854e-04
Rlv_40_27 l_40_27 l_40_28 5.008854e-04
Rlh_40_28 l_40_28 l_41_28 5.008854e-04
Rlv_40_28 l_40_28 l_40_29 5.008854e-04
Rlh_40_29 l_40_29 l_41_29 5.008854e-04
Rlv_40_29 l_40_29 l_40_30 5.008854e-04
Rlh_40_30 l_40_30 l_41_30 5.008854e-04
Rlv_40_30 l_40_30 l_40_31 5.008854e-04
Rlh_40_31 l_40_31 l_41_31 5.008854e-04
Rlv_40_31 l_40_31 l_40_32 5.008854e-04
Rlh_40_32 l_40_32 l_41_32 5.008854e-04
Rlv_40_32 l_40_32 l_40_33 5.008854e-04
Rlh_40_33 l_40_33 l_41_33 5.008854e-04
Rlv_40_33 l_40_33 l_40_34 5.008854e-04
Rlh_40_34 l_40_34 l_41_34 5.008854e-04
Rlv_40_34 l_40_34 l_40_35 5.008854e-04
Rlh_40_35 l_40_35 l_41_35 5.008854e-04
Rlv_40_35 l_40_35 l_40_36 5.008854e-04
Rlh_40_36 l_40_36 l_41_36 5.008854e-04
Rlv_40_36 l_40_36 l_40_37 5.008854e-04
Rlh_40_37 l_40_37 l_41_37 5.008854e-04
Rlv_40_37 l_40_37 l_40_38 5.008854e-04
Rlh_40_38 l_40_38 l_41_38 5.008854e-04
Rlv_40_38 l_40_38 l_40_39 5.008854e-04
Rlh_40_39 l_40_39 l_41_39 5.008854e-04
Rlv_40_39 l_40_39 l_40_40 5.008854e-04
Rlh_40_40 l_40_40 l_41_40 5.008854e-04
Rlv_40_40 l_40_40 l_40_41 5.008854e-04
Rlh_40_41 l_40_41 l_41_41 5.008854e-04
Rlv_40_41 l_40_41 l_40_42 5.008854e-04
Rlh_40_42 l_40_42 l_41_42 5.008854e-04
Rlv_40_42 l_40_42 l_40_43 5.008854e-04
Rlh_40_43 l_40_43 l_41_43 5.008854e-04
Rlv_40_43 l_40_43 l_40_44 5.008854e-04
Rlh_40_44 l_40_44 l_41_44 5.008854e-04
Rlv_40_44 l_40_44 l_40_45 5.008854e-04
Rlh_40_45 l_40_45 l_41_45 5.008854e-04
Rlv_40_45 l_40_45 l_40_46 5.008854e-04
Rlh_40_46 l_40_46 l_41_46 5.008854e-04
Rlv_40_46 l_40_46 l_40_47 5.008854e-04
Rlh_40_47 l_40_47 l_41_47 5.008854e-04
Rlv_40_47 l_40_47 l_40_48 5.008854e-04
Rlh_40_48 l_40_48 l_41_48 5.008854e-04
Rlv_40_48 l_40_48 l_40_49 5.008854e-04
Rlh_40_49 l_40_49 l_41_49 5.008854e-04
Rlv_40_49 l_40_49 l_40_50 5.008854e-04
Rlh_40_50 l_40_50 l_41_50 5.008854e-04
Rlv_40_50 l_40_50 l_40_51 5.008854e-04
Rlh_40_51 l_40_51 l_41_51 5.008854e-04
Rlv_40_51 l_40_51 l_40_52 5.008854e-04
Rlh_40_52 l_40_52 l_41_52 5.008854e-04
Rlv_40_52 l_40_52 l_40_53 5.008854e-04
Rlh_40_53 l_40_53 l_41_53 5.008854e-04
Rlv_40_53 l_40_53 l_40_54 5.008854e-04
Rlh_40_54 l_40_54 l_41_54 5.008854e-04
Rlv_40_54 l_40_54 l_40_55 5.008854e-04
Rlh_40_55 l_40_55 l_41_55 5.008854e-04
Rlv_40_55 l_40_55 l_40_56 5.008854e-04
Rlh_40_56 l_40_56 l_41_56 5.008854e-04
Rlv_40_56 l_40_56 l_40_57 5.008854e-04
Rlh_40_57 l_40_57 l_41_57 5.008854e-04
Rlv_40_57 l_40_57 l_40_58 5.008854e-04
Rlh_40_58 l_40_58 l_41_58 5.008854e-04
Rlv_40_58 l_40_58 l_40_59 5.008854e-04
Rlh_40_59 l_40_59 l_41_59 5.008854e-04
Rlv_40_59 l_40_59 l_40_60 5.008854e-04
Rlh_40_60 l_40_60 l_41_60 5.008854e-04
Rlv_40_60 l_40_60 l_40_61 5.008854e-04
Rlh_40_61 l_40_61 l_41_61 5.008854e-04
Rlv_40_61 l_40_61 l_40_62 5.008854e-04
Rlh_40_62 l_40_62 l_41_62 5.008854e-04
Rlv_40_62 l_40_62 l_40_63 5.008854e-04
Rlh_40_63 l_40_63 l_41_63 5.008854e-04
Rlv_40_63 l_40_63 l_40_64 5.008854e-04
Rlh_40_64 l_40_64 l_41_64 5.008854e-04
Rlv_40_64 l_40_64 l_40_65 5.008854e-04
Rlh_40_65 l_40_65 l_41_65 5.008854e-04
Rlv_40_65 l_40_65 l_40_66 5.008854e-04
Rlh_40_66 l_40_66 l_41_66 5.008854e-04
Rlv_40_66 l_40_66 l_40_67 5.008854e-04
Rlh_40_67 l_40_67 l_41_67 5.008854e-04
Rlv_40_67 l_40_67 l_40_68 5.008854e-04
Rlh_40_68 l_40_68 l_41_68 5.008854e-04
Rlv_40_68 l_40_68 l_40_69 5.008854e-04
Rlh_40_69 l_40_69 l_41_69 5.008854e-04
Rlv_40_69 l_40_69 l_40_70 5.008854e-04
Rlh_40_70 l_40_70 l_41_70 5.008854e-04
Rlv_40_70 l_40_70 l_40_71 5.008854e-04
Rlh_40_71 l_40_71 l_41_71 5.008854e-04
Rlh_41_0 l_41_0 l_42_0 5.008854e-04
Rlv_41_0 l_41_0 l_41_1 5.008854e-04
Rlh_41_1 l_41_1 l_42_1 5.008854e-04
Rlv_41_1 l_41_1 l_41_2 5.008854e-04
Rlh_41_2 l_41_2 l_42_2 5.008854e-04
Rlv_41_2 l_41_2 l_41_3 5.008854e-04
Rlh_41_3 l_41_3 l_42_3 5.008854e-04
Rlv_41_3 l_41_3 l_41_4 5.008854e-04
Rlh_41_4 l_41_4 l_42_4 5.008854e-04
Rlv_41_4 l_41_4 l_41_5 5.008854e-04
Rlh_41_5 l_41_5 l_42_5 5.008854e-04
Rlv_41_5 l_41_5 l_41_6 5.008854e-04
Rlh_41_6 l_41_6 l_42_6 5.008854e-04
Rlv_41_6 l_41_6 l_41_7 5.008854e-04
Rlh_41_7 l_41_7 l_42_7 5.008854e-04
Rlv_41_7 l_41_7 l_41_8 5.008854e-04
Rlh_41_8 l_41_8 l_42_8 5.008854e-04
Rlv_41_8 l_41_8 l_41_9 5.008854e-04
Rlh_41_9 l_41_9 l_42_9 5.008854e-04
Rlv_41_9 l_41_9 l_41_10 5.008854e-04
Rlh_41_10 l_41_10 l_42_10 5.008854e-04
Rlv_41_10 l_41_10 l_41_11 5.008854e-04
Rlh_41_11 l_41_11 l_42_11 5.008854e-04
Rlv_41_11 l_41_11 l_41_12 5.008854e-04
Rlh_41_12 l_41_12 l_42_12 5.008854e-04
Rlv_41_12 l_41_12 l_41_13 5.008854e-04
Rlh_41_13 l_41_13 l_42_13 5.008854e-04
Rlv_41_13 l_41_13 l_41_14 5.008854e-04
Rlh_41_14 l_41_14 l_42_14 5.008854e-04
Rlv_41_14 l_41_14 l_41_15 5.008854e-04
Rlh_41_15 l_41_15 l_42_15 5.008854e-04
Rlv_41_15 l_41_15 l_41_16 5.008854e-04
Rlh_41_16 l_41_16 l_42_16 5.008854e-04
Rlv_41_16 l_41_16 l_41_17 5.008854e-04
Rlh_41_17 l_41_17 l_42_17 5.008854e-04
Rlv_41_17 l_41_17 l_41_18 5.008854e-04
Rlh_41_18 l_41_18 l_42_18 5.008854e-04
Rlv_41_18 l_41_18 l_41_19 5.008854e-04
Rlh_41_19 l_41_19 l_42_19 5.008854e-04
Rlv_41_19 l_41_19 l_41_20 5.008854e-04
Rlh_41_20 l_41_20 l_42_20 5.008854e-04
Rlv_41_20 l_41_20 l_41_21 5.008854e-04
Rlh_41_21 l_41_21 l_42_21 5.008854e-04
Rlv_41_21 l_41_21 l_41_22 5.008854e-04
Rlh_41_22 l_41_22 l_42_22 5.008854e-04
Rlv_41_22 l_41_22 l_41_23 5.008854e-04
Rlh_41_23 l_41_23 l_42_23 5.008854e-04
Rlv_41_23 l_41_23 l_41_24 5.008854e-04
Rlh_41_24 l_41_24 l_42_24 5.008854e-04
Rlv_41_24 l_41_24 l_41_25 5.008854e-04
Rlh_41_25 l_41_25 l_42_25 5.008854e-04
Rlv_41_25 l_41_25 l_41_26 5.008854e-04
Rlh_41_26 l_41_26 l_42_26 5.008854e-04
Rlv_41_26 l_41_26 l_41_27 5.008854e-04
Rlh_41_27 l_41_27 l_42_27 5.008854e-04
Rlv_41_27 l_41_27 l_41_28 5.008854e-04
Rlh_41_28 l_41_28 l_42_28 5.008854e-04
Rlv_41_28 l_41_28 l_41_29 5.008854e-04
Rlh_41_29 l_41_29 l_42_29 5.008854e-04
Rlv_41_29 l_41_29 l_41_30 5.008854e-04
Rlh_41_30 l_41_30 l_42_30 5.008854e-04
Rlv_41_30 l_41_30 l_41_31 5.008854e-04
Rlh_41_31 l_41_31 l_42_31 5.008854e-04
Rlv_41_31 l_41_31 l_41_32 5.008854e-04
Rlh_41_32 l_41_32 l_42_32 5.008854e-04
Rlv_41_32 l_41_32 l_41_33 5.008854e-04
Rlh_41_33 l_41_33 l_42_33 5.008854e-04
Rlv_41_33 l_41_33 l_41_34 5.008854e-04
Rlh_41_34 l_41_34 l_42_34 5.008854e-04
Rlv_41_34 l_41_34 l_41_35 5.008854e-04
Rlh_41_35 l_41_35 l_42_35 5.008854e-04
Rlv_41_35 l_41_35 l_41_36 5.008854e-04
Rlh_41_36 l_41_36 l_42_36 5.008854e-04
Rlv_41_36 l_41_36 l_41_37 5.008854e-04
Rlh_41_37 l_41_37 l_42_37 5.008854e-04
Rlv_41_37 l_41_37 l_41_38 5.008854e-04
Rlh_41_38 l_41_38 l_42_38 5.008854e-04
Rlv_41_38 l_41_38 l_41_39 5.008854e-04
Rlh_41_39 l_41_39 l_42_39 5.008854e-04
Rlv_41_39 l_41_39 l_41_40 5.008854e-04
Rlh_41_40 l_41_40 l_42_40 5.008854e-04
Rlv_41_40 l_41_40 l_41_41 5.008854e-04
Rlh_41_41 l_41_41 l_42_41 5.008854e-04
Rlv_41_41 l_41_41 l_41_42 5.008854e-04
Rlh_41_42 l_41_42 l_42_42 5.008854e-04
Rlv_41_42 l_41_42 l_41_43 5.008854e-04
Rlh_41_43 l_41_43 l_42_43 5.008854e-04
Rlv_41_43 l_41_43 l_41_44 5.008854e-04
Rlh_41_44 l_41_44 l_42_44 5.008854e-04
Rlv_41_44 l_41_44 l_41_45 5.008854e-04
Rlh_41_45 l_41_45 l_42_45 5.008854e-04
Rlv_41_45 l_41_45 l_41_46 5.008854e-04
Rlh_41_46 l_41_46 l_42_46 5.008854e-04
Rlv_41_46 l_41_46 l_41_47 5.008854e-04
Rlh_41_47 l_41_47 l_42_47 5.008854e-04
Rlv_41_47 l_41_47 l_41_48 5.008854e-04
Rlh_41_48 l_41_48 l_42_48 5.008854e-04
Rlv_41_48 l_41_48 l_41_49 5.008854e-04
Rlh_41_49 l_41_49 l_42_49 5.008854e-04
Rlv_41_49 l_41_49 l_41_50 5.008854e-04
Rlh_41_50 l_41_50 l_42_50 5.008854e-04
Rlv_41_50 l_41_50 l_41_51 5.008854e-04
Rlh_41_51 l_41_51 l_42_51 5.008854e-04
Rlv_41_51 l_41_51 l_41_52 5.008854e-04
Rlh_41_52 l_41_52 l_42_52 5.008854e-04
Rlv_41_52 l_41_52 l_41_53 5.008854e-04
Rlh_41_53 l_41_53 l_42_53 5.008854e-04
Rlv_41_53 l_41_53 l_41_54 5.008854e-04
Rlh_41_54 l_41_54 l_42_54 5.008854e-04
Rlv_41_54 l_41_54 l_41_55 5.008854e-04
Rlh_41_55 l_41_55 l_42_55 5.008854e-04
Rlv_41_55 l_41_55 l_41_56 5.008854e-04
Rlh_41_56 l_41_56 l_42_56 5.008854e-04
Rlv_41_56 l_41_56 l_41_57 5.008854e-04
Rlh_41_57 l_41_57 l_42_57 5.008854e-04
Rlv_41_57 l_41_57 l_41_58 5.008854e-04
Rlh_41_58 l_41_58 l_42_58 5.008854e-04
Rlv_41_58 l_41_58 l_41_59 5.008854e-04
Rlh_41_59 l_41_59 l_42_59 5.008854e-04
Rlv_41_59 l_41_59 l_41_60 5.008854e-04
Rlh_41_60 l_41_60 l_42_60 5.008854e-04
Rlv_41_60 l_41_60 l_41_61 5.008854e-04
Rlh_41_61 l_41_61 l_42_61 5.008854e-04
Rlv_41_61 l_41_61 l_41_62 5.008854e-04
Rlh_41_62 l_41_62 l_42_62 5.008854e-04
Rlv_41_62 l_41_62 l_41_63 5.008854e-04
Rlh_41_63 l_41_63 l_42_63 5.008854e-04
Rlv_41_63 l_41_63 l_41_64 5.008854e-04
Rlh_41_64 l_41_64 l_42_64 5.008854e-04
Rlv_41_64 l_41_64 l_41_65 5.008854e-04
Rlh_41_65 l_41_65 l_42_65 5.008854e-04
Rlv_41_65 l_41_65 l_41_66 5.008854e-04
Rlh_41_66 l_41_66 l_42_66 5.008854e-04
Rlv_41_66 l_41_66 l_41_67 5.008854e-04
Rlh_41_67 l_41_67 l_42_67 5.008854e-04
Rlv_41_67 l_41_67 l_41_68 5.008854e-04
Rlh_41_68 l_41_68 l_42_68 5.008854e-04
Rlv_41_68 l_41_68 l_41_69 5.008854e-04
Rlh_41_69 l_41_69 l_42_69 5.008854e-04
Rlv_41_69 l_41_69 l_41_70 5.008854e-04
Rlh_41_70 l_41_70 l_42_70 5.008854e-04
Rlv_41_70 l_41_70 l_41_71 5.008854e-04
Rlh_41_71 l_41_71 l_42_71 5.008854e-04
Rlh_42_0 l_42_0 l_43_0 5.008854e-04
Rlv_42_0 l_42_0 l_42_1 5.008854e-04
Rlh_42_1 l_42_1 l_43_1 5.008854e-04
Rlv_42_1 l_42_1 l_42_2 5.008854e-04
Rlh_42_2 l_42_2 l_43_2 5.008854e-04
Rlv_42_2 l_42_2 l_42_3 5.008854e-04
Rlh_42_3 l_42_3 l_43_3 5.008854e-04
Rlv_42_3 l_42_3 l_42_4 5.008854e-04
Rlh_42_4 l_42_4 l_43_4 5.008854e-04
Rlv_42_4 l_42_4 l_42_5 5.008854e-04
Rlh_42_5 l_42_5 l_43_5 5.008854e-04
Rlv_42_5 l_42_5 l_42_6 5.008854e-04
Rlh_42_6 l_42_6 l_43_6 5.008854e-04
Rlv_42_6 l_42_6 l_42_7 5.008854e-04
Rlh_42_7 l_42_7 l_43_7 5.008854e-04
Rlv_42_7 l_42_7 l_42_8 5.008854e-04
Rlh_42_8 l_42_8 l_43_8 5.008854e-04
Rlv_42_8 l_42_8 l_42_9 5.008854e-04
Rlh_42_9 l_42_9 l_43_9 5.008854e-04
Rlv_42_9 l_42_9 l_42_10 5.008854e-04
Rlh_42_10 l_42_10 l_43_10 5.008854e-04
Rlv_42_10 l_42_10 l_42_11 5.008854e-04
Rlh_42_11 l_42_11 l_43_11 5.008854e-04
Rlv_42_11 l_42_11 l_42_12 5.008854e-04
Rlh_42_12 l_42_12 l_43_12 5.008854e-04
Rlv_42_12 l_42_12 l_42_13 5.008854e-04
Rlh_42_13 l_42_13 l_43_13 5.008854e-04
Rlv_42_13 l_42_13 l_42_14 5.008854e-04
Rlh_42_14 l_42_14 l_43_14 5.008854e-04
Rlv_42_14 l_42_14 l_42_15 5.008854e-04
Rlh_42_15 l_42_15 l_43_15 5.008854e-04
Rlv_42_15 l_42_15 l_42_16 5.008854e-04
Rlh_42_16 l_42_16 l_43_16 5.008854e-04
Rlv_42_16 l_42_16 l_42_17 5.008854e-04
Rlh_42_17 l_42_17 l_43_17 5.008854e-04
Rlv_42_17 l_42_17 l_42_18 5.008854e-04
Rlh_42_18 l_42_18 l_43_18 5.008854e-04
Rlv_42_18 l_42_18 l_42_19 5.008854e-04
Rlh_42_19 l_42_19 l_43_19 5.008854e-04
Rlv_42_19 l_42_19 l_42_20 5.008854e-04
Rlh_42_20 l_42_20 l_43_20 5.008854e-04
Rlv_42_20 l_42_20 l_42_21 5.008854e-04
Rlh_42_21 l_42_21 l_43_21 5.008854e-04
Rlv_42_21 l_42_21 l_42_22 5.008854e-04
Rlh_42_22 l_42_22 l_43_22 5.008854e-04
Rlv_42_22 l_42_22 l_42_23 5.008854e-04
Rlh_42_23 l_42_23 l_43_23 5.008854e-04
Rlv_42_23 l_42_23 l_42_24 5.008854e-04
Rlh_42_24 l_42_24 l_43_24 5.008854e-04
Rlv_42_24 l_42_24 l_42_25 5.008854e-04
Rlh_42_25 l_42_25 l_43_25 5.008854e-04
Rlv_42_25 l_42_25 l_42_26 5.008854e-04
Rlh_42_26 l_42_26 l_43_26 5.008854e-04
Rlv_42_26 l_42_26 l_42_27 5.008854e-04
Rlh_42_27 l_42_27 l_43_27 5.008854e-04
Rlv_42_27 l_42_27 l_42_28 5.008854e-04
Rlh_42_28 l_42_28 l_43_28 5.008854e-04
Rlv_42_28 l_42_28 l_42_29 5.008854e-04
Rlh_42_29 l_42_29 l_43_29 5.008854e-04
Rlv_42_29 l_42_29 l_42_30 5.008854e-04
Rlh_42_30 l_42_30 l_43_30 5.008854e-04
Rlv_42_30 l_42_30 l_42_31 5.008854e-04
Rlh_42_31 l_42_31 l_43_31 5.008854e-04
Rlv_42_31 l_42_31 l_42_32 5.008854e-04
Rlh_42_32 l_42_32 l_43_32 5.008854e-04
Rlv_42_32 l_42_32 l_42_33 5.008854e-04
Rlh_42_33 l_42_33 l_43_33 5.008854e-04
Rlv_42_33 l_42_33 l_42_34 5.008854e-04
Rlh_42_34 l_42_34 l_43_34 5.008854e-04
Rlv_42_34 l_42_34 l_42_35 5.008854e-04
Rlh_42_35 l_42_35 l_43_35 5.008854e-04
Rlv_42_35 l_42_35 l_42_36 5.008854e-04
Rlh_42_36 l_42_36 l_43_36 5.008854e-04
Rlv_42_36 l_42_36 l_42_37 5.008854e-04
Rlh_42_37 l_42_37 l_43_37 5.008854e-04
Rlv_42_37 l_42_37 l_42_38 5.008854e-04
Rlh_42_38 l_42_38 l_43_38 5.008854e-04
Rlv_42_38 l_42_38 l_42_39 5.008854e-04
Rlh_42_39 l_42_39 l_43_39 5.008854e-04
Rlv_42_39 l_42_39 l_42_40 5.008854e-04
Rlh_42_40 l_42_40 l_43_40 5.008854e-04
Rlv_42_40 l_42_40 l_42_41 5.008854e-04
Rlh_42_41 l_42_41 l_43_41 5.008854e-04
Rlv_42_41 l_42_41 l_42_42 5.008854e-04
Rlh_42_42 l_42_42 l_43_42 5.008854e-04
Rlv_42_42 l_42_42 l_42_43 5.008854e-04
Rlh_42_43 l_42_43 l_43_43 5.008854e-04
Rlv_42_43 l_42_43 l_42_44 5.008854e-04
Rlh_42_44 l_42_44 l_43_44 5.008854e-04
Rlv_42_44 l_42_44 l_42_45 5.008854e-04
Rlh_42_45 l_42_45 l_43_45 5.008854e-04
Rlv_42_45 l_42_45 l_42_46 5.008854e-04
Rlh_42_46 l_42_46 l_43_46 5.008854e-04
Rlv_42_46 l_42_46 l_42_47 5.008854e-04
Rlh_42_47 l_42_47 l_43_47 5.008854e-04
Rlv_42_47 l_42_47 l_42_48 5.008854e-04
Rlh_42_48 l_42_48 l_43_48 5.008854e-04
Rlv_42_48 l_42_48 l_42_49 5.008854e-04
Rlh_42_49 l_42_49 l_43_49 5.008854e-04
Rlv_42_49 l_42_49 l_42_50 5.008854e-04
Rlh_42_50 l_42_50 l_43_50 5.008854e-04
Rlv_42_50 l_42_50 l_42_51 5.008854e-04
Rlh_42_51 l_42_51 l_43_51 5.008854e-04
Rlv_42_51 l_42_51 l_42_52 5.008854e-04
Rlh_42_52 l_42_52 l_43_52 5.008854e-04
Rlv_42_52 l_42_52 l_42_53 5.008854e-04
Rlh_42_53 l_42_53 l_43_53 5.008854e-04
Rlv_42_53 l_42_53 l_42_54 5.008854e-04
Rlh_42_54 l_42_54 l_43_54 5.008854e-04
Rlv_42_54 l_42_54 l_42_55 5.008854e-04
Rlh_42_55 l_42_55 l_43_55 5.008854e-04
Rlv_42_55 l_42_55 l_42_56 5.008854e-04
Rlh_42_56 l_42_56 l_43_56 5.008854e-04
Rlv_42_56 l_42_56 l_42_57 5.008854e-04
Rlh_42_57 l_42_57 l_43_57 5.008854e-04
Rlv_42_57 l_42_57 l_42_58 5.008854e-04
Rlh_42_58 l_42_58 l_43_58 5.008854e-04
Rlv_42_58 l_42_58 l_42_59 5.008854e-04
Rlh_42_59 l_42_59 l_43_59 5.008854e-04
Rlv_42_59 l_42_59 l_42_60 5.008854e-04
Rlh_42_60 l_42_60 l_43_60 5.008854e-04
Rlv_42_60 l_42_60 l_42_61 5.008854e-04
Rlh_42_61 l_42_61 l_43_61 5.008854e-04
Rlv_42_61 l_42_61 l_42_62 5.008854e-04
Rlh_42_62 l_42_62 l_43_62 5.008854e-04
Rlv_42_62 l_42_62 l_42_63 5.008854e-04
Rlh_42_63 l_42_63 l_43_63 5.008854e-04
Rlv_42_63 l_42_63 l_42_64 5.008854e-04
Rlh_42_64 l_42_64 l_43_64 5.008854e-04
Rlv_42_64 l_42_64 l_42_65 5.008854e-04
Rlh_42_65 l_42_65 l_43_65 5.008854e-04
Rlv_42_65 l_42_65 l_42_66 5.008854e-04
Rlh_42_66 l_42_66 l_43_66 5.008854e-04
Rlv_42_66 l_42_66 l_42_67 5.008854e-04
Rlh_42_67 l_42_67 l_43_67 5.008854e-04
Rlv_42_67 l_42_67 l_42_68 5.008854e-04
Rlh_42_68 l_42_68 l_43_68 5.008854e-04
Rlv_42_68 l_42_68 l_42_69 5.008854e-04
Rlh_42_69 l_42_69 l_43_69 5.008854e-04
Rlv_42_69 l_42_69 l_42_70 5.008854e-04
Rlh_42_70 l_42_70 l_43_70 5.008854e-04
Rlv_42_70 l_42_70 l_42_71 5.008854e-04
Rlh_42_71 l_42_71 l_43_71 5.008854e-04
Rlh_43_0 l_43_0 l_44_0 5.008854e-04
Rlv_43_0 l_43_0 l_43_1 5.008854e-04
Rlh_43_1 l_43_1 l_44_1 5.008854e-04
Rlv_43_1 l_43_1 l_43_2 5.008854e-04
Rlh_43_2 l_43_2 l_44_2 5.008854e-04
Rlv_43_2 l_43_2 l_43_3 5.008854e-04
Rlh_43_3 l_43_3 l_44_3 5.008854e-04
Rlv_43_3 l_43_3 l_43_4 5.008854e-04
Rlh_43_4 l_43_4 l_44_4 5.008854e-04
Rlv_43_4 l_43_4 l_43_5 5.008854e-04
Rlh_43_5 l_43_5 l_44_5 5.008854e-04
Rlv_43_5 l_43_5 l_43_6 5.008854e-04
Rlh_43_6 l_43_6 l_44_6 5.008854e-04
Rlv_43_6 l_43_6 l_43_7 5.008854e-04
Rlh_43_7 l_43_7 l_44_7 5.008854e-04
Rlv_43_7 l_43_7 l_43_8 5.008854e-04
Rlh_43_8 l_43_8 l_44_8 5.008854e-04
Rlv_43_8 l_43_8 l_43_9 5.008854e-04
Rlh_43_9 l_43_9 l_44_9 5.008854e-04
Rlv_43_9 l_43_9 l_43_10 5.008854e-04
Rlh_43_10 l_43_10 l_44_10 5.008854e-04
Rlv_43_10 l_43_10 l_43_11 5.008854e-04
Rlh_43_11 l_43_11 l_44_11 5.008854e-04
Rlv_43_11 l_43_11 l_43_12 5.008854e-04
Rlh_43_12 l_43_12 l_44_12 5.008854e-04
Rlv_43_12 l_43_12 l_43_13 5.008854e-04
Rlh_43_13 l_43_13 l_44_13 5.008854e-04
Rlv_43_13 l_43_13 l_43_14 5.008854e-04
Rlh_43_14 l_43_14 l_44_14 5.008854e-04
Rlv_43_14 l_43_14 l_43_15 5.008854e-04
Rlh_43_15 l_43_15 l_44_15 5.008854e-04
Rlv_43_15 l_43_15 l_43_16 5.008854e-04
Rlh_43_16 l_43_16 l_44_16 5.008854e-04
Rlv_43_16 l_43_16 l_43_17 5.008854e-04
Rlh_43_17 l_43_17 l_44_17 5.008854e-04
Rlv_43_17 l_43_17 l_43_18 5.008854e-04
Rlh_43_18 l_43_18 l_44_18 5.008854e-04
Rlv_43_18 l_43_18 l_43_19 5.008854e-04
Rlh_43_19 l_43_19 l_44_19 5.008854e-04
Rlv_43_19 l_43_19 l_43_20 5.008854e-04
Rlh_43_20 l_43_20 l_44_20 5.008854e-04
Rlv_43_20 l_43_20 l_43_21 5.008854e-04
Rlh_43_21 l_43_21 l_44_21 5.008854e-04
Rlv_43_21 l_43_21 l_43_22 5.008854e-04
Rlh_43_22 l_43_22 l_44_22 5.008854e-04
Rlv_43_22 l_43_22 l_43_23 5.008854e-04
Rlh_43_23 l_43_23 l_44_23 5.008854e-04
Rlv_43_23 l_43_23 l_43_24 5.008854e-04
Rlh_43_24 l_43_24 l_44_24 5.008854e-04
Rlv_43_24 l_43_24 l_43_25 5.008854e-04
Rlh_43_25 l_43_25 l_44_25 5.008854e-04
Rlv_43_25 l_43_25 l_43_26 5.008854e-04
Rlh_43_26 l_43_26 l_44_26 5.008854e-04
Rlv_43_26 l_43_26 l_43_27 5.008854e-04
Rlh_43_27 l_43_27 l_44_27 5.008854e-04
Rlv_43_27 l_43_27 l_43_28 5.008854e-04
Rlh_43_28 l_43_28 l_44_28 5.008854e-04
Rlv_43_28 l_43_28 l_43_29 5.008854e-04
Rlh_43_29 l_43_29 l_44_29 5.008854e-04
Rlv_43_29 l_43_29 l_43_30 5.008854e-04
Rlh_43_30 l_43_30 l_44_30 5.008854e-04
Rlv_43_30 l_43_30 l_43_31 5.008854e-04
Rlh_43_31 l_43_31 l_44_31 5.008854e-04
Rlv_43_31 l_43_31 l_43_32 5.008854e-04
Rlh_43_32 l_43_32 l_44_32 5.008854e-04
Rlv_43_32 l_43_32 l_43_33 5.008854e-04
Rlh_43_33 l_43_33 l_44_33 5.008854e-04
Rlv_43_33 l_43_33 l_43_34 5.008854e-04
Rlh_43_34 l_43_34 l_44_34 5.008854e-04
Rlv_43_34 l_43_34 l_43_35 5.008854e-04
Rlh_43_35 l_43_35 l_44_35 5.008854e-04
Rlv_43_35 l_43_35 l_43_36 5.008854e-04
Rlh_43_36 l_43_36 l_44_36 5.008854e-04
Rlv_43_36 l_43_36 l_43_37 5.008854e-04
Rlh_43_37 l_43_37 l_44_37 5.008854e-04
Rlv_43_37 l_43_37 l_43_38 5.008854e-04
Rlh_43_38 l_43_38 l_44_38 5.008854e-04
Rlv_43_38 l_43_38 l_43_39 5.008854e-04
Rlh_43_39 l_43_39 l_44_39 5.008854e-04
Rlv_43_39 l_43_39 l_43_40 5.008854e-04
Rlh_43_40 l_43_40 l_44_40 5.008854e-04
Rlv_43_40 l_43_40 l_43_41 5.008854e-04
Rlh_43_41 l_43_41 l_44_41 5.008854e-04
Rlv_43_41 l_43_41 l_43_42 5.008854e-04
Rlh_43_42 l_43_42 l_44_42 5.008854e-04
Rlv_43_42 l_43_42 l_43_43 5.008854e-04
Rlh_43_43 l_43_43 l_44_43 5.008854e-04
Rlv_43_43 l_43_43 l_43_44 5.008854e-04
Rlh_43_44 l_43_44 l_44_44 5.008854e-04
Rlv_43_44 l_43_44 l_43_45 5.008854e-04
Rlh_43_45 l_43_45 l_44_45 5.008854e-04
Rlv_43_45 l_43_45 l_43_46 5.008854e-04
Rlh_43_46 l_43_46 l_44_46 5.008854e-04
Rlv_43_46 l_43_46 l_43_47 5.008854e-04
Rlh_43_47 l_43_47 l_44_47 5.008854e-04
Rlv_43_47 l_43_47 l_43_48 5.008854e-04
Rlh_43_48 l_43_48 l_44_48 5.008854e-04
Rlv_43_48 l_43_48 l_43_49 5.008854e-04
Rlh_43_49 l_43_49 l_44_49 5.008854e-04
Rlv_43_49 l_43_49 l_43_50 5.008854e-04
Rlh_43_50 l_43_50 l_44_50 5.008854e-04
Rlv_43_50 l_43_50 l_43_51 5.008854e-04
Rlh_43_51 l_43_51 l_44_51 5.008854e-04
Rlv_43_51 l_43_51 l_43_52 5.008854e-04
Rlh_43_52 l_43_52 l_44_52 5.008854e-04
Rlv_43_52 l_43_52 l_43_53 5.008854e-04
Rlh_43_53 l_43_53 l_44_53 5.008854e-04
Rlv_43_53 l_43_53 l_43_54 5.008854e-04
Rlh_43_54 l_43_54 l_44_54 5.008854e-04
Rlv_43_54 l_43_54 l_43_55 5.008854e-04
Rlh_43_55 l_43_55 l_44_55 5.008854e-04
Rlv_43_55 l_43_55 l_43_56 5.008854e-04
Rlh_43_56 l_43_56 l_44_56 5.008854e-04
Rlv_43_56 l_43_56 l_43_57 5.008854e-04
Rlh_43_57 l_43_57 l_44_57 5.008854e-04
Rlv_43_57 l_43_57 l_43_58 5.008854e-04
Rlh_43_58 l_43_58 l_44_58 5.008854e-04
Rlv_43_58 l_43_58 l_43_59 5.008854e-04
Rlh_43_59 l_43_59 l_44_59 5.008854e-04
Rlv_43_59 l_43_59 l_43_60 5.008854e-04
Rlh_43_60 l_43_60 l_44_60 5.008854e-04
Rlv_43_60 l_43_60 l_43_61 5.008854e-04
Rlh_43_61 l_43_61 l_44_61 5.008854e-04
Rlv_43_61 l_43_61 l_43_62 5.008854e-04
Rlh_43_62 l_43_62 l_44_62 5.008854e-04
Rlv_43_62 l_43_62 l_43_63 5.008854e-04
Rlh_43_63 l_43_63 l_44_63 5.008854e-04
Rlv_43_63 l_43_63 l_43_64 5.008854e-04
Rlh_43_64 l_43_64 l_44_64 5.008854e-04
Rlv_43_64 l_43_64 l_43_65 5.008854e-04
Rlh_43_65 l_43_65 l_44_65 5.008854e-04
Rlv_43_65 l_43_65 l_43_66 5.008854e-04
Rlh_43_66 l_43_66 l_44_66 5.008854e-04
Rlv_43_66 l_43_66 l_43_67 5.008854e-04
Rlh_43_67 l_43_67 l_44_67 5.008854e-04
Rlv_43_67 l_43_67 l_43_68 5.008854e-04
Rlh_43_68 l_43_68 l_44_68 5.008854e-04
Rlv_43_68 l_43_68 l_43_69 5.008854e-04
Rlh_43_69 l_43_69 l_44_69 5.008854e-04
Rlv_43_69 l_43_69 l_43_70 5.008854e-04
Rlh_43_70 l_43_70 l_44_70 5.008854e-04
Rlv_43_70 l_43_70 l_43_71 5.008854e-04
Rlh_43_71 l_43_71 l_44_71 5.008854e-04
Rlh_44_0 l_44_0 l_45_0 5.008854e-04
Rlv_44_0 l_44_0 l_44_1 5.008854e-04
Rlh_44_1 l_44_1 l_45_1 5.008854e-04
Rlv_44_1 l_44_1 l_44_2 5.008854e-04
Rlh_44_2 l_44_2 l_45_2 5.008854e-04
Rlv_44_2 l_44_2 l_44_3 5.008854e-04
Rlh_44_3 l_44_3 l_45_3 5.008854e-04
Rlv_44_3 l_44_3 l_44_4 5.008854e-04
Rlh_44_4 l_44_4 l_45_4 5.008854e-04
Rlv_44_4 l_44_4 l_44_5 5.008854e-04
Rlh_44_5 l_44_5 l_45_5 5.008854e-04
Rlv_44_5 l_44_5 l_44_6 5.008854e-04
Rlh_44_6 l_44_6 l_45_6 5.008854e-04
Rlv_44_6 l_44_6 l_44_7 5.008854e-04
Rlh_44_7 l_44_7 l_45_7 5.008854e-04
Rlv_44_7 l_44_7 l_44_8 5.008854e-04
Rlh_44_8 l_44_8 l_45_8 5.008854e-04
Rlv_44_8 l_44_8 l_44_9 5.008854e-04
Rlh_44_9 l_44_9 l_45_9 5.008854e-04
Rlv_44_9 l_44_9 l_44_10 5.008854e-04
Rlh_44_10 l_44_10 l_45_10 5.008854e-04
Rlv_44_10 l_44_10 l_44_11 5.008854e-04
Rlh_44_11 l_44_11 l_45_11 5.008854e-04
Rlv_44_11 l_44_11 l_44_12 5.008854e-04
Rlh_44_12 l_44_12 l_45_12 5.008854e-04
Rlv_44_12 l_44_12 l_44_13 5.008854e-04
Rlh_44_13 l_44_13 l_45_13 5.008854e-04
Rlv_44_13 l_44_13 l_44_14 5.008854e-04
Rlh_44_14 l_44_14 l_45_14 5.008854e-04
Rlv_44_14 l_44_14 l_44_15 5.008854e-04
Rlh_44_15 l_44_15 l_45_15 5.008854e-04
Rlv_44_15 l_44_15 l_44_16 5.008854e-04
Rlh_44_16 l_44_16 l_45_16 5.008854e-04
Rlv_44_16 l_44_16 l_44_17 5.008854e-04
Rlh_44_17 l_44_17 l_45_17 5.008854e-04
Rlv_44_17 l_44_17 l_44_18 5.008854e-04
Rlh_44_18 l_44_18 l_45_18 5.008854e-04
Rlv_44_18 l_44_18 l_44_19 5.008854e-04
Rlh_44_19 l_44_19 l_45_19 5.008854e-04
Rlv_44_19 l_44_19 l_44_20 5.008854e-04
Rlh_44_20 l_44_20 l_45_20 5.008854e-04
Rlv_44_20 l_44_20 l_44_21 5.008854e-04
Rlh_44_21 l_44_21 l_45_21 5.008854e-04
Rlv_44_21 l_44_21 l_44_22 5.008854e-04
Rlh_44_22 l_44_22 l_45_22 5.008854e-04
Rlv_44_22 l_44_22 l_44_23 5.008854e-04
Rlh_44_23 l_44_23 l_45_23 5.008854e-04
Rlv_44_23 l_44_23 l_44_24 5.008854e-04
Rlh_44_24 l_44_24 l_45_24 5.008854e-04
Rlv_44_24 l_44_24 l_44_25 5.008854e-04
Rlh_44_25 l_44_25 l_45_25 5.008854e-04
Rlv_44_25 l_44_25 l_44_26 5.008854e-04
Rlh_44_26 l_44_26 l_45_26 5.008854e-04
Rlv_44_26 l_44_26 l_44_27 5.008854e-04
Rlh_44_27 l_44_27 l_45_27 5.008854e-04
Rlv_44_27 l_44_27 l_44_28 5.008854e-04
Rlh_44_28 l_44_28 l_45_28 5.008854e-04
Rlv_44_28 l_44_28 l_44_29 5.008854e-04
Rlh_44_29 l_44_29 l_45_29 5.008854e-04
Rlv_44_29 l_44_29 l_44_30 5.008854e-04
Rlh_44_30 l_44_30 l_45_30 5.008854e-04
Rlv_44_30 l_44_30 l_44_31 5.008854e-04
Rlh_44_31 l_44_31 l_45_31 5.008854e-04
Rlv_44_31 l_44_31 l_44_32 5.008854e-04
Rlh_44_32 l_44_32 l_45_32 5.008854e-04
Rlv_44_32 l_44_32 l_44_33 5.008854e-04
Rlh_44_33 l_44_33 l_45_33 5.008854e-04
Rlv_44_33 l_44_33 l_44_34 5.008854e-04
Rlh_44_34 l_44_34 l_45_34 5.008854e-04
Rlv_44_34 l_44_34 l_44_35 5.008854e-04
Rlh_44_35 l_44_35 l_45_35 5.008854e-04
Rlv_44_35 l_44_35 l_44_36 5.008854e-04
Rlh_44_36 l_44_36 l_45_36 5.008854e-04
Rlv_44_36 l_44_36 l_44_37 5.008854e-04
Rlh_44_37 l_44_37 l_45_37 5.008854e-04
Rlv_44_37 l_44_37 l_44_38 5.008854e-04
Rlh_44_38 l_44_38 l_45_38 5.008854e-04
Rlv_44_38 l_44_38 l_44_39 5.008854e-04
Rlh_44_39 l_44_39 l_45_39 5.008854e-04
Rlv_44_39 l_44_39 l_44_40 5.008854e-04
Rlh_44_40 l_44_40 l_45_40 5.008854e-04
Rlv_44_40 l_44_40 l_44_41 5.008854e-04
Rlh_44_41 l_44_41 l_45_41 5.008854e-04
Rlv_44_41 l_44_41 l_44_42 5.008854e-04
Rlh_44_42 l_44_42 l_45_42 5.008854e-04
Rlv_44_42 l_44_42 l_44_43 5.008854e-04
Rlh_44_43 l_44_43 l_45_43 5.008854e-04
Rlv_44_43 l_44_43 l_44_44 5.008854e-04
Rlh_44_44 l_44_44 l_45_44 5.008854e-04
Rlv_44_44 l_44_44 l_44_45 5.008854e-04
Rlh_44_45 l_44_45 l_45_45 5.008854e-04
Rlv_44_45 l_44_45 l_44_46 5.008854e-04
Rlh_44_46 l_44_46 l_45_46 5.008854e-04
Rlv_44_46 l_44_46 l_44_47 5.008854e-04
Rlh_44_47 l_44_47 l_45_47 5.008854e-04
Rlv_44_47 l_44_47 l_44_48 5.008854e-04
Rlh_44_48 l_44_48 l_45_48 5.008854e-04
Rlv_44_48 l_44_48 l_44_49 5.008854e-04
Rlh_44_49 l_44_49 l_45_49 5.008854e-04
Rlv_44_49 l_44_49 l_44_50 5.008854e-04
Rlh_44_50 l_44_50 l_45_50 5.008854e-04
Rlv_44_50 l_44_50 l_44_51 5.008854e-04
Rlh_44_51 l_44_51 l_45_51 5.008854e-04
Rlv_44_51 l_44_51 l_44_52 5.008854e-04
Rlh_44_52 l_44_52 l_45_52 5.008854e-04
Rlv_44_52 l_44_52 l_44_53 5.008854e-04
Rlh_44_53 l_44_53 l_45_53 5.008854e-04
Rlv_44_53 l_44_53 l_44_54 5.008854e-04
Rlh_44_54 l_44_54 l_45_54 5.008854e-04
Rlv_44_54 l_44_54 l_44_55 5.008854e-04
Rlh_44_55 l_44_55 l_45_55 5.008854e-04
Rlv_44_55 l_44_55 l_44_56 5.008854e-04
Rlh_44_56 l_44_56 l_45_56 5.008854e-04
Rlv_44_56 l_44_56 l_44_57 5.008854e-04
Rlh_44_57 l_44_57 l_45_57 5.008854e-04
Rlv_44_57 l_44_57 l_44_58 5.008854e-04
Rlh_44_58 l_44_58 l_45_58 5.008854e-04
Rlv_44_58 l_44_58 l_44_59 5.008854e-04
Rlh_44_59 l_44_59 l_45_59 5.008854e-04
Rlv_44_59 l_44_59 l_44_60 5.008854e-04
Rlh_44_60 l_44_60 l_45_60 5.008854e-04
Rlv_44_60 l_44_60 l_44_61 5.008854e-04
Rlh_44_61 l_44_61 l_45_61 5.008854e-04
Rlv_44_61 l_44_61 l_44_62 5.008854e-04
Rlh_44_62 l_44_62 l_45_62 5.008854e-04
Rlv_44_62 l_44_62 l_44_63 5.008854e-04
Rlh_44_63 l_44_63 l_45_63 5.008854e-04
Rlv_44_63 l_44_63 l_44_64 5.008854e-04
Rlh_44_64 l_44_64 l_45_64 5.008854e-04
Rlv_44_64 l_44_64 l_44_65 5.008854e-04
Rlh_44_65 l_44_65 l_45_65 5.008854e-04
Rlv_44_65 l_44_65 l_44_66 5.008854e-04
Rlh_44_66 l_44_66 l_45_66 5.008854e-04
Rlv_44_66 l_44_66 l_44_67 5.008854e-04
Rlh_44_67 l_44_67 l_45_67 5.008854e-04
Rlv_44_67 l_44_67 l_44_68 5.008854e-04
Rlh_44_68 l_44_68 l_45_68 5.008854e-04
Rlv_44_68 l_44_68 l_44_69 5.008854e-04
Rlh_44_69 l_44_69 l_45_69 5.008854e-04
Rlv_44_69 l_44_69 l_44_70 5.008854e-04
Rlh_44_70 l_44_70 l_45_70 5.008854e-04
Rlv_44_70 l_44_70 l_44_71 5.008854e-04
Rlh_44_71 l_44_71 l_45_71 5.008854e-04
Rlh_45_0 l_45_0 l_46_0 5.008854e-04
Rlv_45_0 l_45_0 l_45_1 5.008854e-04
Rlh_45_1 l_45_1 l_46_1 5.008854e-04
Rlv_45_1 l_45_1 l_45_2 5.008854e-04
Rlh_45_2 l_45_2 l_46_2 5.008854e-04
Rlv_45_2 l_45_2 l_45_3 5.008854e-04
Rlh_45_3 l_45_3 l_46_3 5.008854e-04
Rlv_45_3 l_45_3 l_45_4 5.008854e-04
Rlh_45_4 l_45_4 l_46_4 5.008854e-04
Rlv_45_4 l_45_4 l_45_5 5.008854e-04
Rlh_45_5 l_45_5 l_46_5 5.008854e-04
Rlv_45_5 l_45_5 l_45_6 5.008854e-04
Rlh_45_6 l_45_6 l_46_6 5.008854e-04
Rlv_45_6 l_45_6 l_45_7 5.008854e-04
Rlh_45_7 l_45_7 l_46_7 5.008854e-04
Rlv_45_7 l_45_7 l_45_8 5.008854e-04
Rlh_45_8 l_45_8 l_46_8 5.008854e-04
Rlv_45_8 l_45_8 l_45_9 5.008854e-04
Rlh_45_9 l_45_9 l_46_9 5.008854e-04
Rlv_45_9 l_45_9 l_45_10 5.008854e-04
Rlh_45_10 l_45_10 l_46_10 5.008854e-04
Rlv_45_10 l_45_10 l_45_11 5.008854e-04
Rlh_45_11 l_45_11 l_46_11 5.008854e-04
Rlv_45_11 l_45_11 l_45_12 5.008854e-04
Rlh_45_12 l_45_12 l_46_12 5.008854e-04
Rlv_45_12 l_45_12 l_45_13 5.008854e-04
Rlh_45_13 l_45_13 l_46_13 5.008854e-04
Rlv_45_13 l_45_13 l_45_14 5.008854e-04
Rlh_45_14 l_45_14 l_46_14 5.008854e-04
Rlv_45_14 l_45_14 l_45_15 5.008854e-04
Rlh_45_15 l_45_15 l_46_15 5.008854e-04
Rlv_45_15 l_45_15 l_45_16 5.008854e-04
Rlh_45_16 l_45_16 l_46_16 5.008854e-04
Rlv_45_16 l_45_16 l_45_17 5.008854e-04
Rlh_45_17 l_45_17 l_46_17 5.008854e-04
Rlv_45_17 l_45_17 l_45_18 5.008854e-04
Rlh_45_18 l_45_18 l_46_18 5.008854e-04
Rlv_45_18 l_45_18 l_45_19 5.008854e-04
Rlh_45_19 l_45_19 l_46_19 5.008854e-04
Rlv_45_19 l_45_19 l_45_20 5.008854e-04
Rlh_45_20 l_45_20 l_46_20 5.008854e-04
Rlv_45_20 l_45_20 l_45_21 5.008854e-04
Rlh_45_21 l_45_21 l_46_21 5.008854e-04
Rlv_45_21 l_45_21 l_45_22 5.008854e-04
Rlh_45_22 l_45_22 l_46_22 5.008854e-04
Rlv_45_22 l_45_22 l_45_23 5.008854e-04
Rlh_45_23 l_45_23 l_46_23 5.008854e-04
Rlv_45_23 l_45_23 l_45_24 5.008854e-04
Rlh_45_24 l_45_24 l_46_24 5.008854e-04
Rlv_45_24 l_45_24 l_45_25 5.008854e-04
Rlh_45_25 l_45_25 l_46_25 5.008854e-04
Rlv_45_25 l_45_25 l_45_26 5.008854e-04
Rlh_45_26 l_45_26 l_46_26 5.008854e-04
Rlv_45_26 l_45_26 l_45_27 5.008854e-04
Rlh_45_27 l_45_27 l_46_27 5.008854e-04
Rlv_45_27 l_45_27 l_45_28 5.008854e-04
Rlh_45_28 l_45_28 l_46_28 5.008854e-04
Rlv_45_28 l_45_28 l_45_29 5.008854e-04
Rlh_45_29 l_45_29 l_46_29 5.008854e-04
Rlv_45_29 l_45_29 l_45_30 5.008854e-04
Rlh_45_30 l_45_30 l_46_30 5.008854e-04
Rlv_45_30 l_45_30 l_45_31 5.008854e-04
Rlh_45_31 l_45_31 l_46_31 5.008854e-04
Rlv_45_31 l_45_31 l_45_32 5.008854e-04
Rlh_45_32 l_45_32 l_46_32 5.008854e-04
Rlv_45_32 l_45_32 l_45_33 5.008854e-04
Rlh_45_33 l_45_33 l_46_33 5.008854e-04
Rlv_45_33 l_45_33 l_45_34 5.008854e-04
Rlh_45_34 l_45_34 l_46_34 5.008854e-04
Rlv_45_34 l_45_34 l_45_35 5.008854e-04
Rlh_45_35 l_45_35 l_46_35 5.008854e-04
Rlv_45_35 l_45_35 l_45_36 5.008854e-04
Rlh_45_36 l_45_36 l_46_36 5.008854e-04
Rlv_45_36 l_45_36 l_45_37 5.008854e-04
Rlh_45_37 l_45_37 l_46_37 5.008854e-04
Rlv_45_37 l_45_37 l_45_38 5.008854e-04
Rlh_45_38 l_45_38 l_46_38 5.008854e-04
Rlv_45_38 l_45_38 l_45_39 5.008854e-04
Rlh_45_39 l_45_39 l_46_39 5.008854e-04
Rlv_45_39 l_45_39 l_45_40 5.008854e-04
Rlh_45_40 l_45_40 l_46_40 5.008854e-04
Rlv_45_40 l_45_40 l_45_41 5.008854e-04
Rlh_45_41 l_45_41 l_46_41 5.008854e-04
Rlv_45_41 l_45_41 l_45_42 5.008854e-04
Rlh_45_42 l_45_42 l_46_42 5.008854e-04
Rlv_45_42 l_45_42 l_45_43 5.008854e-04
Rlh_45_43 l_45_43 l_46_43 5.008854e-04
Rlv_45_43 l_45_43 l_45_44 5.008854e-04
Rlh_45_44 l_45_44 l_46_44 5.008854e-04
Rlv_45_44 l_45_44 l_45_45 5.008854e-04
Rlh_45_45 l_45_45 l_46_45 5.008854e-04
Rlv_45_45 l_45_45 l_45_46 5.008854e-04
Rlh_45_46 l_45_46 l_46_46 5.008854e-04
Rlv_45_46 l_45_46 l_45_47 5.008854e-04
Rlh_45_47 l_45_47 l_46_47 5.008854e-04
Rlv_45_47 l_45_47 l_45_48 5.008854e-04
Rlh_45_48 l_45_48 l_46_48 5.008854e-04
Rlv_45_48 l_45_48 l_45_49 5.008854e-04
Rlh_45_49 l_45_49 l_46_49 5.008854e-04
Rlv_45_49 l_45_49 l_45_50 5.008854e-04
Rlh_45_50 l_45_50 l_46_50 5.008854e-04
Rlv_45_50 l_45_50 l_45_51 5.008854e-04
Rlh_45_51 l_45_51 l_46_51 5.008854e-04
Rlv_45_51 l_45_51 l_45_52 5.008854e-04
Rlh_45_52 l_45_52 l_46_52 5.008854e-04
Rlv_45_52 l_45_52 l_45_53 5.008854e-04
Rlh_45_53 l_45_53 l_46_53 5.008854e-04
Rlv_45_53 l_45_53 l_45_54 5.008854e-04
Rlh_45_54 l_45_54 l_46_54 5.008854e-04
Rlv_45_54 l_45_54 l_45_55 5.008854e-04
Rlh_45_55 l_45_55 l_46_55 5.008854e-04
Rlv_45_55 l_45_55 l_45_56 5.008854e-04
Rlh_45_56 l_45_56 l_46_56 5.008854e-04
Rlv_45_56 l_45_56 l_45_57 5.008854e-04
Rlh_45_57 l_45_57 l_46_57 5.008854e-04
Rlv_45_57 l_45_57 l_45_58 5.008854e-04
Rlh_45_58 l_45_58 l_46_58 5.008854e-04
Rlv_45_58 l_45_58 l_45_59 5.008854e-04
Rlh_45_59 l_45_59 l_46_59 5.008854e-04
Rlv_45_59 l_45_59 l_45_60 5.008854e-04
Rlh_45_60 l_45_60 l_46_60 5.008854e-04
Rlv_45_60 l_45_60 l_45_61 5.008854e-04
Rlh_45_61 l_45_61 l_46_61 5.008854e-04
Rlv_45_61 l_45_61 l_45_62 5.008854e-04
Rlh_45_62 l_45_62 l_46_62 5.008854e-04
Rlv_45_62 l_45_62 l_45_63 5.008854e-04
Rlh_45_63 l_45_63 l_46_63 5.008854e-04
Rlv_45_63 l_45_63 l_45_64 5.008854e-04
Rlh_45_64 l_45_64 l_46_64 5.008854e-04
Rlv_45_64 l_45_64 l_45_65 5.008854e-04
Rlh_45_65 l_45_65 l_46_65 5.008854e-04
Rlv_45_65 l_45_65 l_45_66 5.008854e-04
Rlh_45_66 l_45_66 l_46_66 5.008854e-04
Rlv_45_66 l_45_66 l_45_67 5.008854e-04
Rlh_45_67 l_45_67 l_46_67 5.008854e-04
Rlv_45_67 l_45_67 l_45_68 5.008854e-04
Rlh_45_68 l_45_68 l_46_68 5.008854e-04
Rlv_45_68 l_45_68 l_45_69 5.008854e-04
Rlh_45_69 l_45_69 l_46_69 5.008854e-04
Rlv_45_69 l_45_69 l_45_70 5.008854e-04
Rlh_45_70 l_45_70 l_46_70 5.008854e-04
Rlv_45_70 l_45_70 l_45_71 5.008854e-04
Rlh_45_71 l_45_71 l_46_71 5.008854e-04
Rlh_46_0 l_46_0 l_47_0 5.008854e-04
Rlv_46_0 l_46_0 l_46_1 5.008854e-04
Rlh_46_1 l_46_1 l_47_1 5.008854e-04
Rlv_46_1 l_46_1 l_46_2 5.008854e-04
Rlh_46_2 l_46_2 l_47_2 5.008854e-04
Rlv_46_2 l_46_2 l_46_3 5.008854e-04
Rlh_46_3 l_46_3 l_47_3 5.008854e-04
Rlv_46_3 l_46_3 l_46_4 5.008854e-04
Rlh_46_4 l_46_4 l_47_4 5.008854e-04
Rlv_46_4 l_46_4 l_46_5 5.008854e-04
Rlh_46_5 l_46_5 l_47_5 5.008854e-04
Rlv_46_5 l_46_5 l_46_6 5.008854e-04
Rlh_46_6 l_46_6 l_47_6 5.008854e-04
Rlv_46_6 l_46_6 l_46_7 5.008854e-04
Rlh_46_7 l_46_7 l_47_7 5.008854e-04
Rlv_46_7 l_46_7 l_46_8 5.008854e-04
Rlh_46_8 l_46_8 l_47_8 5.008854e-04
Rlv_46_8 l_46_8 l_46_9 5.008854e-04
Rlh_46_9 l_46_9 l_47_9 5.008854e-04
Rlv_46_9 l_46_9 l_46_10 5.008854e-04
Rlh_46_10 l_46_10 l_47_10 5.008854e-04
Rlv_46_10 l_46_10 l_46_11 5.008854e-04
Rlh_46_11 l_46_11 l_47_11 5.008854e-04
Rlv_46_11 l_46_11 l_46_12 5.008854e-04
Rlh_46_12 l_46_12 l_47_12 5.008854e-04
Rlv_46_12 l_46_12 l_46_13 5.008854e-04
Rlh_46_13 l_46_13 l_47_13 5.008854e-04
Rlv_46_13 l_46_13 l_46_14 5.008854e-04
Rlh_46_14 l_46_14 l_47_14 5.008854e-04
Rlv_46_14 l_46_14 l_46_15 5.008854e-04
Rlh_46_15 l_46_15 l_47_15 5.008854e-04
Rlv_46_15 l_46_15 l_46_16 5.008854e-04
Rlh_46_16 l_46_16 l_47_16 5.008854e-04
Rlv_46_16 l_46_16 l_46_17 5.008854e-04
Rlh_46_17 l_46_17 l_47_17 5.008854e-04
Rlv_46_17 l_46_17 l_46_18 5.008854e-04
Rlh_46_18 l_46_18 l_47_18 5.008854e-04
Rlv_46_18 l_46_18 l_46_19 5.008854e-04
Rlh_46_19 l_46_19 l_47_19 5.008854e-04
Rlv_46_19 l_46_19 l_46_20 5.008854e-04
Rlh_46_20 l_46_20 l_47_20 5.008854e-04
Rlv_46_20 l_46_20 l_46_21 5.008854e-04
Rlh_46_21 l_46_21 l_47_21 5.008854e-04
Rlv_46_21 l_46_21 l_46_22 5.008854e-04
Rlh_46_22 l_46_22 l_47_22 5.008854e-04
Rlv_46_22 l_46_22 l_46_23 5.008854e-04
Rlh_46_23 l_46_23 l_47_23 5.008854e-04
Rlv_46_23 l_46_23 l_46_24 5.008854e-04
Rlh_46_24 l_46_24 l_47_24 5.008854e-04
Rlv_46_24 l_46_24 l_46_25 5.008854e-04
Rlh_46_25 l_46_25 l_47_25 5.008854e-04
Rlv_46_25 l_46_25 l_46_26 5.008854e-04
Rlh_46_26 l_46_26 l_47_26 5.008854e-04
Rlv_46_26 l_46_26 l_46_27 5.008854e-04
Rlh_46_27 l_46_27 l_47_27 5.008854e-04
Rlv_46_27 l_46_27 l_46_28 5.008854e-04
Rlh_46_28 l_46_28 l_47_28 5.008854e-04
Rlv_46_28 l_46_28 l_46_29 5.008854e-04
Rlh_46_29 l_46_29 l_47_29 5.008854e-04
Rlv_46_29 l_46_29 l_46_30 5.008854e-04
Rlh_46_30 l_46_30 l_47_30 5.008854e-04
Rlv_46_30 l_46_30 l_46_31 5.008854e-04
Rlh_46_31 l_46_31 l_47_31 5.008854e-04
Rlv_46_31 l_46_31 l_46_32 5.008854e-04
Rlh_46_32 l_46_32 l_47_32 5.008854e-04
Rlv_46_32 l_46_32 l_46_33 5.008854e-04
Rlh_46_33 l_46_33 l_47_33 5.008854e-04
Rlv_46_33 l_46_33 l_46_34 5.008854e-04
Rlh_46_34 l_46_34 l_47_34 5.008854e-04
Rlv_46_34 l_46_34 l_46_35 5.008854e-04
Rlh_46_35 l_46_35 l_47_35 5.008854e-04
Rlv_46_35 l_46_35 l_46_36 5.008854e-04
Rlh_46_36 l_46_36 l_47_36 5.008854e-04
Rlv_46_36 l_46_36 l_46_37 5.008854e-04
Rlh_46_37 l_46_37 l_47_37 5.008854e-04
Rlv_46_37 l_46_37 l_46_38 5.008854e-04
Rlh_46_38 l_46_38 l_47_38 5.008854e-04
Rlv_46_38 l_46_38 l_46_39 5.008854e-04
Rlh_46_39 l_46_39 l_47_39 5.008854e-04
Rlv_46_39 l_46_39 l_46_40 5.008854e-04
Rlh_46_40 l_46_40 l_47_40 5.008854e-04
Rlv_46_40 l_46_40 l_46_41 5.008854e-04
Rlh_46_41 l_46_41 l_47_41 5.008854e-04
Rlv_46_41 l_46_41 l_46_42 5.008854e-04
Rlh_46_42 l_46_42 l_47_42 5.008854e-04
Rlv_46_42 l_46_42 l_46_43 5.008854e-04
Rlh_46_43 l_46_43 l_47_43 5.008854e-04
Rlv_46_43 l_46_43 l_46_44 5.008854e-04
Rlh_46_44 l_46_44 l_47_44 5.008854e-04
Rlv_46_44 l_46_44 l_46_45 5.008854e-04
Rlh_46_45 l_46_45 l_47_45 5.008854e-04
Rlv_46_45 l_46_45 l_46_46 5.008854e-04
Rlh_46_46 l_46_46 l_47_46 5.008854e-04
Rlv_46_46 l_46_46 l_46_47 5.008854e-04
Rlh_46_47 l_46_47 l_47_47 5.008854e-04
Rlv_46_47 l_46_47 l_46_48 5.008854e-04
Rlh_46_48 l_46_48 l_47_48 5.008854e-04
Rlv_46_48 l_46_48 l_46_49 5.008854e-04
Rlh_46_49 l_46_49 l_47_49 5.008854e-04
Rlv_46_49 l_46_49 l_46_50 5.008854e-04
Rlh_46_50 l_46_50 l_47_50 5.008854e-04
Rlv_46_50 l_46_50 l_46_51 5.008854e-04
Rlh_46_51 l_46_51 l_47_51 5.008854e-04
Rlv_46_51 l_46_51 l_46_52 5.008854e-04
Rlh_46_52 l_46_52 l_47_52 5.008854e-04
Rlv_46_52 l_46_52 l_46_53 5.008854e-04
Rlh_46_53 l_46_53 l_47_53 5.008854e-04
Rlv_46_53 l_46_53 l_46_54 5.008854e-04
Rlh_46_54 l_46_54 l_47_54 5.008854e-04
Rlv_46_54 l_46_54 l_46_55 5.008854e-04
Rlh_46_55 l_46_55 l_47_55 5.008854e-04
Rlv_46_55 l_46_55 l_46_56 5.008854e-04
Rlh_46_56 l_46_56 l_47_56 5.008854e-04
Rlv_46_56 l_46_56 l_46_57 5.008854e-04
Rlh_46_57 l_46_57 l_47_57 5.008854e-04
Rlv_46_57 l_46_57 l_46_58 5.008854e-04
Rlh_46_58 l_46_58 l_47_58 5.008854e-04
Rlv_46_58 l_46_58 l_46_59 5.008854e-04
Rlh_46_59 l_46_59 l_47_59 5.008854e-04
Rlv_46_59 l_46_59 l_46_60 5.008854e-04
Rlh_46_60 l_46_60 l_47_60 5.008854e-04
Rlv_46_60 l_46_60 l_46_61 5.008854e-04
Rlh_46_61 l_46_61 l_47_61 5.008854e-04
Rlv_46_61 l_46_61 l_46_62 5.008854e-04
Rlh_46_62 l_46_62 l_47_62 5.008854e-04
Rlv_46_62 l_46_62 l_46_63 5.008854e-04
Rlh_46_63 l_46_63 l_47_63 5.008854e-04
Rlv_46_63 l_46_63 l_46_64 5.008854e-04
Rlh_46_64 l_46_64 l_47_64 5.008854e-04
Rlv_46_64 l_46_64 l_46_65 5.008854e-04
Rlh_46_65 l_46_65 l_47_65 5.008854e-04
Rlv_46_65 l_46_65 l_46_66 5.008854e-04
Rlh_46_66 l_46_66 l_47_66 5.008854e-04
Rlv_46_66 l_46_66 l_46_67 5.008854e-04
Rlh_46_67 l_46_67 l_47_67 5.008854e-04
Rlv_46_67 l_46_67 l_46_68 5.008854e-04
Rlh_46_68 l_46_68 l_47_68 5.008854e-04
Rlv_46_68 l_46_68 l_46_69 5.008854e-04
Rlh_46_69 l_46_69 l_47_69 5.008854e-04
Rlv_46_69 l_46_69 l_46_70 5.008854e-04
Rlh_46_70 l_46_70 l_47_70 5.008854e-04
Rlv_46_70 l_46_70 l_46_71 5.008854e-04
Rlh_46_71 l_46_71 l_47_71 5.008854e-04
Rlh_47_0 l_47_0 l_48_0 5.008854e-04
Rlv_47_0 l_47_0 l_47_1 5.008854e-04
Rlh_47_1 l_47_1 l_48_1 5.008854e-04
Rlv_47_1 l_47_1 l_47_2 5.008854e-04
Rlh_47_2 l_47_2 l_48_2 5.008854e-04
Rlv_47_2 l_47_2 l_47_3 5.008854e-04
Rlh_47_3 l_47_3 l_48_3 5.008854e-04
Rlv_47_3 l_47_3 l_47_4 5.008854e-04
Rlh_47_4 l_47_4 l_48_4 5.008854e-04
Rlv_47_4 l_47_4 l_47_5 5.008854e-04
Rlh_47_5 l_47_5 l_48_5 5.008854e-04
Rlv_47_5 l_47_5 l_47_6 5.008854e-04
Rlh_47_6 l_47_6 l_48_6 5.008854e-04
Rlv_47_6 l_47_6 l_47_7 5.008854e-04
Rlh_47_7 l_47_7 l_48_7 5.008854e-04
Rlv_47_7 l_47_7 l_47_8 5.008854e-04
Rlh_47_8 l_47_8 l_48_8 5.008854e-04
Rlv_47_8 l_47_8 l_47_9 5.008854e-04
Rlh_47_9 l_47_9 l_48_9 5.008854e-04
Rlv_47_9 l_47_9 l_47_10 5.008854e-04
Rlh_47_10 l_47_10 l_48_10 5.008854e-04
Rlv_47_10 l_47_10 l_47_11 5.008854e-04
Rlh_47_11 l_47_11 l_48_11 5.008854e-04
Rlv_47_11 l_47_11 l_47_12 5.008854e-04
Rlh_47_12 l_47_12 l_48_12 5.008854e-04
Rlv_47_12 l_47_12 l_47_13 5.008854e-04
Rlh_47_13 l_47_13 l_48_13 5.008854e-04
Rlv_47_13 l_47_13 l_47_14 5.008854e-04
Rlh_47_14 l_47_14 l_48_14 5.008854e-04
Rlv_47_14 l_47_14 l_47_15 5.008854e-04
Rlh_47_15 l_47_15 l_48_15 5.008854e-04
Rlv_47_15 l_47_15 l_47_16 5.008854e-04
Rlh_47_16 l_47_16 l_48_16 5.008854e-04
Rlv_47_16 l_47_16 l_47_17 5.008854e-04
Rlh_47_17 l_47_17 l_48_17 5.008854e-04
Rlv_47_17 l_47_17 l_47_18 5.008854e-04
Rlh_47_18 l_47_18 l_48_18 5.008854e-04
Rlv_47_18 l_47_18 l_47_19 5.008854e-04
Rlh_47_19 l_47_19 l_48_19 5.008854e-04
Rlv_47_19 l_47_19 l_47_20 5.008854e-04
Rlh_47_20 l_47_20 l_48_20 5.008854e-04
Rlv_47_20 l_47_20 l_47_21 5.008854e-04
Rlh_47_21 l_47_21 l_48_21 5.008854e-04
Rlv_47_21 l_47_21 l_47_22 5.008854e-04
Rlh_47_22 l_47_22 l_48_22 5.008854e-04
Rlv_47_22 l_47_22 l_47_23 5.008854e-04
Rlh_47_23 l_47_23 l_48_23 5.008854e-04
Rlv_47_23 l_47_23 l_47_24 5.008854e-04
Rlh_47_24 l_47_24 l_48_24 5.008854e-04
Rlv_47_24 l_47_24 l_47_25 5.008854e-04
Rlh_47_25 l_47_25 l_48_25 5.008854e-04
Rlv_47_25 l_47_25 l_47_26 5.008854e-04
Rlh_47_26 l_47_26 l_48_26 5.008854e-04
Rlv_47_26 l_47_26 l_47_27 5.008854e-04
Rlh_47_27 l_47_27 l_48_27 5.008854e-04
Rlv_47_27 l_47_27 l_47_28 5.008854e-04
Rlh_47_28 l_47_28 l_48_28 5.008854e-04
Rlv_47_28 l_47_28 l_47_29 5.008854e-04
Rlh_47_29 l_47_29 l_48_29 5.008854e-04
Rlv_47_29 l_47_29 l_47_30 5.008854e-04
Rlh_47_30 l_47_30 l_48_30 5.008854e-04
Rlv_47_30 l_47_30 l_47_31 5.008854e-04
Rlh_47_31 l_47_31 l_48_31 5.008854e-04
Rlv_47_31 l_47_31 l_47_32 5.008854e-04
Rlh_47_32 l_47_32 l_48_32 5.008854e-04
Rlv_47_32 l_47_32 l_47_33 5.008854e-04
Rlh_47_33 l_47_33 l_48_33 5.008854e-04
Rlv_47_33 l_47_33 l_47_34 5.008854e-04
Rlh_47_34 l_47_34 l_48_34 5.008854e-04
Rlv_47_34 l_47_34 l_47_35 5.008854e-04
Rlh_47_35 l_47_35 l_48_35 5.008854e-04
Rlv_47_35 l_47_35 l_47_36 5.008854e-04
Rlh_47_36 l_47_36 l_48_36 5.008854e-04
Rlv_47_36 l_47_36 l_47_37 5.008854e-04
Rlh_47_37 l_47_37 l_48_37 5.008854e-04
Rlv_47_37 l_47_37 l_47_38 5.008854e-04
Rlh_47_38 l_47_38 l_48_38 5.008854e-04
Rlv_47_38 l_47_38 l_47_39 5.008854e-04
Rlh_47_39 l_47_39 l_48_39 5.008854e-04
Rlv_47_39 l_47_39 l_47_40 5.008854e-04
Rlh_47_40 l_47_40 l_48_40 5.008854e-04
Rlv_47_40 l_47_40 l_47_41 5.008854e-04
Rlh_47_41 l_47_41 l_48_41 5.008854e-04
Rlv_47_41 l_47_41 l_47_42 5.008854e-04
Rlh_47_42 l_47_42 l_48_42 5.008854e-04
Rlv_47_42 l_47_42 l_47_43 5.008854e-04
Rlh_47_43 l_47_43 l_48_43 5.008854e-04
Rlv_47_43 l_47_43 l_47_44 5.008854e-04
Rlh_47_44 l_47_44 l_48_44 5.008854e-04
Rlv_47_44 l_47_44 l_47_45 5.008854e-04
Rlh_47_45 l_47_45 l_48_45 5.008854e-04
Rlv_47_45 l_47_45 l_47_46 5.008854e-04
Rlh_47_46 l_47_46 l_48_46 5.008854e-04
Rlv_47_46 l_47_46 l_47_47 5.008854e-04
Rlh_47_47 l_47_47 l_48_47 5.008854e-04
Rlv_47_47 l_47_47 l_47_48 5.008854e-04
Rlh_47_48 l_47_48 l_48_48 5.008854e-04
Rlv_47_48 l_47_48 l_47_49 5.008854e-04
Rlh_47_49 l_47_49 l_48_49 5.008854e-04
Rlv_47_49 l_47_49 l_47_50 5.008854e-04
Rlh_47_50 l_47_50 l_48_50 5.008854e-04
Rlv_47_50 l_47_50 l_47_51 5.008854e-04
Rlh_47_51 l_47_51 l_48_51 5.008854e-04
Rlv_47_51 l_47_51 l_47_52 5.008854e-04
Rlh_47_52 l_47_52 l_48_52 5.008854e-04
Rlv_47_52 l_47_52 l_47_53 5.008854e-04
Rlh_47_53 l_47_53 l_48_53 5.008854e-04
Rlv_47_53 l_47_53 l_47_54 5.008854e-04
Rlh_47_54 l_47_54 l_48_54 5.008854e-04
Rlv_47_54 l_47_54 l_47_55 5.008854e-04
Rlh_47_55 l_47_55 l_48_55 5.008854e-04
Rlv_47_55 l_47_55 l_47_56 5.008854e-04
Rlh_47_56 l_47_56 l_48_56 5.008854e-04
Rlv_47_56 l_47_56 l_47_57 5.008854e-04
Rlh_47_57 l_47_57 l_48_57 5.008854e-04
Rlv_47_57 l_47_57 l_47_58 5.008854e-04
Rlh_47_58 l_47_58 l_48_58 5.008854e-04
Rlv_47_58 l_47_58 l_47_59 5.008854e-04
Rlh_47_59 l_47_59 l_48_59 5.008854e-04
Rlv_47_59 l_47_59 l_47_60 5.008854e-04
Rlh_47_60 l_47_60 l_48_60 5.008854e-04
Rlv_47_60 l_47_60 l_47_61 5.008854e-04
Rlh_47_61 l_47_61 l_48_61 5.008854e-04
Rlv_47_61 l_47_61 l_47_62 5.008854e-04
Rlh_47_62 l_47_62 l_48_62 5.008854e-04
Rlv_47_62 l_47_62 l_47_63 5.008854e-04
Rlh_47_63 l_47_63 l_48_63 5.008854e-04
Rlv_47_63 l_47_63 l_47_64 5.008854e-04
Rlh_47_64 l_47_64 l_48_64 5.008854e-04
Rlv_47_64 l_47_64 l_47_65 5.008854e-04
Rlh_47_65 l_47_65 l_48_65 5.008854e-04
Rlv_47_65 l_47_65 l_47_66 5.008854e-04
Rlh_47_66 l_47_66 l_48_66 5.008854e-04
Rlv_47_66 l_47_66 l_47_67 5.008854e-04
Rlh_47_67 l_47_67 l_48_67 5.008854e-04
Rlv_47_67 l_47_67 l_47_68 5.008854e-04
Rlh_47_68 l_47_68 l_48_68 5.008854e-04
Rlv_47_68 l_47_68 l_47_69 5.008854e-04
Rlh_47_69 l_47_69 l_48_69 5.008854e-04
Rlv_47_69 l_47_69 l_47_70 5.008854e-04
Rlh_47_70 l_47_70 l_48_70 5.008854e-04
Rlv_47_70 l_47_70 l_47_71 5.008854e-04
Rlh_47_71 l_47_71 l_48_71 5.008854e-04
Rlh_48_0 l_48_0 l_49_0 5.008854e-04
Rlv_48_0 l_48_0 l_48_1 5.008854e-04
Rlh_48_1 l_48_1 l_49_1 5.008854e-04
Rlv_48_1 l_48_1 l_48_2 5.008854e-04
Rlh_48_2 l_48_2 l_49_2 5.008854e-04
Rlv_48_2 l_48_2 l_48_3 5.008854e-04
Rlh_48_3 l_48_3 l_49_3 5.008854e-04
Rlv_48_3 l_48_3 l_48_4 5.008854e-04
Rlh_48_4 l_48_4 l_49_4 5.008854e-04
Rlv_48_4 l_48_4 l_48_5 5.008854e-04
Rlh_48_5 l_48_5 l_49_5 5.008854e-04
Rlv_48_5 l_48_5 l_48_6 5.008854e-04
Rlh_48_6 l_48_6 l_49_6 5.008854e-04
Rlv_48_6 l_48_6 l_48_7 5.008854e-04
Rlh_48_7 l_48_7 l_49_7 5.008854e-04
Rlv_48_7 l_48_7 l_48_8 5.008854e-04
Rlh_48_8 l_48_8 l_49_8 5.008854e-04
Rlv_48_8 l_48_8 l_48_9 5.008854e-04
Rlh_48_9 l_48_9 l_49_9 5.008854e-04
Rlv_48_9 l_48_9 l_48_10 5.008854e-04
Rlh_48_10 l_48_10 l_49_10 5.008854e-04
Rlv_48_10 l_48_10 l_48_11 5.008854e-04
Rlh_48_11 l_48_11 l_49_11 5.008854e-04
Rlv_48_11 l_48_11 l_48_12 5.008854e-04
Rlh_48_12 l_48_12 l_49_12 5.008854e-04
Rlv_48_12 l_48_12 l_48_13 5.008854e-04
Rlh_48_13 l_48_13 l_49_13 5.008854e-04
Rlv_48_13 l_48_13 l_48_14 5.008854e-04
Rlh_48_14 l_48_14 l_49_14 5.008854e-04
Rlv_48_14 l_48_14 l_48_15 5.008854e-04
Rlh_48_15 l_48_15 l_49_15 5.008854e-04
Rlv_48_15 l_48_15 l_48_16 5.008854e-04
Rlh_48_16 l_48_16 l_49_16 5.008854e-04
Rlv_48_16 l_48_16 l_48_17 5.008854e-04
Rlh_48_17 l_48_17 l_49_17 5.008854e-04
Rlv_48_17 l_48_17 l_48_18 5.008854e-04
Rlh_48_18 l_48_18 l_49_18 5.008854e-04
Rlv_48_18 l_48_18 l_48_19 5.008854e-04
Rlh_48_19 l_48_19 l_49_19 5.008854e-04
Rlv_48_19 l_48_19 l_48_20 5.008854e-04
Rlh_48_20 l_48_20 l_49_20 5.008854e-04
Rlv_48_20 l_48_20 l_48_21 5.008854e-04
Rlh_48_21 l_48_21 l_49_21 5.008854e-04
Rlv_48_21 l_48_21 l_48_22 5.008854e-04
Rlh_48_22 l_48_22 l_49_22 5.008854e-04
Rlv_48_22 l_48_22 l_48_23 5.008854e-04
Rlh_48_23 l_48_23 l_49_23 5.008854e-04
Rlv_48_23 l_48_23 l_48_24 5.008854e-04
Rlh_48_24 l_48_24 l_49_24 5.008854e-04
Rlv_48_24 l_48_24 l_48_25 5.008854e-04
Rlh_48_25 l_48_25 l_49_25 5.008854e-04
Rlv_48_25 l_48_25 l_48_26 5.008854e-04
Rlh_48_26 l_48_26 l_49_26 5.008854e-04
Rlv_48_26 l_48_26 l_48_27 5.008854e-04
Rlh_48_27 l_48_27 l_49_27 5.008854e-04
Rlv_48_27 l_48_27 l_48_28 5.008854e-04
Rlh_48_28 l_48_28 l_49_28 5.008854e-04
Rlv_48_28 l_48_28 l_48_29 5.008854e-04
Rlh_48_29 l_48_29 l_49_29 5.008854e-04
Rlv_48_29 l_48_29 l_48_30 5.008854e-04
Rlh_48_30 l_48_30 l_49_30 5.008854e-04
Rlv_48_30 l_48_30 l_48_31 5.008854e-04
Rlh_48_31 l_48_31 l_49_31 5.008854e-04
Rlv_48_31 l_48_31 l_48_32 5.008854e-04
Rlh_48_32 l_48_32 l_49_32 5.008854e-04
Rlv_48_32 l_48_32 l_48_33 5.008854e-04
Rlh_48_33 l_48_33 l_49_33 5.008854e-04
Rlv_48_33 l_48_33 l_48_34 5.008854e-04
Rlh_48_34 l_48_34 l_49_34 5.008854e-04
Rlv_48_34 l_48_34 l_48_35 5.008854e-04
Rlh_48_35 l_48_35 l_49_35 5.008854e-04
Rlv_48_35 l_48_35 l_48_36 5.008854e-04
Rlh_48_36 l_48_36 l_49_36 5.008854e-04
Rlv_48_36 l_48_36 l_48_37 5.008854e-04
Rlh_48_37 l_48_37 l_49_37 5.008854e-04
Rlv_48_37 l_48_37 l_48_38 5.008854e-04
Rlh_48_38 l_48_38 l_49_38 5.008854e-04
Rlv_48_38 l_48_38 l_48_39 5.008854e-04
Rlh_48_39 l_48_39 l_49_39 5.008854e-04
Rlv_48_39 l_48_39 l_48_40 5.008854e-04
Rlh_48_40 l_48_40 l_49_40 5.008854e-04
Rlv_48_40 l_48_40 l_48_41 5.008854e-04
Rlh_48_41 l_48_41 l_49_41 5.008854e-04
Rlv_48_41 l_48_41 l_48_42 5.008854e-04
Rlh_48_42 l_48_42 l_49_42 5.008854e-04
Rlv_48_42 l_48_42 l_48_43 5.008854e-04
Rlh_48_43 l_48_43 l_49_43 5.008854e-04
Rlv_48_43 l_48_43 l_48_44 5.008854e-04
Rlh_48_44 l_48_44 l_49_44 5.008854e-04
Rlv_48_44 l_48_44 l_48_45 5.008854e-04
Rlh_48_45 l_48_45 l_49_45 5.008854e-04
Rlv_48_45 l_48_45 l_48_46 5.008854e-04
Rlh_48_46 l_48_46 l_49_46 5.008854e-04
Rlv_48_46 l_48_46 l_48_47 5.008854e-04
Rlh_48_47 l_48_47 l_49_47 5.008854e-04
Rlv_48_47 l_48_47 l_48_48 5.008854e-04
Rlh_48_48 l_48_48 l_49_48 5.008854e-04
Rlv_48_48 l_48_48 l_48_49 5.008854e-04
Rlh_48_49 l_48_49 l_49_49 5.008854e-04
Rlv_48_49 l_48_49 l_48_50 5.008854e-04
Rlh_48_50 l_48_50 l_49_50 5.008854e-04
Rlv_48_50 l_48_50 l_48_51 5.008854e-04
Rlh_48_51 l_48_51 l_49_51 5.008854e-04
Rlv_48_51 l_48_51 l_48_52 5.008854e-04
Rlh_48_52 l_48_52 l_49_52 5.008854e-04
Rlv_48_52 l_48_52 l_48_53 5.008854e-04
Rlh_48_53 l_48_53 l_49_53 5.008854e-04
Rlv_48_53 l_48_53 l_48_54 5.008854e-04
Rlh_48_54 l_48_54 l_49_54 5.008854e-04
Rlv_48_54 l_48_54 l_48_55 5.008854e-04
Rlh_48_55 l_48_55 l_49_55 5.008854e-04
Rlv_48_55 l_48_55 l_48_56 5.008854e-04
Rlh_48_56 l_48_56 l_49_56 5.008854e-04
Rlv_48_56 l_48_56 l_48_57 5.008854e-04
Rlh_48_57 l_48_57 l_49_57 5.008854e-04
Rlv_48_57 l_48_57 l_48_58 5.008854e-04
Rlh_48_58 l_48_58 l_49_58 5.008854e-04
Rlv_48_58 l_48_58 l_48_59 5.008854e-04
Rlh_48_59 l_48_59 l_49_59 5.008854e-04
Rlv_48_59 l_48_59 l_48_60 5.008854e-04
Rlh_48_60 l_48_60 l_49_60 5.008854e-04
Rlv_48_60 l_48_60 l_48_61 5.008854e-04
Rlh_48_61 l_48_61 l_49_61 5.008854e-04
Rlv_48_61 l_48_61 l_48_62 5.008854e-04
Rlh_48_62 l_48_62 l_49_62 5.008854e-04
Rlv_48_62 l_48_62 l_48_63 5.008854e-04
Rlh_48_63 l_48_63 l_49_63 5.008854e-04
Rlv_48_63 l_48_63 l_48_64 5.008854e-04
Rlh_48_64 l_48_64 l_49_64 5.008854e-04
Rlv_48_64 l_48_64 l_48_65 5.008854e-04
Rlh_48_65 l_48_65 l_49_65 5.008854e-04
Rlv_48_65 l_48_65 l_48_66 5.008854e-04
Rlh_48_66 l_48_66 l_49_66 5.008854e-04
Rlv_48_66 l_48_66 l_48_67 5.008854e-04
Rlh_48_67 l_48_67 l_49_67 5.008854e-04
Rlv_48_67 l_48_67 l_48_68 5.008854e-04
Rlh_48_68 l_48_68 l_49_68 5.008854e-04
Rlv_48_68 l_48_68 l_48_69 5.008854e-04
Rlh_48_69 l_48_69 l_49_69 5.008854e-04
Rlv_48_69 l_48_69 l_48_70 5.008854e-04
Rlh_48_70 l_48_70 l_49_70 5.008854e-04
Rlv_48_70 l_48_70 l_48_71 5.008854e-04
Rlh_48_71 l_48_71 l_49_71 5.008854e-04
Rlh_49_0 l_49_0 l_50_0 5.008854e-04
Rlv_49_0 l_49_0 l_49_1 5.008854e-04
Rlh_49_1 l_49_1 l_50_1 5.008854e-04
Rlv_49_1 l_49_1 l_49_2 5.008854e-04
Rlh_49_2 l_49_2 l_50_2 5.008854e-04
Rlv_49_2 l_49_2 l_49_3 5.008854e-04
Rlh_49_3 l_49_3 l_50_3 5.008854e-04
Rlv_49_3 l_49_3 l_49_4 5.008854e-04
Rlh_49_4 l_49_4 l_50_4 5.008854e-04
Rlv_49_4 l_49_4 l_49_5 5.008854e-04
Rlh_49_5 l_49_5 l_50_5 5.008854e-04
Rlv_49_5 l_49_5 l_49_6 5.008854e-04
Rlh_49_6 l_49_6 l_50_6 5.008854e-04
Rlv_49_6 l_49_6 l_49_7 5.008854e-04
Rlh_49_7 l_49_7 l_50_7 5.008854e-04
Rlv_49_7 l_49_7 l_49_8 5.008854e-04
Rlh_49_8 l_49_8 l_50_8 5.008854e-04
Rlv_49_8 l_49_8 l_49_9 5.008854e-04
Rlh_49_9 l_49_9 l_50_9 5.008854e-04
Rlv_49_9 l_49_9 l_49_10 5.008854e-04
Rlh_49_10 l_49_10 l_50_10 5.008854e-04
Rlv_49_10 l_49_10 l_49_11 5.008854e-04
Rlh_49_11 l_49_11 l_50_11 5.008854e-04
Rlv_49_11 l_49_11 l_49_12 5.008854e-04
Rlh_49_12 l_49_12 l_50_12 5.008854e-04
Rlv_49_12 l_49_12 l_49_13 5.008854e-04
Rlh_49_13 l_49_13 l_50_13 5.008854e-04
Rlv_49_13 l_49_13 l_49_14 5.008854e-04
Rlh_49_14 l_49_14 l_50_14 5.008854e-04
Rlv_49_14 l_49_14 l_49_15 5.008854e-04
Rlh_49_15 l_49_15 l_50_15 5.008854e-04
Rlv_49_15 l_49_15 l_49_16 5.008854e-04
Rlh_49_16 l_49_16 l_50_16 5.008854e-04
Rlv_49_16 l_49_16 l_49_17 5.008854e-04
Rlh_49_17 l_49_17 l_50_17 5.008854e-04
Rlv_49_17 l_49_17 l_49_18 5.008854e-04
Rlh_49_18 l_49_18 l_50_18 5.008854e-04
Rlv_49_18 l_49_18 l_49_19 5.008854e-04
Rlh_49_19 l_49_19 l_50_19 5.008854e-04
Rlv_49_19 l_49_19 l_49_20 5.008854e-04
Rlh_49_20 l_49_20 l_50_20 5.008854e-04
Rlv_49_20 l_49_20 l_49_21 5.008854e-04
Rlh_49_21 l_49_21 l_50_21 5.008854e-04
Rlv_49_21 l_49_21 l_49_22 5.008854e-04
Rlh_49_22 l_49_22 l_50_22 5.008854e-04
Rlv_49_22 l_49_22 l_49_23 5.008854e-04
Rlh_49_23 l_49_23 l_50_23 5.008854e-04
Rlv_49_23 l_49_23 l_49_24 5.008854e-04
Rlh_49_24 l_49_24 l_50_24 5.008854e-04
Rlv_49_24 l_49_24 l_49_25 5.008854e-04
Rlh_49_25 l_49_25 l_50_25 5.008854e-04
Rlv_49_25 l_49_25 l_49_26 5.008854e-04
Rlh_49_26 l_49_26 l_50_26 5.008854e-04
Rlv_49_26 l_49_26 l_49_27 5.008854e-04
Rlh_49_27 l_49_27 l_50_27 5.008854e-04
Rlv_49_27 l_49_27 l_49_28 5.008854e-04
Rlh_49_28 l_49_28 l_50_28 5.008854e-04
Rlv_49_28 l_49_28 l_49_29 5.008854e-04
Rlh_49_29 l_49_29 l_50_29 5.008854e-04
Rlv_49_29 l_49_29 l_49_30 5.008854e-04
Rlh_49_30 l_49_30 l_50_30 5.008854e-04
Rlv_49_30 l_49_30 l_49_31 5.008854e-04
Rlh_49_31 l_49_31 l_50_31 5.008854e-04
Rlv_49_31 l_49_31 l_49_32 5.008854e-04
Rlh_49_32 l_49_32 l_50_32 5.008854e-04
Rlv_49_32 l_49_32 l_49_33 5.008854e-04
Rlh_49_33 l_49_33 l_50_33 5.008854e-04
Rlv_49_33 l_49_33 l_49_34 5.008854e-04
Rlh_49_34 l_49_34 l_50_34 5.008854e-04
Rlv_49_34 l_49_34 l_49_35 5.008854e-04
Rlh_49_35 l_49_35 l_50_35 5.008854e-04
Rlv_49_35 l_49_35 l_49_36 5.008854e-04
Rlh_49_36 l_49_36 l_50_36 5.008854e-04
Rlv_49_36 l_49_36 l_49_37 5.008854e-04
Rlh_49_37 l_49_37 l_50_37 5.008854e-04
Rlv_49_37 l_49_37 l_49_38 5.008854e-04
Rlh_49_38 l_49_38 l_50_38 5.008854e-04
Rlv_49_38 l_49_38 l_49_39 5.008854e-04
Rlh_49_39 l_49_39 l_50_39 5.008854e-04
Rlv_49_39 l_49_39 l_49_40 5.008854e-04
Rlh_49_40 l_49_40 l_50_40 5.008854e-04
Rlv_49_40 l_49_40 l_49_41 5.008854e-04
Rlh_49_41 l_49_41 l_50_41 5.008854e-04
Rlv_49_41 l_49_41 l_49_42 5.008854e-04
Rlh_49_42 l_49_42 l_50_42 5.008854e-04
Rlv_49_42 l_49_42 l_49_43 5.008854e-04
Rlh_49_43 l_49_43 l_50_43 5.008854e-04
Rlv_49_43 l_49_43 l_49_44 5.008854e-04
Rlh_49_44 l_49_44 l_50_44 5.008854e-04
Rlv_49_44 l_49_44 l_49_45 5.008854e-04
Rlh_49_45 l_49_45 l_50_45 5.008854e-04
Rlv_49_45 l_49_45 l_49_46 5.008854e-04
Rlh_49_46 l_49_46 l_50_46 5.008854e-04
Rlv_49_46 l_49_46 l_49_47 5.008854e-04
Rlh_49_47 l_49_47 l_50_47 5.008854e-04
Rlv_49_47 l_49_47 l_49_48 5.008854e-04
Rlh_49_48 l_49_48 l_50_48 5.008854e-04
Rlv_49_48 l_49_48 l_49_49 5.008854e-04
Rlh_49_49 l_49_49 l_50_49 5.008854e-04
Rlv_49_49 l_49_49 l_49_50 5.008854e-04
Rlh_49_50 l_49_50 l_50_50 5.008854e-04
Rlv_49_50 l_49_50 l_49_51 5.008854e-04
Rlh_49_51 l_49_51 l_50_51 5.008854e-04
Rlv_49_51 l_49_51 l_49_52 5.008854e-04
Rlh_49_52 l_49_52 l_50_52 5.008854e-04
Rlv_49_52 l_49_52 l_49_53 5.008854e-04
Rlh_49_53 l_49_53 l_50_53 5.008854e-04
Rlv_49_53 l_49_53 l_49_54 5.008854e-04
Rlh_49_54 l_49_54 l_50_54 5.008854e-04
Rlv_49_54 l_49_54 l_49_55 5.008854e-04
Rlh_49_55 l_49_55 l_50_55 5.008854e-04
Rlv_49_55 l_49_55 l_49_56 5.008854e-04
Rlh_49_56 l_49_56 l_50_56 5.008854e-04
Rlv_49_56 l_49_56 l_49_57 5.008854e-04
Rlh_49_57 l_49_57 l_50_57 5.008854e-04
Rlv_49_57 l_49_57 l_49_58 5.008854e-04
Rlh_49_58 l_49_58 l_50_58 5.008854e-04
Rlv_49_58 l_49_58 l_49_59 5.008854e-04
Rlh_49_59 l_49_59 l_50_59 5.008854e-04
Rlv_49_59 l_49_59 l_49_60 5.008854e-04
Rlh_49_60 l_49_60 l_50_60 5.008854e-04
Rlv_49_60 l_49_60 l_49_61 5.008854e-04
Rlh_49_61 l_49_61 l_50_61 5.008854e-04
Rlv_49_61 l_49_61 l_49_62 5.008854e-04
Rlh_49_62 l_49_62 l_50_62 5.008854e-04
Rlv_49_62 l_49_62 l_49_63 5.008854e-04
Rlh_49_63 l_49_63 l_50_63 5.008854e-04
Rlv_49_63 l_49_63 l_49_64 5.008854e-04
Rlh_49_64 l_49_64 l_50_64 5.008854e-04
Rlv_49_64 l_49_64 l_49_65 5.008854e-04
Rlh_49_65 l_49_65 l_50_65 5.008854e-04
Rlv_49_65 l_49_65 l_49_66 5.008854e-04
Rlh_49_66 l_49_66 l_50_66 5.008854e-04
Rlv_49_66 l_49_66 l_49_67 5.008854e-04
Rlh_49_67 l_49_67 l_50_67 5.008854e-04
Rlv_49_67 l_49_67 l_49_68 5.008854e-04
Rlh_49_68 l_49_68 l_50_68 5.008854e-04
Rlv_49_68 l_49_68 l_49_69 5.008854e-04
Rlh_49_69 l_49_69 l_50_69 5.008854e-04
Rlv_49_69 l_49_69 l_49_70 5.008854e-04
Rlh_49_70 l_49_70 l_50_70 5.008854e-04
Rlv_49_70 l_49_70 l_49_71 5.008854e-04
Rlh_49_71 l_49_71 l_50_71 5.008854e-04
Rlh_50_0 l_50_0 l_51_0 5.008854e-04
Rlv_50_0 l_50_0 l_50_1 5.008854e-04
Rlh_50_1 l_50_1 l_51_1 5.008854e-04
Rlv_50_1 l_50_1 l_50_2 5.008854e-04
Rlh_50_2 l_50_2 l_51_2 5.008854e-04
Rlv_50_2 l_50_2 l_50_3 5.008854e-04
Rlh_50_3 l_50_3 l_51_3 5.008854e-04
Rlv_50_3 l_50_3 l_50_4 5.008854e-04
Rlh_50_4 l_50_4 l_51_4 5.008854e-04
Rlv_50_4 l_50_4 l_50_5 5.008854e-04
Rlh_50_5 l_50_5 l_51_5 5.008854e-04
Rlv_50_5 l_50_5 l_50_6 5.008854e-04
Rlh_50_6 l_50_6 l_51_6 5.008854e-04
Rlv_50_6 l_50_6 l_50_7 5.008854e-04
Rlh_50_7 l_50_7 l_51_7 5.008854e-04
Rlv_50_7 l_50_7 l_50_8 5.008854e-04
Rlh_50_8 l_50_8 l_51_8 5.008854e-04
Rlv_50_8 l_50_8 l_50_9 5.008854e-04
Rlh_50_9 l_50_9 l_51_9 5.008854e-04
Rlv_50_9 l_50_9 l_50_10 5.008854e-04
Rlh_50_10 l_50_10 l_51_10 5.008854e-04
Rlv_50_10 l_50_10 l_50_11 5.008854e-04
Rlh_50_11 l_50_11 l_51_11 5.008854e-04
Rlv_50_11 l_50_11 l_50_12 5.008854e-04
Rlh_50_12 l_50_12 l_51_12 5.008854e-04
Rlv_50_12 l_50_12 l_50_13 5.008854e-04
Rlh_50_13 l_50_13 l_51_13 5.008854e-04
Rlv_50_13 l_50_13 l_50_14 5.008854e-04
Rlh_50_14 l_50_14 l_51_14 5.008854e-04
Rlv_50_14 l_50_14 l_50_15 5.008854e-04
Rlh_50_15 l_50_15 l_51_15 5.008854e-04
Rlv_50_15 l_50_15 l_50_16 5.008854e-04
Rlh_50_16 l_50_16 l_51_16 5.008854e-04
Rlv_50_16 l_50_16 l_50_17 5.008854e-04
Rlh_50_17 l_50_17 l_51_17 5.008854e-04
Rlv_50_17 l_50_17 l_50_18 5.008854e-04
Rlh_50_18 l_50_18 l_51_18 5.008854e-04
Rlv_50_18 l_50_18 l_50_19 5.008854e-04
Rlh_50_19 l_50_19 l_51_19 5.008854e-04
Rlv_50_19 l_50_19 l_50_20 5.008854e-04
Rlh_50_20 l_50_20 l_51_20 5.008854e-04
Rlv_50_20 l_50_20 l_50_21 5.008854e-04
Rlh_50_21 l_50_21 l_51_21 5.008854e-04
Rlv_50_21 l_50_21 l_50_22 5.008854e-04
Rlh_50_22 l_50_22 l_51_22 5.008854e-04
Rlv_50_22 l_50_22 l_50_23 5.008854e-04
Rlh_50_23 l_50_23 l_51_23 5.008854e-04
Rlv_50_23 l_50_23 l_50_24 5.008854e-04
Rlh_50_24 l_50_24 l_51_24 5.008854e-04
Rlv_50_24 l_50_24 l_50_25 5.008854e-04
Rlh_50_25 l_50_25 l_51_25 5.008854e-04
Rlv_50_25 l_50_25 l_50_26 5.008854e-04
Rlh_50_26 l_50_26 l_51_26 5.008854e-04
Rlv_50_26 l_50_26 l_50_27 5.008854e-04
Rlh_50_27 l_50_27 l_51_27 5.008854e-04
Rlv_50_27 l_50_27 l_50_28 5.008854e-04
Rlh_50_28 l_50_28 l_51_28 5.008854e-04
Rlv_50_28 l_50_28 l_50_29 5.008854e-04
Rlh_50_29 l_50_29 l_51_29 5.008854e-04
Rlv_50_29 l_50_29 l_50_30 5.008854e-04
Rlh_50_30 l_50_30 l_51_30 5.008854e-04
Rlv_50_30 l_50_30 l_50_31 5.008854e-04
Rlh_50_31 l_50_31 l_51_31 5.008854e-04
Rlv_50_31 l_50_31 l_50_32 5.008854e-04
Rlh_50_32 l_50_32 l_51_32 5.008854e-04
Rlv_50_32 l_50_32 l_50_33 5.008854e-04
Rlh_50_33 l_50_33 l_51_33 5.008854e-04
Rlv_50_33 l_50_33 l_50_34 5.008854e-04
Rlh_50_34 l_50_34 l_51_34 5.008854e-04
Rlv_50_34 l_50_34 l_50_35 5.008854e-04
Rlh_50_35 l_50_35 l_51_35 5.008854e-04
Rlv_50_35 l_50_35 l_50_36 5.008854e-04
Rlh_50_36 l_50_36 l_51_36 5.008854e-04
Rlv_50_36 l_50_36 l_50_37 5.008854e-04
Rlh_50_37 l_50_37 l_51_37 5.008854e-04
Rlv_50_37 l_50_37 l_50_38 5.008854e-04
Rlh_50_38 l_50_38 l_51_38 5.008854e-04
Rlv_50_38 l_50_38 l_50_39 5.008854e-04
Rlh_50_39 l_50_39 l_51_39 5.008854e-04
Rlv_50_39 l_50_39 l_50_40 5.008854e-04
Rlh_50_40 l_50_40 l_51_40 5.008854e-04
Rlv_50_40 l_50_40 l_50_41 5.008854e-04
Rlh_50_41 l_50_41 l_51_41 5.008854e-04
Rlv_50_41 l_50_41 l_50_42 5.008854e-04
Rlh_50_42 l_50_42 l_51_42 5.008854e-04
Rlv_50_42 l_50_42 l_50_43 5.008854e-04
Rlh_50_43 l_50_43 l_51_43 5.008854e-04
Rlv_50_43 l_50_43 l_50_44 5.008854e-04
Rlh_50_44 l_50_44 l_51_44 5.008854e-04
Rlv_50_44 l_50_44 l_50_45 5.008854e-04
Rlh_50_45 l_50_45 l_51_45 5.008854e-04
Rlv_50_45 l_50_45 l_50_46 5.008854e-04
Rlh_50_46 l_50_46 l_51_46 5.008854e-04
Rlv_50_46 l_50_46 l_50_47 5.008854e-04
Rlh_50_47 l_50_47 l_51_47 5.008854e-04
Rlv_50_47 l_50_47 l_50_48 5.008854e-04
Rlh_50_48 l_50_48 l_51_48 5.008854e-04
Rlv_50_48 l_50_48 l_50_49 5.008854e-04
Rlh_50_49 l_50_49 l_51_49 5.008854e-04
Rlv_50_49 l_50_49 l_50_50 5.008854e-04
Rlh_50_50 l_50_50 l_51_50 5.008854e-04
Rlv_50_50 l_50_50 l_50_51 5.008854e-04
Rlh_50_51 l_50_51 l_51_51 5.008854e-04
Rlv_50_51 l_50_51 l_50_52 5.008854e-04
Rlh_50_52 l_50_52 l_51_52 5.008854e-04
Rlv_50_52 l_50_52 l_50_53 5.008854e-04
Rlh_50_53 l_50_53 l_51_53 5.008854e-04
Rlv_50_53 l_50_53 l_50_54 5.008854e-04
Rlh_50_54 l_50_54 l_51_54 5.008854e-04
Rlv_50_54 l_50_54 l_50_55 5.008854e-04
Rlh_50_55 l_50_55 l_51_55 5.008854e-04
Rlv_50_55 l_50_55 l_50_56 5.008854e-04
Rlh_50_56 l_50_56 l_51_56 5.008854e-04
Rlv_50_56 l_50_56 l_50_57 5.008854e-04
Rlh_50_57 l_50_57 l_51_57 5.008854e-04
Rlv_50_57 l_50_57 l_50_58 5.008854e-04
Rlh_50_58 l_50_58 l_51_58 5.008854e-04
Rlv_50_58 l_50_58 l_50_59 5.008854e-04
Rlh_50_59 l_50_59 l_51_59 5.008854e-04
Rlv_50_59 l_50_59 l_50_60 5.008854e-04
Rlh_50_60 l_50_60 l_51_60 5.008854e-04
Rlv_50_60 l_50_60 l_50_61 5.008854e-04
Rlh_50_61 l_50_61 l_51_61 5.008854e-04
Rlv_50_61 l_50_61 l_50_62 5.008854e-04
Rlh_50_62 l_50_62 l_51_62 5.008854e-04
Rlv_50_62 l_50_62 l_50_63 5.008854e-04
Rlh_50_63 l_50_63 l_51_63 5.008854e-04
Rlv_50_63 l_50_63 l_50_64 5.008854e-04
Rlh_50_64 l_50_64 l_51_64 5.008854e-04
Rlv_50_64 l_50_64 l_50_65 5.008854e-04
Rlh_50_65 l_50_65 l_51_65 5.008854e-04
Rlv_50_65 l_50_65 l_50_66 5.008854e-04
Rlh_50_66 l_50_66 l_51_66 5.008854e-04
Rlv_50_66 l_50_66 l_50_67 5.008854e-04
Rlh_50_67 l_50_67 l_51_67 5.008854e-04
Rlv_50_67 l_50_67 l_50_68 5.008854e-04
Rlh_50_68 l_50_68 l_51_68 5.008854e-04
Rlv_50_68 l_50_68 l_50_69 5.008854e-04
Rlh_50_69 l_50_69 l_51_69 5.008854e-04
Rlv_50_69 l_50_69 l_50_70 5.008854e-04
Rlh_50_70 l_50_70 l_51_70 5.008854e-04
Rlv_50_70 l_50_70 l_50_71 5.008854e-04
Rlh_50_71 l_50_71 l_51_71 5.008854e-04
Rlh_51_0 l_51_0 l_52_0 5.008854e-04
Rlv_51_0 l_51_0 l_51_1 5.008854e-04
Rlh_51_1 l_51_1 l_52_1 5.008854e-04
Rlv_51_1 l_51_1 l_51_2 5.008854e-04
Rlh_51_2 l_51_2 l_52_2 5.008854e-04
Rlv_51_2 l_51_2 l_51_3 5.008854e-04
Rlh_51_3 l_51_3 l_52_3 5.008854e-04
Rlv_51_3 l_51_3 l_51_4 5.008854e-04
Rlh_51_4 l_51_4 l_52_4 5.008854e-04
Rlv_51_4 l_51_4 l_51_5 5.008854e-04
Rlh_51_5 l_51_5 l_52_5 5.008854e-04
Rlv_51_5 l_51_5 l_51_6 5.008854e-04
Rlh_51_6 l_51_6 l_52_6 5.008854e-04
Rlv_51_6 l_51_6 l_51_7 5.008854e-04
Rlh_51_7 l_51_7 l_52_7 5.008854e-04
Rlv_51_7 l_51_7 l_51_8 5.008854e-04
Rlh_51_8 l_51_8 l_52_8 5.008854e-04
Rlv_51_8 l_51_8 l_51_9 5.008854e-04
Rlh_51_9 l_51_9 l_52_9 5.008854e-04
Rlv_51_9 l_51_9 l_51_10 5.008854e-04
Rlh_51_10 l_51_10 l_52_10 5.008854e-04
Rlv_51_10 l_51_10 l_51_11 5.008854e-04
Rlh_51_11 l_51_11 l_52_11 5.008854e-04
Rlv_51_11 l_51_11 l_51_12 5.008854e-04
Rlh_51_12 l_51_12 l_52_12 5.008854e-04
Rlv_51_12 l_51_12 l_51_13 5.008854e-04
Rlh_51_13 l_51_13 l_52_13 5.008854e-04
Rlv_51_13 l_51_13 l_51_14 5.008854e-04
Rlh_51_14 l_51_14 l_52_14 5.008854e-04
Rlv_51_14 l_51_14 l_51_15 5.008854e-04
Rlh_51_15 l_51_15 l_52_15 5.008854e-04
Rlv_51_15 l_51_15 l_51_16 5.008854e-04
Rlh_51_16 l_51_16 l_52_16 5.008854e-04
Rlv_51_16 l_51_16 l_51_17 5.008854e-04
Rlh_51_17 l_51_17 l_52_17 5.008854e-04
Rlv_51_17 l_51_17 l_51_18 5.008854e-04
Rlh_51_18 l_51_18 l_52_18 5.008854e-04
Rlv_51_18 l_51_18 l_51_19 5.008854e-04
Rlh_51_19 l_51_19 l_52_19 5.008854e-04
Rlv_51_19 l_51_19 l_51_20 5.008854e-04
Rlh_51_20 l_51_20 l_52_20 5.008854e-04
Rlv_51_20 l_51_20 l_51_21 5.008854e-04
Rlh_51_21 l_51_21 l_52_21 5.008854e-04
Rlv_51_21 l_51_21 l_51_22 5.008854e-04
Rlh_51_22 l_51_22 l_52_22 5.008854e-04
Rlv_51_22 l_51_22 l_51_23 5.008854e-04
Rlh_51_23 l_51_23 l_52_23 5.008854e-04
Rlv_51_23 l_51_23 l_51_24 5.008854e-04
Rlh_51_24 l_51_24 l_52_24 5.008854e-04
Rlv_51_24 l_51_24 l_51_25 5.008854e-04
Rlh_51_25 l_51_25 l_52_25 5.008854e-04
Rlv_51_25 l_51_25 l_51_26 5.008854e-04
Rlh_51_26 l_51_26 l_52_26 5.008854e-04
Rlv_51_26 l_51_26 l_51_27 5.008854e-04
Rlh_51_27 l_51_27 l_52_27 5.008854e-04
Rlv_51_27 l_51_27 l_51_28 5.008854e-04
Rlh_51_28 l_51_28 l_52_28 5.008854e-04
Rlv_51_28 l_51_28 l_51_29 5.008854e-04
Rlh_51_29 l_51_29 l_52_29 5.008854e-04
Rlv_51_29 l_51_29 l_51_30 5.008854e-04
Rlh_51_30 l_51_30 l_52_30 5.008854e-04
Rlv_51_30 l_51_30 l_51_31 5.008854e-04
Rlh_51_31 l_51_31 l_52_31 5.008854e-04
Rlv_51_31 l_51_31 l_51_32 5.008854e-04
Rlh_51_32 l_51_32 l_52_32 5.008854e-04
Rlv_51_32 l_51_32 l_51_33 5.008854e-04
Rlh_51_33 l_51_33 l_52_33 5.008854e-04
Rlv_51_33 l_51_33 l_51_34 5.008854e-04
Rlh_51_34 l_51_34 l_52_34 5.008854e-04
Rlv_51_34 l_51_34 l_51_35 5.008854e-04
Rlh_51_35 l_51_35 l_52_35 5.008854e-04
Rlv_51_35 l_51_35 l_51_36 5.008854e-04
Rlh_51_36 l_51_36 l_52_36 5.008854e-04
Rlv_51_36 l_51_36 l_51_37 5.008854e-04
Rlh_51_37 l_51_37 l_52_37 5.008854e-04
Rlv_51_37 l_51_37 l_51_38 5.008854e-04
Rlh_51_38 l_51_38 l_52_38 5.008854e-04
Rlv_51_38 l_51_38 l_51_39 5.008854e-04
Rlh_51_39 l_51_39 l_52_39 5.008854e-04
Rlv_51_39 l_51_39 l_51_40 5.008854e-04
Rlh_51_40 l_51_40 l_52_40 5.008854e-04
Rlv_51_40 l_51_40 l_51_41 5.008854e-04
Rlh_51_41 l_51_41 l_52_41 5.008854e-04
Rlv_51_41 l_51_41 l_51_42 5.008854e-04
Rlh_51_42 l_51_42 l_52_42 5.008854e-04
Rlv_51_42 l_51_42 l_51_43 5.008854e-04
Rlh_51_43 l_51_43 l_52_43 5.008854e-04
Rlv_51_43 l_51_43 l_51_44 5.008854e-04
Rlh_51_44 l_51_44 l_52_44 5.008854e-04
Rlv_51_44 l_51_44 l_51_45 5.008854e-04
Rlh_51_45 l_51_45 l_52_45 5.008854e-04
Rlv_51_45 l_51_45 l_51_46 5.008854e-04
Rlh_51_46 l_51_46 l_52_46 5.008854e-04
Rlv_51_46 l_51_46 l_51_47 5.008854e-04
Rlh_51_47 l_51_47 l_52_47 5.008854e-04
Rlv_51_47 l_51_47 l_51_48 5.008854e-04
Rlh_51_48 l_51_48 l_52_48 5.008854e-04
Rlv_51_48 l_51_48 l_51_49 5.008854e-04
Rlh_51_49 l_51_49 l_52_49 5.008854e-04
Rlv_51_49 l_51_49 l_51_50 5.008854e-04
Rlh_51_50 l_51_50 l_52_50 5.008854e-04
Rlv_51_50 l_51_50 l_51_51 5.008854e-04
Rlh_51_51 l_51_51 l_52_51 5.008854e-04
Rlv_51_51 l_51_51 l_51_52 5.008854e-04
Rlh_51_52 l_51_52 l_52_52 5.008854e-04
Rlv_51_52 l_51_52 l_51_53 5.008854e-04
Rlh_51_53 l_51_53 l_52_53 5.008854e-04
Rlv_51_53 l_51_53 l_51_54 5.008854e-04
Rlh_51_54 l_51_54 l_52_54 5.008854e-04
Rlv_51_54 l_51_54 l_51_55 5.008854e-04
Rlh_51_55 l_51_55 l_52_55 5.008854e-04
Rlv_51_55 l_51_55 l_51_56 5.008854e-04
Rlh_51_56 l_51_56 l_52_56 5.008854e-04
Rlv_51_56 l_51_56 l_51_57 5.008854e-04
Rlh_51_57 l_51_57 l_52_57 5.008854e-04
Rlv_51_57 l_51_57 l_51_58 5.008854e-04
Rlh_51_58 l_51_58 l_52_58 5.008854e-04
Rlv_51_58 l_51_58 l_51_59 5.008854e-04
Rlh_51_59 l_51_59 l_52_59 5.008854e-04
Rlv_51_59 l_51_59 l_51_60 5.008854e-04
Rlh_51_60 l_51_60 l_52_60 5.008854e-04
Rlv_51_60 l_51_60 l_51_61 5.008854e-04
Rlh_51_61 l_51_61 l_52_61 5.008854e-04
Rlv_51_61 l_51_61 l_51_62 5.008854e-04
Rlh_51_62 l_51_62 l_52_62 5.008854e-04
Rlv_51_62 l_51_62 l_51_63 5.008854e-04
Rlh_51_63 l_51_63 l_52_63 5.008854e-04
Rlv_51_63 l_51_63 l_51_64 5.008854e-04
Rlh_51_64 l_51_64 l_52_64 5.008854e-04
Rlv_51_64 l_51_64 l_51_65 5.008854e-04
Rlh_51_65 l_51_65 l_52_65 5.008854e-04
Rlv_51_65 l_51_65 l_51_66 5.008854e-04
Rlh_51_66 l_51_66 l_52_66 5.008854e-04
Rlv_51_66 l_51_66 l_51_67 5.008854e-04
Rlh_51_67 l_51_67 l_52_67 5.008854e-04
Rlv_51_67 l_51_67 l_51_68 5.008854e-04
Rlh_51_68 l_51_68 l_52_68 5.008854e-04
Rlv_51_68 l_51_68 l_51_69 5.008854e-04
Rlh_51_69 l_51_69 l_52_69 5.008854e-04
Rlv_51_69 l_51_69 l_51_70 5.008854e-04
Rlh_51_70 l_51_70 l_52_70 5.008854e-04
Rlv_51_70 l_51_70 l_51_71 5.008854e-04
Rlh_51_71 l_51_71 l_52_71 5.008854e-04
Rlh_52_0 l_52_0 l_53_0 5.008854e-04
Rlv_52_0 l_52_0 l_52_1 5.008854e-04
Rlh_52_1 l_52_1 l_53_1 5.008854e-04
Rlv_52_1 l_52_1 l_52_2 5.008854e-04
Rlh_52_2 l_52_2 l_53_2 5.008854e-04
Rlv_52_2 l_52_2 l_52_3 5.008854e-04
Rlh_52_3 l_52_3 l_53_3 5.008854e-04
Rlv_52_3 l_52_3 l_52_4 5.008854e-04
Rlh_52_4 l_52_4 l_53_4 5.008854e-04
Rlv_52_4 l_52_4 l_52_5 5.008854e-04
Rlh_52_5 l_52_5 l_53_5 5.008854e-04
Rlv_52_5 l_52_5 l_52_6 5.008854e-04
Rlh_52_6 l_52_6 l_53_6 5.008854e-04
Rlv_52_6 l_52_6 l_52_7 5.008854e-04
Rlh_52_7 l_52_7 l_53_7 5.008854e-04
Rlv_52_7 l_52_7 l_52_8 5.008854e-04
Rlh_52_8 l_52_8 l_53_8 5.008854e-04
Rlv_52_8 l_52_8 l_52_9 5.008854e-04
Rlh_52_9 l_52_9 l_53_9 5.008854e-04
Rlv_52_9 l_52_9 l_52_10 5.008854e-04
Rlh_52_10 l_52_10 l_53_10 5.008854e-04
Rlv_52_10 l_52_10 l_52_11 5.008854e-04
Rlh_52_11 l_52_11 l_53_11 5.008854e-04
Rlv_52_11 l_52_11 l_52_12 5.008854e-04
Rlh_52_12 l_52_12 l_53_12 5.008854e-04
Rlv_52_12 l_52_12 l_52_13 5.008854e-04
Rlh_52_13 l_52_13 l_53_13 5.008854e-04
Rlv_52_13 l_52_13 l_52_14 5.008854e-04
Rlh_52_14 l_52_14 l_53_14 5.008854e-04
Rlv_52_14 l_52_14 l_52_15 5.008854e-04
Rlh_52_15 l_52_15 l_53_15 5.008854e-04
Rlv_52_15 l_52_15 l_52_16 5.008854e-04
Rlh_52_16 l_52_16 l_53_16 5.008854e-04
Rlv_52_16 l_52_16 l_52_17 5.008854e-04
Rlh_52_17 l_52_17 l_53_17 5.008854e-04
Rlv_52_17 l_52_17 l_52_18 5.008854e-04
Rlh_52_18 l_52_18 l_53_18 5.008854e-04
Rlv_52_18 l_52_18 l_52_19 5.008854e-04
Rlh_52_19 l_52_19 l_53_19 5.008854e-04
Rlv_52_19 l_52_19 l_52_20 5.008854e-04
Rlh_52_20 l_52_20 l_53_20 5.008854e-04
Rlv_52_20 l_52_20 l_52_21 5.008854e-04
Rlh_52_21 l_52_21 l_53_21 5.008854e-04
Rlv_52_21 l_52_21 l_52_22 5.008854e-04
Rlh_52_22 l_52_22 l_53_22 5.008854e-04
Rlv_52_22 l_52_22 l_52_23 5.008854e-04
Rlh_52_23 l_52_23 l_53_23 5.008854e-04
Rlv_52_23 l_52_23 l_52_24 5.008854e-04
Rlh_52_24 l_52_24 l_53_24 5.008854e-04
Rlv_52_24 l_52_24 l_52_25 5.008854e-04
Rlh_52_25 l_52_25 l_53_25 5.008854e-04
Rlv_52_25 l_52_25 l_52_26 5.008854e-04
Rlh_52_26 l_52_26 l_53_26 5.008854e-04
Rlv_52_26 l_52_26 l_52_27 5.008854e-04
Rlh_52_27 l_52_27 l_53_27 5.008854e-04
Rlv_52_27 l_52_27 l_52_28 5.008854e-04
Rlh_52_28 l_52_28 l_53_28 5.008854e-04
Rlv_52_28 l_52_28 l_52_29 5.008854e-04
Rlh_52_29 l_52_29 l_53_29 5.008854e-04
Rlv_52_29 l_52_29 l_52_30 5.008854e-04
Rlh_52_30 l_52_30 l_53_30 5.008854e-04
Rlv_52_30 l_52_30 l_52_31 5.008854e-04
Rlh_52_31 l_52_31 l_53_31 5.008854e-04
Rlv_52_31 l_52_31 l_52_32 5.008854e-04
Rlh_52_32 l_52_32 l_53_32 5.008854e-04
Rlv_52_32 l_52_32 l_52_33 5.008854e-04
Rlh_52_33 l_52_33 l_53_33 5.008854e-04
Rlv_52_33 l_52_33 l_52_34 5.008854e-04
Rlh_52_34 l_52_34 l_53_34 5.008854e-04
Rlv_52_34 l_52_34 l_52_35 5.008854e-04
Rlh_52_35 l_52_35 l_53_35 5.008854e-04
Rlv_52_35 l_52_35 l_52_36 5.008854e-04
Rlh_52_36 l_52_36 l_53_36 5.008854e-04
Rlv_52_36 l_52_36 l_52_37 5.008854e-04
Rlh_52_37 l_52_37 l_53_37 5.008854e-04
Rlv_52_37 l_52_37 l_52_38 5.008854e-04
Rlh_52_38 l_52_38 l_53_38 5.008854e-04
Rlv_52_38 l_52_38 l_52_39 5.008854e-04
Rlh_52_39 l_52_39 l_53_39 5.008854e-04
Rlv_52_39 l_52_39 l_52_40 5.008854e-04
Rlh_52_40 l_52_40 l_53_40 5.008854e-04
Rlv_52_40 l_52_40 l_52_41 5.008854e-04
Rlh_52_41 l_52_41 l_53_41 5.008854e-04
Rlv_52_41 l_52_41 l_52_42 5.008854e-04
Rlh_52_42 l_52_42 l_53_42 5.008854e-04
Rlv_52_42 l_52_42 l_52_43 5.008854e-04
Rlh_52_43 l_52_43 l_53_43 5.008854e-04
Rlv_52_43 l_52_43 l_52_44 5.008854e-04
Rlh_52_44 l_52_44 l_53_44 5.008854e-04
Rlv_52_44 l_52_44 l_52_45 5.008854e-04
Rlh_52_45 l_52_45 l_53_45 5.008854e-04
Rlv_52_45 l_52_45 l_52_46 5.008854e-04
Rlh_52_46 l_52_46 l_53_46 5.008854e-04
Rlv_52_46 l_52_46 l_52_47 5.008854e-04
Rlh_52_47 l_52_47 l_53_47 5.008854e-04
Rlv_52_47 l_52_47 l_52_48 5.008854e-04
Rlh_52_48 l_52_48 l_53_48 5.008854e-04
Rlv_52_48 l_52_48 l_52_49 5.008854e-04
Rlh_52_49 l_52_49 l_53_49 5.008854e-04
Rlv_52_49 l_52_49 l_52_50 5.008854e-04
Rlh_52_50 l_52_50 l_53_50 5.008854e-04
Rlv_52_50 l_52_50 l_52_51 5.008854e-04
Rlh_52_51 l_52_51 l_53_51 5.008854e-04
Rlv_52_51 l_52_51 l_52_52 5.008854e-04
Rlh_52_52 l_52_52 l_53_52 5.008854e-04
Rlv_52_52 l_52_52 l_52_53 5.008854e-04
Rlh_52_53 l_52_53 l_53_53 5.008854e-04
Rlv_52_53 l_52_53 l_52_54 5.008854e-04
Rlh_52_54 l_52_54 l_53_54 5.008854e-04
Rlv_52_54 l_52_54 l_52_55 5.008854e-04
Rlh_52_55 l_52_55 l_53_55 5.008854e-04
Rlv_52_55 l_52_55 l_52_56 5.008854e-04
Rlh_52_56 l_52_56 l_53_56 5.008854e-04
Rlv_52_56 l_52_56 l_52_57 5.008854e-04
Rlh_52_57 l_52_57 l_53_57 5.008854e-04
Rlv_52_57 l_52_57 l_52_58 5.008854e-04
Rlh_52_58 l_52_58 l_53_58 5.008854e-04
Rlv_52_58 l_52_58 l_52_59 5.008854e-04
Rlh_52_59 l_52_59 l_53_59 5.008854e-04
Rlv_52_59 l_52_59 l_52_60 5.008854e-04
Rlh_52_60 l_52_60 l_53_60 5.008854e-04
Rlv_52_60 l_52_60 l_52_61 5.008854e-04
Rlh_52_61 l_52_61 l_53_61 5.008854e-04
Rlv_52_61 l_52_61 l_52_62 5.008854e-04
Rlh_52_62 l_52_62 l_53_62 5.008854e-04
Rlv_52_62 l_52_62 l_52_63 5.008854e-04
Rlh_52_63 l_52_63 l_53_63 5.008854e-04
Rlv_52_63 l_52_63 l_52_64 5.008854e-04
Rlh_52_64 l_52_64 l_53_64 5.008854e-04
Rlv_52_64 l_52_64 l_52_65 5.008854e-04
Rlh_52_65 l_52_65 l_53_65 5.008854e-04
Rlv_52_65 l_52_65 l_52_66 5.008854e-04
Rlh_52_66 l_52_66 l_53_66 5.008854e-04
Rlv_52_66 l_52_66 l_52_67 5.008854e-04
Rlh_52_67 l_52_67 l_53_67 5.008854e-04
Rlv_52_67 l_52_67 l_52_68 5.008854e-04
Rlh_52_68 l_52_68 l_53_68 5.008854e-04
Rlv_52_68 l_52_68 l_52_69 5.008854e-04
Rlh_52_69 l_52_69 l_53_69 5.008854e-04
Rlv_52_69 l_52_69 l_52_70 5.008854e-04
Rlh_52_70 l_52_70 l_53_70 5.008854e-04
Rlv_52_70 l_52_70 l_52_71 5.008854e-04
Rlh_52_71 l_52_71 l_53_71 5.008854e-04
Rlh_53_0 l_53_0 l_54_0 5.008854e-04
Rlv_53_0 l_53_0 l_53_1 5.008854e-04
Rlh_53_1 l_53_1 l_54_1 5.008854e-04
Rlv_53_1 l_53_1 l_53_2 5.008854e-04
Rlh_53_2 l_53_2 l_54_2 5.008854e-04
Rlv_53_2 l_53_2 l_53_3 5.008854e-04
Rlh_53_3 l_53_3 l_54_3 5.008854e-04
Rlv_53_3 l_53_3 l_53_4 5.008854e-04
Rlh_53_4 l_53_4 l_54_4 5.008854e-04
Rlv_53_4 l_53_4 l_53_5 5.008854e-04
Rlh_53_5 l_53_5 l_54_5 5.008854e-04
Rlv_53_5 l_53_5 l_53_6 5.008854e-04
Rlh_53_6 l_53_6 l_54_6 5.008854e-04
Rlv_53_6 l_53_6 l_53_7 5.008854e-04
Rlh_53_7 l_53_7 l_54_7 5.008854e-04
Rlv_53_7 l_53_7 l_53_8 5.008854e-04
Rlh_53_8 l_53_8 l_54_8 5.008854e-04
Rlv_53_8 l_53_8 l_53_9 5.008854e-04
Rlh_53_9 l_53_9 l_54_9 5.008854e-04
Rlv_53_9 l_53_9 l_53_10 5.008854e-04
Rlh_53_10 l_53_10 l_54_10 5.008854e-04
Rlv_53_10 l_53_10 l_53_11 5.008854e-04
Rlh_53_11 l_53_11 l_54_11 5.008854e-04
Rlv_53_11 l_53_11 l_53_12 5.008854e-04
Rlh_53_12 l_53_12 l_54_12 5.008854e-04
Rlv_53_12 l_53_12 l_53_13 5.008854e-04
Rlh_53_13 l_53_13 l_54_13 5.008854e-04
Rlv_53_13 l_53_13 l_53_14 5.008854e-04
Rlh_53_14 l_53_14 l_54_14 5.008854e-04
Rlv_53_14 l_53_14 l_53_15 5.008854e-04
Rlh_53_15 l_53_15 l_54_15 5.008854e-04
Rlv_53_15 l_53_15 l_53_16 5.008854e-04
Rlh_53_16 l_53_16 l_54_16 5.008854e-04
Rlv_53_16 l_53_16 l_53_17 5.008854e-04
Rlh_53_17 l_53_17 l_54_17 5.008854e-04
Rlv_53_17 l_53_17 l_53_18 5.008854e-04
Rlh_53_18 l_53_18 l_54_18 5.008854e-04
Rlv_53_18 l_53_18 l_53_19 5.008854e-04
Rlh_53_19 l_53_19 l_54_19 5.008854e-04
Rlv_53_19 l_53_19 l_53_20 5.008854e-04
Rlh_53_20 l_53_20 l_54_20 5.008854e-04
Rlv_53_20 l_53_20 l_53_21 5.008854e-04
Rlh_53_21 l_53_21 l_54_21 5.008854e-04
Rlv_53_21 l_53_21 l_53_22 5.008854e-04
Rlh_53_22 l_53_22 l_54_22 5.008854e-04
Rlv_53_22 l_53_22 l_53_23 5.008854e-04
Rlh_53_23 l_53_23 l_54_23 5.008854e-04
Rlv_53_23 l_53_23 l_53_24 5.008854e-04
Rlh_53_24 l_53_24 l_54_24 5.008854e-04
Rlv_53_24 l_53_24 l_53_25 5.008854e-04
Rlh_53_25 l_53_25 l_54_25 5.008854e-04
Rlv_53_25 l_53_25 l_53_26 5.008854e-04
Rlh_53_26 l_53_26 l_54_26 5.008854e-04
Rlv_53_26 l_53_26 l_53_27 5.008854e-04
Rlh_53_27 l_53_27 l_54_27 5.008854e-04
Rlv_53_27 l_53_27 l_53_28 5.008854e-04
Rlh_53_28 l_53_28 l_54_28 5.008854e-04
Rlv_53_28 l_53_28 l_53_29 5.008854e-04
Rlh_53_29 l_53_29 l_54_29 5.008854e-04
Rlv_53_29 l_53_29 l_53_30 5.008854e-04
Rlh_53_30 l_53_30 l_54_30 5.008854e-04
Rlv_53_30 l_53_30 l_53_31 5.008854e-04
Rlh_53_31 l_53_31 l_54_31 5.008854e-04
Rlv_53_31 l_53_31 l_53_32 5.008854e-04
Rlh_53_32 l_53_32 l_54_32 5.008854e-04
Rlv_53_32 l_53_32 l_53_33 5.008854e-04
Rlh_53_33 l_53_33 l_54_33 5.008854e-04
Rlv_53_33 l_53_33 l_53_34 5.008854e-04
Rlh_53_34 l_53_34 l_54_34 5.008854e-04
Rlv_53_34 l_53_34 l_53_35 5.008854e-04
Rlh_53_35 l_53_35 l_54_35 5.008854e-04
Rlv_53_35 l_53_35 l_53_36 5.008854e-04
Rlh_53_36 l_53_36 l_54_36 5.008854e-04
Rlv_53_36 l_53_36 l_53_37 5.008854e-04
Rlh_53_37 l_53_37 l_54_37 5.008854e-04
Rlv_53_37 l_53_37 l_53_38 5.008854e-04
Rlh_53_38 l_53_38 l_54_38 5.008854e-04
Rlv_53_38 l_53_38 l_53_39 5.008854e-04
Rlh_53_39 l_53_39 l_54_39 5.008854e-04
Rlv_53_39 l_53_39 l_53_40 5.008854e-04
Rlh_53_40 l_53_40 l_54_40 5.008854e-04
Rlv_53_40 l_53_40 l_53_41 5.008854e-04
Rlh_53_41 l_53_41 l_54_41 5.008854e-04
Rlv_53_41 l_53_41 l_53_42 5.008854e-04
Rlh_53_42 l_53_42 l_54_42 5.008854e-04
Rlv_53_42 l_53_42 l_53_43 5.008854e-04
Rlh_53_43 l_53_43 l_54_43 5.008854e-04
Rlv_53_43 l_53_43 l_53_44 5.008854e-04
Rlh_53_44 l_53_44 l_54_44 5.008854e-04
Rlv_53_44 l_53_44 l_53_45 5.008854e-04
Rlh_53_45 l_53_45 l_54_45 5.008854e-04
Rlv_53_45 l_53_45 l_53_46 5.008854e-04
Rlh_53_46 l_53_46 l_54_46 5.008854e-04
Rlv_53_46 l_53_46 l_53_47 5.008854e-04
Rlh_53_47 l_53_47 l_54_47 5.008854e-04
Rlv_53_47 l_53_47 l_53_48 5.008854e-04
Rlh_53_48 l_53_48 l_54_48 5.008854e-04
Rlv_53_48 l_53_48 l_53_49 5.008854e-04
Rlh_53_49 l_53_49 l_54_49 5.008854e-04
Rlv_53_49 l_53_49 l_53_50 5.008854e-04
Rlh_53_50 l_53_50 l_54_50 5.008854e-04
Rlv_53_50 l_53_50 l_53_51 5.008854e-04
Rlh_53_51 l_53_51 l_54_51 5.008854e-04
Rlv_53_51 l_53_51 l_53_52 5.008854e-04
Rlh_53_52 l_53_52 l_54_52 5.008854e-04
Rlv_53_52 l_53_52 l_53_53 5.008854e-04
Rlh_53_53 l_53_53 l_54_53 5.008854e-04
Rlv_53_53 l_53_53 l_53_54 5.008854e-04
Rlh_53_54 l_53_54 l_54_54 5.008854e-04
Rlv_53_54 l_53_54 l_53_55 5.008854e-04
Rlh_53_55 l_53_55 l_54_55 5.008854e-04
Rlv_53_55 l_53_55 l_53_56 5.008854e-04
Rlh_53_56 l_53_56 l_54_56 5.008854e-04
Rlv_53_56 l_53_56 l_53_57 5.008854e-04
Rlh_53_57 l_53_57 l_54_57 5.008854e-04
Rlv_53_57 l_53_57 l_53_58 5.008854e-04
Rlh_53_58 l_53_58 l_54_58 5.008854e-04
Rlv_53_58 l_53_58 l_53_59 5.008854e-04
Rlh_53_59 l_53_59 l_54_59 5.008854e-04
Rlv_53_59 l_53_59 l_53_60 5.008854e-04
Rlh_53_60 l_53_60 l_54_60 5.008854e-04
Rlv_53_60 l_53_60 l_53_61 5.008854e-04
Rlh_53_61 l_53_61 l_54_61 5.008854e-04
Rlv_53_61 l_53_61 l_53_62 5.008854e-04
Rlh_53_62 l_53_62 l_54_62 5.008854e-04
Rlv_53_62 l_53_62 l_53_63 5.008854e-04
Rlh_53_63 l_53_63 l_54_63 5.008854e-04
Rlv_53_63 l_53_63 l_53_64 5.008854e-04
Rlh_53_64 l_53_64 l_54_64 5.008854e-04
Rlv_53_64 l_53_64 l_53_65 5.008854e-04
Rlh_53_65 l_53_65 l_54_65 5.008854e-04
Rlv_53_65 l_53_65 l_53_66 5.008854e-04
Rlh_53_66 l_53_66 l_54_66 5.008854e-04
Rlv_53_66 l_53_66 l_53_67 5.008854e-04
Rlh_53_67 l_53_67 l_54_67 5.008854e-04
Rlv_53_67 l_53_67 l_53_68 5.008854e-04
Rlh_53_68 l_53_68 l_54_68 5.008854e-04
Rlv_53_68 l_53_68 l_53_69 5.008854e-04
Rlh_53_69 l_53_69 l_54_69 5.008854e-04
Rlv_53_69 l_53_69 l_53_70 5.008854e-04
Rlh_53_70 l_53_70 l_54_70 5.008854e-04
Rlv_53_70 l_53_70 l_53_71 5.008854e-04
Rlh_53_71 l_53_71 l_54_71 5.008854e-04
Rlh_54_0 l_54_0 l_55_0 5.008854e-04
Rlv_54_0 l_54_0 l_54_1 5.008854e-04
Rlh_54_1 l_54_1 l_55_1 5.008854e-04
Rlv_54_1 l_54_1 l_54_2 5.008854e-04
Rlh_54_2 l_54_2 l_55_2 5.008854e-04
Rlv_54_2 l_54_2 l_54_3 5.008854e-04
Rlh_54_3 l_54_3 l_55_3 5.008854e-04
Rlv_54_3 l_54_3 l_54_4 5.008854e-04
Rlh_54_4 l_54_4 l_55_4 5.008854e-04
Rlv_54_4 l_54_4 l_54_5 5.008854e-04
Rlh_54_5 l_54_5 l_55_5 5.008854e-04
Rlv_54_5 l_54_5 l_54_6 5.008854e-04
Rlh_54_6 l_54_6 l_55_6 5.008854e-04
Rlv_54_6 l_54_6 l_54_7 5.008854e-04
Rlh_54_7 l_54_7 l_55_7 5.008854e-04
Rlv_54_7 l_54_7 l_54_8 5.008854e-04
Rlh_54_8 l_54_8 l_55_8 5.008854e-04
Rlv_54_8 l_54_8 l_54_9 5.008854e-04
Rlh_54_9 l_54_9 l_55_9 5.008854e-04
Rlv_54_9 l_54_9 l_54_10 5.008854e-04
Rlh_54_10 l_54_10 l_55_10 5.008854e-04
Rlv_54_10 l_54_10 l_54_11 5.008854e-04
Rlh_54_11 l_54_11 l_55_11 5.008854e-04
Rlv_54_11 l_54_11 l_54_12 5.008854e-04
Rlh_54_12 l_54_12 l_55_12 5.008854e-04
Rlv_54_12 l_54_12 l_54_13 5.008854e-04
Rlh_54_13 l_54_13 l_55_13 5.008854e-04
Rlv_54_13 l_54_13 l_54_14 5.008854e-04
Rlh_54_14 l_54_14 l_55_14 5.008854e-04
Rlv_54_14 l_54_14 l_54_15 5.008854e-04
Rlh_54_15 l_54_15 l_55_15 5.008854e-04
Rlv_54_15 l_54_15 l_54_16 5.008854e-04
Rlh_54_16 l_54_16 l_55_16 5.008854e-04
Rlv_54_16 l_54_16 l_54_17 5.008854e-04
Rlh_54_17 l_54_17 l_55_17 5.008854e-04
Rlv_54_17 l_54_17 l_54_18 5.008854e-04
Rlh_54_18 l_54_18 l_55_18 5.008854e-04
Rlv_54_18 l_54_18 l_54_19 5.008854e-04
Rlh_54_19 l_54_19 l_55_19 5.008854e-04
Rlv_54_19 l_54_19 l_54_20 5.008854e-04
Rlh_54_20 l_54_20 l_55_20 5.008854e-04
Rlv_54_20 l_54_20 l_54_21 5.008854e-04
Rlh_54_21 l_54_21 l_55_21 5.008854e-04
Rlv_54_21 l_54_21 l_54_22 5.008854e-04
Rlh_54_22 l_54_22 l_55_22 5.008854e-04
Rlv_54_22 l_54_22 l_54_23 5.008854e-04
Rlh_54_23 l_54_23 l_55_23 5.008854e-04
Rlv_54_23 l_54_23 l_54_24 5.008854e-04
Rlh_54_24 l_54_24 l_55_24 5.008854e-04
Rlv_54_24 l_54_24 l_54_25 5.008854e-04
Rlh_54_25 l_54_25 l_55_25 5.008854e-04
Rlv_54_25 l_54_25 l_54_26 5.008854e-04
Rlh_54_26 l_54_26 l_55_26 5.008854e-04
Rlv_54_26 l_54_26 l_54_27 5.008854e-04
Rlh_54_27 l_54_27 l_55_27 5.008854e-04
Rlv_54_27 l_54_27 l_54_28 5.008854e-04
Rlh_54_28 l_54_28 l_55_28 5.008854e-04
Rlv_54_28 l_54_28 l_54_29 5.008854e-04
Rlh_54_29 l_54_29 l_55_29 5.008854e-04
Rlv_54_29 l_54_29 l_54_30 5.008854e-04
Rlh_54_30 l_54_30 l_55_30 5.008854e-04
Rlv_54_30 l_54_30 l_54_31 5.008854e-04
Rlh_54_31 l_54_31 l_55_31 5.008854e-04
Rlv_54_31 l_54_31 l_54_32 5.008854e-04
Rlh_54_32 l_54_32 l_55_32 5.008854e-04
Rlv_54_32 l_54_32 l_54_33 5.008854e-04
Rlh_54_33 l_54_33 l_55_33 5.008854e-04
Rlv_54_33 l_54_33 l_54_34 5.008854e-04
Rlh_54_34 l_54_34 l_55_34 5.008854e-04
Rlv_54_34 l_54_34 l_54_35 5.008854e-04
Rlh_54_35 l_54_35 l_55_35 5.008854e-04
Rlv_54_35 l_54_35 l_54_36 5.008854e-04
Rlh_54_36 l_54_36 l_55_36 5.008854e-04
Rlv_54_36 l_54_36 l_54_37 5.008854e-04
Rlh_54_37 l_54_37 l_55_37 5.008854e-04
Rlv_54_37 l_54_37 l_54_38 5.008854e-04
Rlh_54_38 l_54_38 l_55_38 5.008854e-04
Rlv_54_38 l_54_38 l_54_39 5.008854e-04
Rlh_54_39 l_54_39 l_55_39 5.008854e-04
Rlv_54_39 l_54_39 l_54_40 5.008854e-04
Rlh_54_40 l_54_40 l_55_40 5.008854e-04
Rlv_54_40 l_54_40 l_54_41 5.008854e-04
Rlh_54_41 l_54_41 l_55_41 5.008854e-04
Rlv_54_41 l_54_41 l_54_42 5.008854e-04
Rlh_54_42 l_54_42 l_55_42 5.008854e-04
Rlv_54_42 l_54_42 l_54_43 5.008854e-04
Rlh_54_43 l_54_43 l_55_43 5.008854e-04
Rlv_54_43 l_54_43 l_54_44 5.008854e-04
Rlh_54_44 l_54_44 l_55_44 5.008854e-04
Rlv_54_44 l_54_44 l_54_45 5.008854e-04
Rlh_54_45 l_54_45 l_55_45 5.008854e-04
Rlv_54_45 l_54_45 l_54_46 5.008854e-04
Rlh_54_46 l_54_46 l_55_46 5.008854e-04
Rlv_54_46 l_54_46 l_54_47 5.008854e-04
Rlh_54_47 l_54_47 l_55_47 5.008854e-04
Rlv_54_47 l_54_47 l_54_48 5.008854e-04
Rlh_54_48 l_54_48 l_55_48 5.008854e-04
Rlv_54_48 l_54_48 l_54_49 5.008854e-04
Rlh_54_49 l_54_49 l_55_49 5.008854e-04
Rlv_54_49 l_54_49 l_54_50 5.008854e-04
Rlh_54_50 l_54_50 l_55_50 5.008854e-04
Rlv_54_50 l_54_50 l_54_51 5.008854e-04
Rlh_54_51 l_54_51 l_55_51 5.008854e-04
Rlv_54_51 l_54_51 l_54_52 5.008854e-04
Rlh_54_52 l_54_52 l_55_52 5.008854e-04
Rlv_54_52 l_54_52 l_54_53 5.008854e-04
Rlh_54_53 l_54_53 l_55_53 5.008854e-04
Rlv_54_53 l_54_53 l_54_54 5.008854e-04
Rlh_54_54 l_54_54 l_55_54 5.008854e-04
Rlv_54_54 l_54_54 l_54_55 5.008854e-04
Rlh_54_55 l_54_55 l_55_55 5.008854e-04
Rlv_54_55 l_54_55 l_54_56 5.008854e-04
Rlh_54_56 l_54_56 l_55_56 5.008854e-04
Rlv_54_56 l_54_56 l_54_57 5.008854e-04
Rlh_54_57 l_54_57 l_55_57 5.008854e-04
Rlv_54_57 l_54_57 l_54_58 5.008854e-04
Rlh_54_58 l_54_58 l_55_58 5.008854e-04
Rlv_54_58 l_54_58 l_54_59 5.008854e-04
Rlh_54_59 l_54_59 l_55_59 5.008854e-04
Rlv_54_59 l_54_59 l_54_60 5.008854e-04
Rlh_54_60 l_54_60 l_55_60 5.008854e-04
Rlv_54_60 l_54_60 l_54_61 5.008854e-04
Rlh_54_61 l_54_61 l_55_61 5.008854e-04
Rlv_54_61 l_54_61 l_54_62 5.008854e-04
Rlh_54_62 l_54_62 l_55_62 5.008854e-04
Rlv_54_62 l_54_62 l_54_63 5.008854e-04
Rlh_54_63 l_54_63 l_55_63 5.008854e-04
Rlv_54_63 l_54_63 l_54_64 5.008854e-04
Rlh_54_64 l_54_64 l_55_64 5.008854e-04
Rlv_54_64 l_54_64 l_54_65 5.008854e-04
Rlh_54_65 l_54_65 l_55_65 5.008854e-04
Rlv_54_65 l_54_65 l_54_66 5.008854e-04
Rlh_54_66 l_54_66 l_55_66 5.008854e-04
Rlv_54_66 l_54_66 l_54_67 5.008854e-04
Rlh_54_67 l_54_67 l_55_67 5.008854e-04
Rlv_54_67 l_54_67 l_54_68 5.008854e-04
Rlh_54_68 l_54_68 l_55_68 5.008854e-04
Rlv_54_68 l_54_68 l_54_69 5.008854e-04
Rlh_54_69 l_54_69 l_55_69 5.008854e-04
Rlv_54_69 l_54_69 l_54_70 5.008854e-04
Rlh_54_70 l_54_70 l_55_70 5.008854e-04
Rlv_54_70 l_54_70 l_54_71 5.008854e-04
Rlh_54_71 l_54_71 l_55_71 5.008854e-04
Rlh_55_0 l_55_0 l_56_0 5.008854e-04
Rlv_55_0 l_55_0 l_55_1 5.008854e-04
Rlh_55_1 l_55_1 l_56_1 5.008854e-04
Rlv_55_1 l_55_1 l_55_2 5.008854e-04
Rlh_55_2 l_55_2 l_56_2 5.008854e-04
Rlv_55_2 l_55_2 l_55_3 5.008854e-04
Rlh_55_3 l_55_3 l_56_3 5.008854e-04
Rlv_55_3 l_55_3 l_55_4 5.008854e-04
Rlh_55_4 l_55_4 l_56_4 5.008854e-04
Rlv_55_4 l_55_4 l_55_5 5.008854e-04
Rlh_55_5 l_55_5 l_56_5 5.008854e-04
Rlv_55_5 l_55_5 l_55_6 5.008854e-04
Rlh_55_6 l_55_6 l_56_6 5.008854e-04
Rlv_55_6 l_55_6 l_55_7 5.008854e-04
Rlh_55_7 l_55_7 l_56_7 5.008854e-04
Rlv_55_7 l_55_7 l_55_8 5.008854e-04
Rlh_55_8 l_55_8 l_56_8 5.008854e-04
Rlv_55_8 l_55_8 l_55_9 5.008854e-04
Rlh_55_9 l_55_9 l_56_9 5.008854e-04
Rlv_55_9 l_55_9 l_55_10 5.008854e-04
Rlh_55_10 l_55_10 l_56_10 5.008854e-04
Rlv_55_10 l_55_10 l_55_11 5.008854e-04
Rlh_55_11 l_55_11 l_56_11 5.008854e-04
Rlv_55_11 l_55_11 l_55_12 5.008854e-04
Rlh_55_12 l_55_12 l_56_12 5.008854e-04
Rlv_55_12 l_55_12 l_55_13 5.008854e-04
Rlh_55_13 l_55_13 l_56_13 5.008854e-04
Rlv_55_13 l_55_13 l_55_14 5.008854e-04
Rlh_55_14 l_55_14 l_56_14 5.008854e-04
Rlv_55_14 l_55_14 l_55_15 5.008854e-04
Rlh_55_15 l_55_15 l_56_15 5.008854e-04
Rlv_55_15 l_55_15 l_55_16 5.008854e-04
Rlh_55_16 l_55_16 l_56_16 5.008854e-04
Rlv_55_16 l_55_16 l_55_17 5.008854e-04
Rlh_55_17 l_55_17 l_56_17 5.008854e-04
Rlv_55_17 l_55_17 l_55_18 5.008854e-04
Rlh_55_18 l_55_18 l_56_18 5.008854e-04
Rlv_55_18 l_55_18 l_55_19 5.008854e-04
Rlh_55_19 l_55_19 l_56_19 5.008854e-04
Rlv_55_19 l_55_19 l_55_20 5.008854e-04
Rlh_55_20 l_55_20 l_56_20 5.008854e-04
Rlv_55_20 l_55_20 l_55_21 5.008854e-04
Rlh_55_21 l_55_21 l_56_21 5.008854e-04
Rlv_55_21 l_55_21 l_55_22 5.008854e-04
Rlh_55_22 l_55_22 l_56_22 5.008854e-04
Rlv_55_22 l_55_22 l_55_23 5.008854e-04
Rlh_55_23 l_55_23 l_56_23 5.008854e-04
Rlv_55_23 l_55_23 l_55_24 5.008854e-04
Rlh_55_24 l_55_24 l_56_24 5.008854e-04
Rlv_55_24 l_55_24 l_55_25 5.008854e-04
Rlh_55_25 l_55_25 l_56_25 5.008854e-04
Rlv_55_25 l_55_25 l_55_26 5.008854e-04
Rlh_55_26 l_55_26 l_56_26 5.008854e-04
Rlv_55_26 l_55_26 l_55_27 5.008854e-04
Rlh_55_27 l_55_27 l_56_27 5.008854e-04
Rlv_55_27 l_55_27 l_55_28 5.008854e-04
Rlh_55_28 l_55_28 l_56_28 5.008854e-04
Rlv_55_28 l_55_28 l_55_29 5.008854e-04
Rlh_55_29 l_55_29 l_56_29 5.008854e-04
Rlv_55_29 l_55_29 l_55_30 5.008854e-04
Rlh_55_30 l_55_30 l_56_30 5.008854e-04
Rlv_55_30 l_55_30 l_55_31 5.008854e-04
Rlh_55_31 l_55_31 l_56_31 5.008854e-04
Rlv_55_31 l_55_31 l_55_32 5.008854e-04
Rlh_55_32 l_55_32 l_56_32 5.008854e-04
Rlv_55_32 l_55_32 l_55_33 5.008854e-04
Rlh_55_33 l_55_33 l_56_33 5.008854e-04
Rlv_55_33 l_55_33 l_55_34 5.008854e-04
Rlh_55_34 l_55_34 l_56_34 5.008854e-04
Rlv_55_34 l_55_34 l_55_35 5.008854e-04
Rlh_55_35 l_55_35 l_56_35 5.008854e-04
Rlv_55_35 l_55_35 l_55_36 5.008854e-04
Rlh_55_36 l_55_36 l_56_36 5.008854e-04
Rlv_55_36 l_55_36 l_55_37 5.008854e-04
Rlh_55_37 l_55_37 l_56_37 5.008854e-04
Rlv_55_37 l_55_37 l_55_38 5.008854e-04
Rlh_55_38 l_55_38 l_56_38 5.008854e-04
Rlv_55_38 l_55_38 l_55_39 5.008854e-04
Rlh_55_39 l_55_39 l_56_39 5.008854e-04
Rlv_55_39 l_55_39 l_55_40 5.008854e-04
Rlh_55_40 l_55_40 l_56_40 5.008854e-04
Rlv_55_40 l_55_40 l_55_41 5.008854e-04
Rlh_55_41 l_55_41 l_56_41 5.008854e-04
Rlv_55_41 l_55_41 l_55_42 5.008854e-04
Rlh_55_42 l_55_42 l_56_42 5.008854e-04
Rlv_55_42 l_55_42 l_55_43 5.008854e-04
Rlh_55_43 l_55_43 l_56_43 5.008854e-04
Rlv_55_43 l_55_43 l_55_44 5.008854e-04
Rlh_55_44 l_55_44 l_56_44 5.008854e-04
Rlv_55_44 l_55_44 l_55_45 5.008854e-04
Rlh_55_45 l_55_45 l_56_45 5.008854e-04
Rlv_55_45 l_55_45 l_55_46 5.008854e-04
Rlh_55_46 l_55_46 l_56_46 5.008854e-04
Rlv_55_46 l_55_46 l_55_47 5.008854e-04
Rlh_55_47 l_55_47 l_56_47 5.008854e-04
Rlv_55_47 l_55_47 l_55_48 5.008854e-04
Rlh_55_48 l_55_48 l_56_48 5.008854e-04
Rlv_55_48 l_55_48 l_55_49 5.008854e-04
Rlh_55_49 l_55_49 l_56_49 5.008854e-04
Rlv_55_49 l_55_49 l_55_50 5.008854e-04
Rlh_55_50 l_55_50 l_56_50 5.008854e-04
Rlv_55_50 l_55_50 l_55_51 5.008854e-04
Rlh_55_51 l_55_51 l_56_51 5.008854e-04
Rlv_55_51 l_55_51 l_55_52 5.008854e-04
Rlh_55_52 l_55_52 l_56_52 5.008854e-04
Rlv_55_52 l_55_52 l_55_53 5.008854e-04
Rlh_55_53 l_55_53 l_56_53 5.008854e-04
Rlv_55_53 l_55_53 l_55_54 5.008854e-04
Rlh_55_54 l_55_54 l_56_54 5.008854e-04
Rlv_55_54 l_55_54 l_55_55 5.008854e-04
Rlh_55_55 l_55_55 l_56_55 5.008854e-04
Rlv_55_55 l_55_55 l_55_56 5.008854e-04
Rlh_55_56 l_55_56 l_56_56 5.008854e-04
Rlv_55_56 l_55_56 l_55_57 5.008854e-04
Rlh_55_57 l_55_57 l_56_57 5.008854e-04
Rlv_55_57 l_55_57 l_55_58 5.008854e-04
Rlh_55_58 l_55_58 l_56_58 5.008854e-04
Rlv_55_58 l_55_58 l_55_59 5.008854e-04
Rlh_55_59 l_55_59 l_56_59 5.008854e-04
Rlv_55_59 l_55_59 l_55_60 5.008854e-04
Rlh_55_60 l_55_60 l_56_60 5.008854e-04
Rlv_55_60 l_55_60 l_55_61 5.008854e-04
Rlh_55_61 l_55_61 l_56_61 5.008854e-04
Rlv_55_61 l_55_61 l_55_62 5.008854e-04
Rlh_55_62 l_55_62 l_56_62 5.008854e-04
Rlv_55_62 l_55_62 l_55_63 5.008854e-04
Rlh_55_63 l_55_63 l_56_63 5.008854e-04
Rlv_55_63 l_55_63 l_55_64 5.008854e-04
Rlh_55_64 l_55_64 l_56_64 5.008854e-04
Rlv_55_64 l_55_64 l_55_65 5.008854e-04
Rlh_55_65 l_55_65 l_56_65 5.008854e-04
Rlv_55_65 l_55_65 l_55_66 5.008854e-04
Rlh_55_66 l_55_66 l_56_66 5.008854e-04
Rlv_55_66 l_55_66 l_55_67 5.008854e-04
Rlh_55_67 l_55_67 l_56_67 5.008854e-04
Rlv_55_67 l_55_67 l_55_68 5.008854e-04
Rlh_55_68 l_55_68 l_56_68 5.008854e-04
Rlv_55_68 l_55_68 l_55_69 5.008854e-04
Rlh_55_69 l_55_69 l_56_69 5.008854e-04
Rlv_55_69 l_55_69 l_55_70 5.008854e-04
Rlh_55_70 l_55_70 l_56_70 5.008854e-04
Rlv_55_70 l_55_70 l_55_71 5.008854e-04
Rlh_55_71 l_55_71 l_56_71 5.008854e-04
Rlh_56_0 l_56_0 l_57_0 5.008854e-04
Rlv_56_0 l_56_0 l_56_1 5.008854e-04
Rlh_56_1 l_56_1 l_57_1 5.008854e-04
Rlv_56_1 l_56_1 l_56_2 5.008854e-04
Rlh_56_2 l_56_2 l_57_2 5.008854e-04
Rlv_56_2 l_56_2 l_56_3 5.008854e-04
Rlh_56_3 l_56_3 l_57_3 5.008854e-04
Rlv_56_3 l_56_3 l_56_4 5.008854e-04
Rlh_56_4 l_56_4 l_57_4 5.008854e-04
Rlv_56_4 l_56_4 l_56_5 5.008854e-04
Rlh_56_5 l_56_5 l_57_5 5.008854e-04
Rlv_56_5 l_56_5 l_56_6 5.008854e-04
Rlh_56_6 l_56_6 l_57_6 5.008854e-04
Rlv_56_6 l_56_6 l_56_7 5.008854e-04
Rlh_56_7 l_56_7 l_57_7 5.008854e-04
Rlv_56_7 l_56_7 l_56_8 5.008854e-04
Rlh_56_8 l_56_8 l_57_8 5.008854e-04
Rlv_56_8 l_56_8 l_56_9 5.008854e-04
Rlh_56_9 l_56_9 l_57_9 5.008854e-04
Rlv_56_9 l_56_9 l_56_10 5.008854e-04
Rlh_56_10 l_56_10 l_57_10 5.008854e-04
Rlv_56_10 l_56_10 l_56_11 5.008854e-04
Rlh_56_11 l_56_11 l_57_11 5.008854e-04
Rlv_56_11 l_56_11 l_56_12 5.008854e-04
Rlh_56_12 l_56_12 l_57_12 5.008854e-04
Rlv_56_12 l_56_12 l_56_13 5.008854e-04
Rlh_56_13 l_56_13 l_57_13 5.008854e-04
Rlv_56_13 l_56_13 l_56_14 5.008854e-04
Rlh_56_14 l_56_14 l_57_14 5.008854e-04
Rlv_56_14 l_56_14 l_56_15 5.008854e-04
Rlh_56_15 l_56_15 l_57_15 5.008854e-04
Rlv_56_15 l_56_15 l_56_16 5.008854e-04
Rlh_56_16 l_56_16 l_57_16 5.008854e-04
Rlv_56_16 l_56_16 l_56_17 5.008854e-04
Rlh_56_17 l_56_17 l_57_17 5.008854e-04
Rlv_56_17 l_56_17 l_56_18 5.008854e-04
Rlh_56_18 l_56_18 l_57_18 5.008854e-04
Rlv_56_18 l_56_18 l_56_19 5.008854e-04
Rlh_56_19 l_56_19 l_57_19 5.008854e-04
Rlv_56_19 l_56_19 l_56_20 5.008854e-04
Rlh_56_20 l_56_20 l_57_20 5.008854e-04
Rlv_56_20 l_56_20 l_56_21 5.008854e-04
Rlh_56_21 l_56_21 l_57_21 5.008854e-04
Rlv_56_21 l_56_21 l_56_22 5.008854e-04
Rlh_56_22 l_56_22 l_57_22 5.008854e-04
Rlv_56_22 l_56_22 l_56_23 5.008854e-04
Rlh_56_23 l_56_23 l_57_23 5.008854e-04
Rlv_56_23 l_56_23 l_56_24 5.008854e-04
Rlh_56_24 l_56_24 l_57_24 5.008854e-04
Rlv_56_24 l_56_24 l_56_25 5.008854e-04
Rlh_56_25 l_56_25 l_57_25 5.008854e-04
Rlv_56_25 l_56_25 l_56_26 5.008854e-04
Rlh_56_26 l_56_26 l_57_26 5.008854e-04
Rlv_56_26 l_56_26 l_56_27 5.008854e-04
Rlh_56_27 l_56_27 l_57_27 5.008854e-04
Rlv_56_27 l_56_27 l_56_28 5.008854e-04
Rlh_56_28 l_56_28 l_57_28 5.008854e-04
Rlv_56_28 l_56_28 l_56_29 5.008854e-04
Rlh_56_29 l_56_29 l_57_29 5.008854e-04
Rlv_56_29 l_56_29 l_56_30 5.008854e-04
Rlh_56_30 l_56_30 l_57_30 5.008854e-04
Rlv_56_30 l_56_30 l_56_31 5.008854e-04
Rlh_56_31 l_56_31 l_57_31 5.008854e-04
Rlv_56_31 l_56_31 l_56_32 5.008854e-04
Rlh_56_32 l_56_32 l_57_32 5.008854e-04
Rlv_56_32 l_56_32 l_56_33 5.008854e-04
Rlh_56_33 l_56_33 l_57_33 5.008854e-04
Rlv_56_33 l_56_33 l_56_34 5.008854e-04
Rlh_56_34 l_56_34 l_57_34 5.008854e-04
Rlv_56_34 l_56_34 l_56_35 5.008854e-04
Rlh_56_35 l_56_35 l_57_35 5.008854e-04
Rlv_56_35 l_56_35 l_56_36 5.008854e-04
Rlh_56_36 l_56_36 l_57_36 5.008854e-04
Rlv_56_36 l_56_36 l_56_37 5.008854e-04
Rlh_56_37 l_56_37 l_57_37 5.008854e-04
Rlv_56_37 l_56_37 l_56_38 5.008854e-04
Rlh_56_38 l_56_38 l_57_38 5.008854e-04
Rlv_56_38 l_56_38 l_56_39 5.008854e-04
Rlh_56_39 l_56_39 l_57_39 5.008854e-04
Rlv_56_39 l_56_39 l_56_40 5.008854e-04
Rlh_56_40 l_56_40 l_57_40 5.008854e-04
Rlv_56_40 l_56_40 l_56_41 5.008854e-04
Rlh_56_41 l_56_41 l_57_41 5.008854e-04
Rlv_56_41 l_56_41 l_56_42 5.008854e-04
Rlh_56_42 l_56_42 l_57_42 5.008854e-04
Rlv_56_42 l_56_42 l_56_43 5.008854e-04
Rlh_56_43 l_56_43 l_57_43 5.008854e-04
Rlv_56_43 l_56_43 l_56_44 5.008854e-04
Rlh_56_44 l_56_44 l_57_44 5.008854e-04
Rlv_56_44 l_56_44 l_56_45 5.008854e-04
Rlh_56_45 l_56_45 l_57_45 5.008854e-04
Rlv_56_45 l_56_45 l_56_46 5.008854e-04
Rlh_56_46 l_56_46 l_57_46 5.008854e-04
Rlv_56_46 l_56_46 l_56_47 5.008854e-04
Rlh_56_47 l_56_47 l_57_47 5.008854e-04
Rlv_56_47 l_56_47 l_56_48 5.008854e-04
Rlh_56_48 l_56_48 l_57_48 5.008854e-04
Rlv_56_48 l_56_48 l_56_49 5.008854e-04
Rlh_56_49 l_56_49 l_57_49 5.008854e-04
Rlv_56_49 l_56_49 l_56_50 5.008854e-04
Rlh_56_50 l_56_50 l_57_50 5.008854e-04
Rlv_56_50 l_56_50 l_56_51 5.008854e-04
Rlh_56_51 l_56_51 l_57_51 5.008854e-04
Rlv_56_51 l_56_51 l_56_52 5.008854e-04
Rlh_56_52 l_56_52 l_57_52 5.008854e-04
Rlv_56_52 l_56_52 l_56_53 5.008854e-04
Rlh_56_53 l_56_53 l_57_53 5.008854e-04
Rlv_56_53 l_56_53 l_56_54 5.008854e-04
Rlh_56_54 l_56_54 l_57_54 5.008854e-04
Rlv_56_54 l_56_54 l_56_55 5.008854e-04
Rlh_56_55 l_56_55 l_57_55 5.008854e-04
Rlv_56_55 l_56_55 l_56_56 5.008854e-04
Rlh_56_56 l_56_56 l_57_56 5.008854e-04
Rlv_56_56 l_56_56 l_56_57 5.008854e-04
Rlh_56_57 l_56_57 l_57_57 5.008854e-04
Rlv_56_57 l_56_57 l_56_58 5.008854e-04
Rlh_56_58 l_56_58 l_57_58 5.008854e-04
Rlv_56_58 l_56_58 l_56_59 5.008854e-04
Rlh_56_59 l_56_59 l_57_59 5.008854e-04
Rlv_56_59 l_56_59 l_56_60 5.008854e-04
Rlh_56_60 l_56_60 l_57_60 5.008854e-04
Rlv_56_60 l_56_60 l_56_61 5.008854e-04
Rlh_56_61 l_56_61 l_57_61 5.008854e-04
Rlv_56_61 l_56_61 l_56_62 5.008854e-04
Rlh_56_62 l_56_62 l_57_62 5.008854e-04
Rlv_56_62 l_56_62 l_56_63 5.008854e-04
Rlh_56_63 l_56_63 l_57_63 5.008854e-04
Rlv_56_63 l_56_63 l_56_64 5.008854e-04
Rlh_56_64 l_56_64 l_57_64 5.008854e-04
Rlv_56_64 l_56_64 l_56_65 5.008854e-04
Rlh_56_65 l_56_65 l_57_65 5.008854e-04
Rlv_56_65 l_56_65 l_56_66 5.008854e-04
Rlh_56_66 l_56_66 l_57_66 5.008854e-04
Rlv_56_66 l_56_66 l_56_67 5.008854e-04
Rlh_56_67 l_56_67 l_57_67 5.008854e-04
Rlv_56_67 l_56_67 l_56_68 5.008854e-04
Rlh_56_68 l_56_68 l_57_68 5.008854e-04
Rlv_56_68 l_56_68 l_56_69 5.008854e-04
Rlh_56_69 l_56_69 l_57_69 5.008854e-04
Rlv_56_69 l_56_69 l_56_70 5.008854e-04
Rlh_56_70 l_56_70 l_57_70 5.008854e-04
Rlv_56_70 l_56_70 l_56_71 5.008854e-04
Rlh_56_71 l_56_71 l_57_71 5.008854e-04
Rlh_57_0 l_57_0 l_58_0 5.008854e-04
Rlv_57_0 l_57_0 l_57_1 5.008854e-04
Rlh_57_1 l_57_1 l_58_1 5.008854e-04
Rlv_57_1 l_57_1 l_57_2 5.008854e-04
Rlh_57_2 l_57_2 l_58_2 5.008854e-04
Rlv_57_2 l_57_2 l_57_3 5.008854e-04
Rlh_57_3 l_57_3 l_58_3 5.008854e-04
Rlv_57_3 l_57_3 l_57_4 5.008854e-04
Rlh_57_4 l_57_4 l_58_4 5.008854e-04
Rlv_57_4 l_57_4 l_57_5 5.008854e-04
Rlh_57_5 l_57_5 l_58_5 5.008854e-04
Rlv_57_5 l_57_5 l_57_6 5.008854e-04
Rlh_57_6 l_57_6 l_58_6 5.008854e-04
Rlv_57_6 l_57_6 l_57_7 5.008854e-04
Rlh_57_7 l_57_7 l_58_7 5.008854e-04
Rlv_57_7 l_57_7 l_57_8 5.008854e-04
Rlh_57_8 l_57_8 l_58_8 5.008854e-04
Rlv_57_8 l_57_8 l_57_9 5.008854e-04
Rlh_57_9 l_57_9 l_58_9 5.008854e-04
Rlv_57_9 l_57_9 l_57_10 5.008854e-04
Rlh_57_10 l_57_10 l_58_10 5.008854e-04
Rlv_57_10 l_57_10 l_57_11 5.008854e-04
Rlh_57_11 l_57_11 l_58_11 5.008854e-04
Rlv_57_11 l_57_11 l_57_12 5.008854e-04
Rlh_57_12 l_57_12 l_58_12 5.008854e-04
Rlv_57_12 l_57_12 l_57_13 5.008854e-04
Rlh_57_13 l_57_13 l_58_13 5.008854e-04
Rlv_57_13 l_57_13 l_57_14 5.008854e-04
Rlh_57_14 l_57_14 l_58_14 5.008854e-04
Rlv_57_14 l_57_14 l_57_15 5.008854e-04
Rlh_57_15 l_57_15 l_58_15 5.008854e-04
Rlv_57_15 l_57_15 l_57_16 5.008854e-04
Rlh_57_16 l_57_16 l_58_16 5.008854e-04
Rlv_57_16 l_57_16 l_57_17 5.008854e-04
Rlh_57_17 l_57_17 l_58_17 5.008854e-04
Rlv_57_17 l_57_17 l_57_18 5.008854e-04
Rlh_57_18 l_57_18 l_58_18 5.008854e-04
Rlv_57_18 l_57_18 l_57_19 5.008854e-04
Rlh_57_19 l_57_19 l_58_19 5.008854e-04
Rlv_57_19 l_57_19 l_57_20 5.008854e-04
Rlh_57_20 l_57_20 l_58_20 5.008854e-04
Rlv_57_20 l_57_20 l_57_21 5.008854e-04
Rlh_57_21 l_57_21 l_58_21 5.008854e-04
Rlv_57_21 l_57_21 l_57_22 5.008854e-04
Rlh_57_22 l_57_22 l_58_22 5.008854e-04
Rlv_57_22 l_57_22 l_57_23 5.008854e-04
Rlh_57_23 l_57_23 l_58_23 5.008854e-04
Rlv_57_23 l_57_23 l_57_24 5.008854e-04
Rlh_57_24 l_57_24 l_58_24 5.008854e-04
Rlv_57_24 l_57_24 l_57_25 5.008854e-04
Rlh_57_25 l_57_25 l_58_25 5.008854e-04
Rlv_57_25 l_57_25 l_57_26 5.008854e-04
Rlh_57_26 l_57_26 l_58_26 5.008854e-04
Rlv_57_26 l_57_26 l_57_27 5.008854e-04
Rlh_57_27 l_57_27 l_58_27 5.008854e-04
Rlv_57_27 l_57_27 l_57_28 5.008854e-04
Rlh_57_28 l_57_28 l_58_28 5.008854e-04
Rlv_57_28 l_57_28 l_57_29 5.008854e-04
Rlh_57_29 l_57_29 l_58_29 5.008854e-04
Rlv_57_29 l_57_29 l_57_30 5.008854e-04
Rlh_57_30 l_57_30 l_58_30 5.008854e-04
Rlv_57_30 l_57_30 l_57_31 5.008854e-04
Rlh_57_31 l_57_31 l_58_31 5.008854e-04
Rlv_57_31 l_57_31 l_57_32 5.008854e-04
Rlh_57_32 l_57_32 l_58_32 5.008854e-04
Rlv_57_32 l_57_32 l_57_33 5.008854e-04
Rlh_57_33 l_57_33 l_58_33 5.008854e-04
Rlv_57_33 l_57_33 l_57_34 5.008854e-04
Rlh_57_34 l_57_34 l_58_34 5.008854e-04
Rlv_57_34 l_57_34 l_57_35 5.008854e-04
Rlh_57_35 l_57_35 l_58_35 5.008854e-04
Rlv_57_35 l_57_35 l_57_36 5.008854e-04
Rlh_57_36 l_57_36 l_58_36 5.008854e-04
Rlv_57_36 l_57_36 l_57_37 5.008854e-04
Rlh_57_37 l_57_37 l_58_37 5.008854e-04
Rlv_57_37 l_57_37 l_57_38 5.008854e-04
Rlh_57_38 l_57_38 l_58_38 5.008854e-04
Rlv_57_38 l_57_38 l_57_39 5.008854e-04
Rlh_57_39 l_57_39 l_58_39 5.008854e-04
Rlv_57_39 l_57_39 l_57_40 5.008854e-04
Rlh_57_40 l_57_40 l_58_40 5.008854e-04
Rlv_57_40 l_57_40 l_57_41 5.008854e-04
Rlh_57_41 l_57_41 l_58_41 5.008854e-04
Rlv_57_41 l_57_41 l_57_42 5.008854e-04
Rlh_57_42 l_57_42 l_58_42 5.008854e-04
Rlv_57_42 l_57_42 l_57_43 5.008854e-04
Rlh_57_43 l_57_43 l_58_43 5.008854e-04
Rlv_57_43 l_57_43 l_57_44 5.008854e-04
Rlh_57_44 l_57_44 l_58_44 5.008854e-04
Rlv_57_44 l_57_44 l_57_45 5.008854e-04
Rlh_57_45 l_57_45 l_58_45 5.008854e-04
Rlv_57_45 l_57_45 l_57_46 5.008854e-04
Rlh_57_46 l_57_46 l_58_46 5.008854e-04
Rlv_57_46 l_57_46 l_57_47 5.008854e-04
Rlh_57_47 l_57_47 l_58_47 5.008854e-04
Rlv_57_47 l_57_47 l_57_48 5.008854e-04
Rlh_57_48 l_57_48 l_58_48 5.008854e-04
Rlv_57_48 l_57_48 l_57_49 5.008854e-04
Rlh_57_49 l_57_49 l_58_49 5.008854e-04
Rlv_57_49 l_57_49 l_57_50 5.008854e-04
Rlh_57_50 l_57_50 l_58_50 5.008854e-04
Rlv_57_50 l_57_50 l_57_51 5.008854e-04
Rlh_57_51 l_57_51 l_58_51 5.008854e-04
Rlv_57_51 l_57_51 l_57_52 5.008854e-04
Rlh_57_52 l_57_52 l_58_52 5.008854e-04
Rlv_57_52 l_57_52 l_57_53 5.008854e-04
Rlh_57_53 l_57_53 l_58_53 5.008854e-04
Rlv_57_53 l_57_53 l_57_54 5.008854e-04
Rlh_57_54 l_57_54 l_58_54 5.008854e-04
Rlv_57_54 l_57_54 l_57_55 5.008854e-04
Rlh_57_55 l_57_55 l_58_55 5.008854e-04
Rlv_57_55 l_57_55 l_57_56 5.008854e-04
Rlh_57_56 l_57_56 l_58_56 5.008854e-04
Rlv_57_56 l_57_56 l_57_57 5.008854e-04
Rlh_57_57 l_57_57 l_58_57 5.008854e-04
Rlv_57_57 l_57_57 l_57_58 5.008854e-04
Rlh_57_58 l_57_58 l_58_58 5.008854e-04
Rlv_57_58 l_57_58 l_57_59 5.008854e-04
Rlh_57_59 l_57_59 l_58_59 5.008854e-04
Rlv_57_59 l_57_59 l_57_60 5.008854e-04
Rlh_57_60 l_57_60 l_58_60 5.008854e-04
Rlv_57_60 l_57_60 l_57_61 5.008854e-04
Rlh_57_61 l_57_61 l_58_61 5.008854e-04
Rlv_57_61 l_57_61 l_57_62 5.008854e-04
Rlh_57_62 l_57_62 l_58_62 5.008854e-04
Rlv_57_62 l_57_62 l_57_63 5.008854e-04
Rlh_57_63 l_57_63 l_58_63 5.008854e-04
Rlv_57_63 l_57_63 l_57_64 5.008854e-04
Rlh_57_64 l_57_64 l_58_64 5.008854e-04
Rlv_57_64 l_57_64 l_57_65 5.008854e-04
Rlh_57_65 l_57_65 l_58_65 5.008854e-04
Rlv_57_65 l_57_65 l_57_66 5.008854e-04
Rlh_57_66 l_57_66 l_58_66 5.008854e-04
Rlv_57_66 l_57_66 l_57_67 5.008854e-04
Rlh_57_67 l_57_67 l_58_67 5.008854e-04
Rlv_57_67 l_57_67 l_57_68 5.008854e-04
Rlh_57_68 l_57_68 l_58_68 5.008854e-04
Rlv_57_68 l_57_68 l_57_69 5.008854e-04
Rlh_57_69 l_57_69 l_58_69 5.008854e-04
Rlv_57_69 l_57_69 l_57_70 5.008854e-04
Rlh_57_70 l_57_70 l_58_70 5.008854e-04
Rlv_57_70 l_57_70 l_57_71 5.008854e-04
Rlh_57_71 l_57_71 l_58_71 5.008854e-04
Rlh_58_0 l_58_0 l_59_0 5.008854e-04
Rlv_58_0 l_58_0 l_58_1 5.008854e-04
Rlh_58_1 l_58_1 l_59_1 5.008854e-04
Rlv_58_1 l_58_1 l_58_2 5.008854e-04
Rlh_58_2 l_58_2 l_59_2 5.008854e-04
Rlv_58_2 l_58_2 l_58_3 5.008854e-04
Rlh_58_3 l_58_3 l_59_3 5.008854e-04
Rlv_58_3 l_58_3 l_58_4 5.008854e-04
Rlh_58_4 l_58_4 l_59_4 5.008854e-04
Rlv_58_4 l_58_4 l_58_5 5.008854e-04
Rlh_58_5 l_58_5 l_59_5 5.008854e-04
Rlv_58_5 l_58_5 l_58_6 5.008854e-04
Rlh_58_6 l_58_6 l_59_6 5.008854e-04
Rlv_58_6 l_58_6 l_58_7 5.008854e-04
Rlh_58_7 l_58_7 l_59_7 5.008854e-04
Rlv_58_7 l_58_7 l_58_8 5.008854e-04
Rlh_58_8 l_58_8 l_59_8 5.008854e-04
Rlv_58_8 l_58_8 l_58_9 5.008854e-04
Rlh_58_9 l_58_9 l_59_9 5.008854e-04
Rlv_58_9 l_58_9 l_58_10 5.008854e-04
Rlh_58_10 l_58_10 l_59_10 5.008854e-04
Rlv_58_10 l_58_10 l_58_11 5.008854e-04
Rlh_58_11 l_58_11 l_59_11 5.008854e-04
Rlv_58_11 l_58_11 l_58_12 5.008854e-04
Rlh_58_12 l_58_12 l_59_12 5.008854e-04
Rlv_58_12 l_58_12 l_58_13 5.008854e-04
Rlh_58_13 l_58_13 l_59_13 5.008854e-04
Rlv_58_13 l_58_13 l_58_14 5.008854e-04
Rlh_58_14 l_58_14 l_59_14 5.008854e-04
Rlv_58_14 l_58_14 l_58_15 5.008854e-04
Rlh_58_15 l_58_15 l_59_15 5.008854e-04
Rlv_58_15 l_58_15 l_58_16 5.008854e-04
Rlh_58_16 l_58_16 l_59_16 5.008854e-04
Rlv_58_16 l_58_16 l_58_17 5.008854e-04
Rlh_58_17 l_58_17 l_59_17 5.008854e-04
Rlv_58_17 l_58_17 l_58_18 5.008854e-04
Rlh_58_18 l_58_18 l_59_18 5.008854e-04
Rlv_58_18 l_58_18 l_58_19 5.008854e-04
Rlh_58_19 l_58_19 l_59_19 5.008854e-04
Rlv_58_19 l_58_19 l_58_20 5.008854e-04
Rlh_58_20 l_58_20 l_59_20 5.008854e-04
Rlv_58_20 l_58_20 l_58_21 5.008854e-04
Rlh_58_21 l_58_21 l_59_21 5.008854e-04
Rlv_58_21 l_58_21 l_58_22 5.008854e-04
Rlh_58_22 l_58_22 l_59_22 5.008854e-04
Rlv_58_22 l_58_22 l_58_23 5.008854e-04
Rlh_58_23 l_58_23 l_59_23 5.008854e-04
Rlv_58_23 l_58_23 l_58_24 5.008854e-04
Rlh_58_24 l_58_24 l_59_24 5.008854e-04
Rlv_58_24 l_58_24 l_58_25 5.008854e-04
Rlh_58_25 l_58_25 l_59_25 5.008854e-04
Rlv_58_25 l_58_25 l_58_26 5.008854e-04
Rlh_58_26 l_58_26 l_59_26 5.008854e-04
Rlv_58_26 l_58_26 l_58_27 5.008854e-04
Rlh_58_27 l_58_27 l_59_27 5.008854e-04
Rlv_58_27 l_58_27 l_58_28 5.008854e-04
Rlh_58_28 l_58_28 l_59_28 5.008854e-04
Rlv_58_28 l_58_28 l_58_29 5.008854e-04
Rlh_58_29 l_58_29 l_59_29 5.008854e-04
Rlv_58_29 l_58_29 l_58_30 5.008854e-04
Rlh_58_30 l_58_30 l_59_30 5.008854e-04
Rlv_58_30 l_58_30 l_58_31 5.008854e-04
Rlh_58_31 l_58_31 l_59_31 5.008854e-04
Rlv_58_31 l_58_31 l_58_32 5.008854e-04
Rlh_58_32 l_58_32 l_59_32 5.008854e-04
Rlv_58_32 l_58_32 l_58_33 5.008854e-04
Rlh_58_33 l_58_33 l_59_33 5.008854e-04
Rlv_58_33 l_58_33 l_58_34 5.008854e-04
Rlh_58_34 l_58_34 l_59_34 5.008854e-04
Rlv_58_34 l_58_34 l_58_35 5.008854e-04
Rlh_58_35 l_58_35 l_59_35 5.008854e-04
Rlv_58_35 l_58_35 l_58_36 5.008854e-04
Rlh_58_36 l_58_36 l_59_36 5.008854e-04
Rlv_58_36 l_58_36 l_58_37 5.008854e-04
Rlh_58_37 l_58_37 l_59_37 5.008854e-04
Rlv_58_37 l_58_37 l_58_38 5.008854e-04
Rlh_58_38 l_58_38 l_59_38 5.008854e-04
Rlv_58_38 l_58_38 l_58_39 5.008854e-04
Rlh_58_39 l_58_39 l_59_39 5.008854e-04
Rlv_58_39 l_58_39 l_58_40 5.008854e-04
Rlh_58_40 l_58_40 l_59_40 5.008854e-04
Rlv_58_40 l_58_40 l_58_41 5.008854e-04
Rlh_58_41 l_58_41 l_59_41 5.008854e-04
Rlv_58_41 l_58_41 l_58_42 5.008854e-04
Rlh_58_42 l_58_42 l_59_42 5.008854e-04
Rlv_58_42 l_58_42 l_58_43 5.008854e-04
Rlh_58_43 l_58_43 l_59_43 5.008854e-04
Rlv_58_43 l_58_43 l_58_44 5.008854e-04
Rlh_58_44 l_58_44 l_59_44 5.008854e-04
Rlv_58_44 l_58_44 l_58_45 5.008854e-04
Rlh_58_45 l_58_45 l_59_45 5.008854e-04
Rlv_58_45 l_58_45 l_58_46 5.008854e-04
Rlh_58_46 l_58_46 l_59_46 5.008854e-04
Rlv_58_46 l_58_46 l_58_47 5.008854e-04
Rlh_58_47 l_58_47 l_59_47 5.008854e-04
Rlv_58_47 l_58_47 l_58_48 5.008854e-04
Rlh_58_48 l_58_48 l_59_48 5.008854e-04
Rlv_58_48 l_58_48 l_58_49 5.008854e-04
Rlh_58_49 l_58_49 l_59_49 5.008854e-04
Rlv_58_49 l_58_49 l_58_50 5.008854e-04
Rlh_58_50 l_58_50 l_59_50 5.008854e-04
Rlv_58_50 l_58_50 l_58_51 5.008854e-04
Rlh_58_51 l_58_51 l_59_51 5.008854e-04
Rlv_58_51 l_58_51 l_58_52 5.008854e-04
Rlh_58_52 l_58_52 l_59_52 5.008854e-04
Rlv_58_52 l_58_52 l_58_53 5.008854e-04
Rlh_58_53 l_58_53 l_59_53 5.008854e-04
Rlv_58_53 l_58_53 l_58_54 5.008854e-04
Rlh_58_54 l_58_54 l_59_54 5.008854e-04
Rlv_58_54 l_58_54 l_58_55 5.008854e-04
Rlh_58_55 l_58_55 l_59_55 5.008854e-04
Rlv_58_55 l_58_55 l_58_56 5.008854e-04
Rlh_58_56 l_58_56 l_59_56 5.008854e-04
Rlv_58_56 l_58_56 l_58_57 5.008854e-04
Rlh_58_57 l_58_57 l_59_57 5.008854e-04
Rlv_58_57 l_58_57 l_58_58 5.008854e-04
Rlh_58_58 l_58_58 l_59_58 5.008854e-04
Rlv_58_58 l_58_58 l_58_59 5.008854e-04
Rlh_58_59 l_58_59 l_59_59 5.008854e-04
Rlv_58_59 l_58_59 l_58_60 5.008854e-04
Rlh_58_60 l_58_60 l_59_60 5.008854e-04
Rlv_58_60 l_58_60 l_58_61 5.008854e-04
Rlh_58_61 l_58_61 l_59_61 5.008854e-04
Rlv_58_61 l_58_61 l_58_62 5.008854e-04
Rlh_58_62 l_58_62 l_59_62 5.008854e-04
Rlv_58_62 l_58_62 l_58_63 5.008854e-04
Rlh_58_63 l_58_63 l_59_63 5.008854e-04
Rlv_58_63 l_58_63 l_58_64 5.008854e-04
Rlh_58_64 l_58_64 l_59_64 5.008854e-04
Rlv_58_64 l_58_64 l_58_65 5.008854e-04
Rlh_58_65 l_58_65 l_59_65 5.008854e-04
Rlv_58_65 l_58_65 l_58_66 5.008854e-04
Rlh_58_66 l_58_66 l_59_66 5.008854e-04
Rlv_58_66 l_58_66 l_58_67 5.008854e-04
Rlh_58_67 l_58_67 l_59_67 5.008854e-04
Rlv_58_67 l_58_67 l_58_68 5.008854e-04
Rlh_58_68 l_58_68 l_59_68 5.008854e-04
Rlv_58_68 l_58_68 l_58_69 5.008854e-04
Rlh_58_69 l_58_69 l_59_69 5.008854e-04
Rlv_58_69 l_58_69 l_58_70 5.008854e-04
Rlh_58_70 l_58_70 l_59_70 5.008854e-04
Rlv_58_70 l_58_70 l_58_71 5.008854e-04
Rlh_58_71 l_58_71 l_59_71 5.008854e-04
Rlh_59_0 l_59_0 l_60_0 5.008854e-04
Rlv_59_0 l_59_0 l_59_1 5.008854e-04
Rlh_59_1 l_59_1 l_60_1 5.008854e-04
Rlv_59_1 l_59_1 l_59_2 5.008854e-04
Rlh_59_2 l_59_2 l_60_2 5.008854e-04
Rlv_59_2 l_59_2 l_59_3 5.008854e-04
Rlh_59_3 l_59_3 l_60_3 5.008854e-04
Rlv_59_3 l_59_3 l_59_4 5.008854e-04
Rlh_59_4 l_59_4 l_60_4 5.008854e-04
Rlv_59_4 l_59_4 l_59_5 5.008854e-04
Rlh_59_5 l_59_5 l_60_5 5.008854e-04
Rlv_59_5 l_59_5 l_59_6 5.008854e-04
Rlh_59_6 l_59_6 l_60_6 5.008854e-04
Rlv_59_6 l_59_6 l_59_7 5.008854e-04
Rlh_59_7 l_59_7 l_60_7 5.008854e-04
Rlv_59_7 l_59_7 l_59_8 5.008854e-04
Rlh_59_8 l_59_8 l_60_8 5.008854e-04
Rlv_59_8 l_59_8 l_59_9 5.008854e-04
Rlh_59_9 l_59_9 l_60_9 5.008854e-04
Rlv_59_9 l_59_9 l_59_10 5.008854e-04
Rlh_59_10 l_59_10 l_60_10 5.008854e-04
Rlv_59_10 l_59_10 l_59_11 5.008854e-04
Rlh_59_11 l_59_11 l_60_11 5.008854e-04
Rlv_59_11 l_59_11 l_59_12 5.008854e-04
Rlh_59_12 l_59_12 l_60_12 5.008854e-04
Rlv_59_12 l_59_12 l_59_13 5.008854e-04
Rlh_59_13 l_59_13 l_60_13 5.008854e-04
Rlv_59_13 l_59_13 l_59_14 5.008854e-04
Rlh_59_14 l_59_14 l_60_14 5.008854e-04
Rlv_59_14 l_59_14 l_59_15 5.008854e-04
Rlh_59_15 l_59_15 l_60_15 5.008854e-04
Rlv_59_15 l_59_15 l_59_16 5.008854e-04
Rlh_59_16 l_59_16 l_60_16 5.008854e-04
Rlv_59_16 l_59_16 l_59_17 5.008854e-04
Rlh_59_17 l_59_17 l_60_17 5.008854e-04
Rlv_59_17 l_59_17 l_59_18 5.008854e-04
Rlh_59_18 l_59_18 l_60_18 5.008854e-04
Rlv_59_18 l_59_18 l_59_19 5.008854e-04
Rlh_59_19 l_59_19 l_60_19 5.008854e-04
Rlv_59_19 l_59_19 l_59_20 5.008854e-04
Rlh_59_20 l_59_20 l_60_20 5.008854e-04
Rlv_59_20 l_59_20 l_59_21 5.008854e-04
Rlh_59_21 l_59_21 l_60_21 5.008854e-04
Rlv_59_21 l_59_21 l_59_22 5.008854e-04
Rlh_59_22 l_59_22 l_60_22 5.008854e-04
Rlv_59_22 l_59_22 l_59_23 5.008854e-04
Rlh_59_23 l_59_23 l_60_23 5.008854e-04
Rlv_59_23 l_59_23 l_59_24 5.008854e-04
Rlh_59_24 l_59_24 l_60_24 5.008854e-04
Rlv_59_24 l_59_24 l_59_25 5.008854e-04
Rlh_59_25 l_59_25 l_60_25 5.008854e-04
Rlv_59_25 l_59_25 l_59_26 5.008854e-04
Rlh_59_26 l_59_26 l_60_26 5.008854e-04
Rlv_59_26 l_59_26 l_59_27 5.008854e-04
Rlh_59_27 l_59_27 l_60_27 5.008854e-04
Rlv_59_27 l_59_27 l_59_28 5.008854e-04
Rlh_59_28 l_59_28 l_60_28 5.008854e-04
Rlv_59_28 l_59_28 l_59_29 5.008854e-04
Rlh_59_29 l_59_29 l_60_29 5.008854e-04
Rlv_59_29 l_59_29 l_59_30 5.008854e-04
Rlh_59_30 l_59_30 l_60_30 5.008854e-04
Rlv_59_30 l_59_30 l_59_31 5.008854e-04
Rlh_59_31 l_59_31 l_60_31 5.008854e-04
Rlv_59_31 l_59_31 l_59_32 5.008854e-04
Rlh_59_32 l_59_32 l_60_32 5.008854e-04
Rlv_59_32 l_59_32 l_59_33 5.008854e-04
Rlh_59_33 l_59_33 l_60_33 5.008854e-04
Rlv_59_33 l_59_33 l_59_34 5.008854e-04
Rlh_59_34 l_59_34 l_60_34 5.008854e-04
Rlv_59_34 l_59_34 l_59_35 5.008854e-04
Rlh_59_35 l_59_35 l_60_35 5.008854e-04
Rlv_59_35 l_59_35 l_59_36 5.008854e-04
Rlh_59_36 l_59_36 l_60_36 5.008854e-04
Rlv_59_36 l_59_36 l_59_37 5.008854e-04
Rlh_59_37 l_59_37 l_60_37 5.008854e-04
Rlv_59_37 l_59_37 l_59_38 5.008854e-04
Rlh_59_38 l_59_38 l_60_38 5.008854e-04
Rlv_59_38 l_59_38 l_59_39 5.008854e-04
Rlh_59_39 l_59_39 l_60_39 5.008854e-04
Rlv_59_39 l_59_39 l_59_40 5.008854e-04
Rlh_59_40 l_59_40 l_60_40 5.008854e-04
Rlv_59_40 l_59_40 l_59_41 5.008854e-04
Rlh_59_41 l_59_41 l_60_41 5.008854e-04
Rlv_59_41 l_59_41 l_59_42 5.008854e-04
Rlh_59_42 l_59_42 l_60_42 5.008854e-04
Rlv_59_42 l_59_42 l_59_43 5.008854e-04
Rlh_59_43 l_59_43 l_60_43 5.008854e-04
Rlv_59_43 l_59_43 l_59_44 5.008854e-04
Rlh_59_44 l_59_44 l_60_44 5.008854e-04
Rlv_59_44 l_59_44 l_59_45 5.008854e-04
Rlh_59_45 l_59_45 l_60_45 5.008854e-04
Rlv_59_45 l_59_45 l_59_46 5.008854e-04
Rlh_59_46 l_59_46 l_60_46 5.008854e-04
Rlv_59_46 l_59_46 l_59_47 5.008854e-04
Rlh_59_47 l_59_47 l_60_47 5.008854e-04
Rlv_59_47 l_59_47 l_59_48 5.008854e-04
Rlh_59_48 l_59_48 l_60_48 5.008854e-04
Rlv_59_48 l_59_48 l_59_49 5.008854e-04
Rlh_59_49 l_59_49 l_60_49 5.008854e-04
Rlv_59_49 l_59_49 l_59_50 5.008854e-04
Rlh_59_50 l_59_50 l_60_50 5.008854e-04
Rlv_59_50 l_59_50 l_59_51 5.008854e-04
Rlh_59_51 l_59_51 l_60_51 5.008854e-04
Rlv_59_51 l_59_51 l_59_52 5.008854e-04
Rlh_59_52 l_59_52 l_60_52 5.008854e-04
Rlv_59_52 l_59_52 l_59_53 5.008854e-04
Rlh_59_53 l_59_53 l_60_53 5.008854e-04
Rlv_59_53 l_59_53 l_59_54 5.008854e-04
Rlh_59_54 l_59_54 l_60_54 5.008854e-04
Rlv_59_54 l_59_54 l_59_55 5.008854e-04
Rlh_59_55 l_59_55 l_60_55 5.008854e-04
Rlv_59_55 l_59_55 l_59_56 5.008854e-04
Rlh_59_56 l_59_56 l_60_56 5.008854e-04
Rlv_59_56 l_59_56 l_59_57 5.008854e-04
Rlh_59_57 l_59_57 l_60_57 5.008854e-04
Rlv_59_57 l_59_57 l_59_58 5.008854e-04
Rlh_59_58 l_59_58 l_60_58 5.008854e-04
Rlv_59_58 l_59_58 l_59_59 5.008854e-04
Rlh_59_59 l_59_59 l_60_59 5.008854e-04
Rlv_59_59 l_59_59 l_59_60 5.008854e-04
Rlh_59_60 l_59_60 l_60_60 5.008854e-04
Rlv_59_60 l_59_60 l_59_61 5.008854e-04
Rlh_59_61 l_59_61 l_60_61 5.008854e-04
Rlv_59_61 l_59_61 l_59_62 5.008854e-04
Rlh_59_62 l_59_62 l_60_62 5.008854e-04
Rlv_59_62 l_59_62 l_59_63 5.008854e-04
Rlh_59_63 l_59_63 l_60_63 5.008854e-04
Rlv_59_63 l_59_63 l_59_64 5.008854e-04
Rlh_59_64 l_59_64 l_60_64 5.008854e-04
Rlv_59_64 l_59_64 l_59_65 5.008854e-04
Rlh_59_65 l_59_65 l_60_65 5.008854e-04
Rlv_59_65 l_59_65 l_59_66 5.008854e-04
Rlh_59_66 l_59_66 l_60_66 5.008854e-04
Rlv_59_66 l_59_66 l_59_67 5.008854e-04
Rlh_59_67 l_59_67 l_60_67 5.008854e-04
Rlv_59_67 l_59_67 l_59_68 5.008854e-04
Rlh_59_68 l_59_68 l_60_68 5.008854e-04
Rlv_59_68 l_59_68 l_59_69 5.008854e-04
Rlh_59_69 l_59_69 l_60_69 5.008854e-04
Rlv_59_69 l_59_69 l_59_70 5.008854e-04
Rlh_59_70 l_59_70 l_60_70 5.008854e-04
Rlv_59_70 l_59_70 l_59_71 5.008854e-04
Rlh_59_71 l_59_71 l_60_71 5.008854e-04
Rlh_60_0 l_60_0 l_61_0 5.008854e-04
Rlv_60_0 l_60_0 l_60_1 5.008854e-04
Rlh_60_1 l_60_1 l_61_1 5.008854e-04
Rlv_60_1 l_60_1 l_60_2 5.008854e-04
Rlh_60_2 l_60_2 l_61_2 5.008854e-04
Rlv_60_2 l_60_2 l_60_3 5.008854e-04
Rlh_60_3 l_60_3 l_61_3 5.008854e-04
Rlv_60_3 l_60_3 l_60_4 5.008854e-04
Rlh_60_4 l_60_4 l_61_4 5.008854e-04
Rlv_60_4 l_60_4 l_60_5 5.008854e-04
Rlh_60_5 l_60_5 l_61_5 5.008854e-04
Rlv_60_5 l_60_5 l_60_6 5.008854e-04
Rlh_60_6 l_60_6 l_61_6 5.008854e-04
Rlv_60_6 l_60_6 l_60_7 5.008854e-04
Rlh_60_7 l_60_7 l_61_7 5.008854e-04
Rlv_60_7 l_60_7 l_60_8 5.008854e-04
Rlh_60_8 l_60_8 l_61_8 5.008854e-04
Rlv_60_8 l_60_8 l_60_9 5.008854e-04
Rlh_60_9 l_60_9 l_61_9 5.008854e-04
Rlv_60_9 l_60_9 l_60_10 5.008854e-04
Rlh_60_10 l_60_10 l_61_10 5.008854e-04
Rlv_60_10 l_60_10 l_60_11 5.008854e-04
Rlh_60_11 l_60_11 l_61_11 5.008854e-04
Rlv_60_11 l_60_11 l_60_12 5.008854e-04
Rlh_60_12 l_60_12 l_61_12 5.008854e-04
Rlv_60_12 l_60_12 l_60_13 5.008854e-04
Rlh_60_13 l_60_13 l_61_13 5.008854e-04
Rlv_60_13 l_60_13 l_60_14 5.008854e-04
Rlh_60_14 l_60_14 l_61_14 5.008854e-04
Rlv_60_14 l_60_14 l_60_15 5.008854e-04
Rlh_60_15 l_60_15 l_61_15 5.008854e-04
Rlv_60_15 l_60_15 l_60_16 5.008854e-04
Rlh_60_16 l_60_16 l_61_16 5.008854e-04
Rlv_60_16 l_60_16 l_60_17 5.008854e-04
Rlh_60_17 l_60_17 l_61_17 5.008854e-04
Rlv_60_17 l_60_17 l_60_18 5.008854e-04
Rlh_60_18 l_60_18 l_61_18 5.008854e-04
Rlv_60_18 l_60_18 l_60_19 5.008854e-04
Rlh_60_19 l_60_19 l_61_19 5.008854e-04
Rlv_60_19 l_60_19 l_60_20 5.008854e-04
Rlh_60_20 l_60_20 l_61_20 5.008854e-04
Rlv_60_20 l_60_20 l_60_21 5.008854e-04
Rlh_60_21 l_60_21 l_61_21 5.008854e-04
Rlv_60_21 l_60_21 l_60_22 5.008854e-04
Rlh_60_22 l_60_22 l_61_22 5.008854e-04
Rlv_60_22 l_60_22 l_60_23 5.008854e-04
Rlh_60_23 l_60_23 l_61_23 5.008854e-04
Rlv_60_23 l_60_23 l_60_24 5.008854e-04
Rlh_60_24 l_60_24 l_61_24 5.008854e-04
Rlv_60_24 l_60_24 l_60_25 5.008854e-04
Rlh_60_25 l_60_25 l_61_25 5.008854e-04
Rlv_60_25 l_60_25 l_60_26 5.008854e-04
Rlh_60_26 l_60_26 l_61_26 5.008854e-04
Rlv_60_26 l_60_26 l_60_27 5.008854e-04
Rlh_60_27 l_60_27 l_61_27 5.008854e-04
Rlv_60_27 l_60_27 l_60_28 5.008854e-04
Rlh_60_28 l_60_28 l_61_28 5.008854e-04
Rlv_60_28 l_60_28 l_60_29 5.008854e-04
Rlh_60_29 l_60_29 l_61_29 5.008854e-04
Rlv_60_29 l_60_29 l_60_30 5.008854e-04
Rlh_60_30 l_60_30 l_61_30 5.008854e-04
Rlv_60_30 l_60_30 l_60_31 5.008854e-04
Rlh_60_31 l_60_31 l_61_31 5.008854e-04
Rlv_60_31 l_60_31 l_60_32 5.008854e-04
Rlh_60_32 l_60_32 l_61_32 5.008854e-04
Rlv_60_32 l_60_32 l_60_33 5.008854e-04
Rlh_60_33 l_60_33 l_61_33 5.008854e-04
Rlv_60_33 l_60_33 l_60_34 5.008854e-04
Rlh_60_34 l_60_34 l_61_34 5.008854e-04
Rlv_60_34 l_60_34 l_60_35 5.008854e-04
Rlh_60_35 l_60_35 l_61_35 5.008854e-04
Rlv_60_35 l_60_35 l_60_36 5.008854e-04
Rlh_60_36 l_60_36 l_61_36 5.008854e-04
Rlv_60_36 l_60_36 l_60_37 5.008854e-04
Rlh_60_37 l_60_37 l_61_37 5.008854e-04
Rlv_60_37 l_60_37 l_60_38 5.008854e-04
Rlh_60_38 l_60_38 l_61_38 5.008854e-04
Rlv_60_38 l_60_38 l_60_39 5.008854e-04
Rlh_60_39 l_60_39 l_61_39 5.008854e-04
Rlv_60_39 l_60_39 l_60_40 5.008854e-04
Rlh_60_40 l_60_40 l_61_40 5.008854e-04
Rlv_60_40 l_60_40 l_60_41 5.008854e-04
Rlh_60_41 l_60_41 l_61_41 5.008854e-04
Rlv_60_41 l_60_41 l_60_42 5.008854e-04
Rlh_60_42 l_60_42 l_61_42 5.008854e-04
Rlv_60_42 l_60_42 l_60_43 5.008854e-04
Rlh_60_43 l_60_43 l_61_43 5.008854e-04
Rlv_60_43 l_60_43 l_60_44 5.008854e-04
Rlh_60_44 l_60_44 l_61_44 5.008854e-04
Rlv_60_44 l_60_44 l_60_45 5.008854e-04
Rlh_60_45 l_60_45 l_61_45 5.008854e-04
Rlv_60_45 l_60_45 l_60_46 5.008854e-04
Rlh_60_46 l_60_46 l_61_46 5.008854e-04
Rlv_60_46 l_60_46 l_60_47 5.008854e-04
Rlh_60_47 l_60_47 l_61_47 5.008854e-04
Rlv_60_47 l_60_47 l_60_48 5.008854e-04
Rlh_60_48 l_60_48 l_61_48 5.008854e-04
Rlv_60_48 l_60_48 l_60_49 5.008854e-04
Rlh_60_49 l_60_49 l_61_49 5.008854e-04
Rlv_60_49 l_60_49 l_60_50 5.008854e-04
Rlh_60_50 l_60_50 l_61_50 5.008854e-04
Rlv_60_50 l_60_50 l_60_51 5.008854e-04
Rlh_60_51 l_60_51 l_61_51 5.008854e-04
Rlv_60_51 l_60_51 l_60_52 5.008854e-04
Rlh_60_52 l_60_52 l_61_52 5.008854e-04
Rlv_60_52 l_60_52 l_60_53 5.008854e-04
Rlh_60_53 l_60_53 l_61_53 5.008854e-04
Rlv_60_53 l_60_53 l_60_54 5.008854e-04
Rlh_60_54 l_60_54 l_61_54 5.008854e-04
Rlv_60_54 l_60_54 l_60_55 5.008854e-04
Rlh_60_55 l_60_55 l_61_55 5.008854e-04
Rlv_60_55 l_60_55 l_60_56 5.008854e-04
Rlh_60_56 l_60_56 l_61_56 5.008854e-04
Rlv_60_56 l_60_56 l_60_57 5.008854e-04
Rlh_60_57 l_60_57 l_61_57 5.008854e-04
Rlv_60_57 l_60_57 l_60_58 5.008854e-04
Rlh_60_58 l_60_58 l_61_58 5.008854e-04
Rlv_60_58 l_60_58 l_60_59 5.008854e-04
Rlh_60_59 l_60_59 l_61_59 5.008854e-04
Rlv_60_59 l_60_59 l_60_60 5.008854e-04
Rlh_60_60 l_60_60 l_61_60 5.008854e-04
Rlv_60_60 l_60_60 l_60_61 5.008854e-04
Rlh_60_61 l_60_61 l_61_61 5.008854e-04
Rlv_60_61 l_60_61 l_60_62 5.008854e-04
Rlh_60_62 l_60_62 l_61_62 5.008854e-04
Rlv_60_62 l_60_62 l_60_63 5.008854e-04
Rlh_60_63 l_60_63 l_61_63 5.008854e-04
Rlv_60_63 l_60_63 l_60_64 5.008854e-04
Rlh_60_64 l_60_64 l_61_64 5.008854e-04
Rlv_60_64 l_60_64 l_60_65 5.008854e-04
Rlh_60_65 l_60_65 l_61_65 5.008854e-04
Rlv_60_65 l_60_65 l_60_66 5.008854e-04
Rlh_60_66 l_60_66 l_61_66 5.008854e-04
Rlv_60_66 l_60_66 l_60_67 5.008854e-04
Rlh_60_67 l_60_67 l_61_67 5.008854e-04
Rlv_60_67 l_60_67 l_60_68 5.008854e-04
Rlh_60_68 l_60_68 l_61_68 5.008854e-04
Rlv_60_68 l_60_68 l_60_69 5.008854e-04
Rlh_60_69 l_60_69 l_61_69 5.008854e-04
Rlv_60_69 l_60_69 l_60_70 5.008854e-04
Rlh_60_70 l_60_70 l_61_70 5.008854e-04
Rlv_60_70 l_60_70 l_60_71 5.008854e-04
Rlh_60_71 l_60_71 l_61_71 5.008854e-04
Rlh_61_0 l_61_0 l_62_0 5.008854e-04
Rlv_61_0 l_61_0 l_61_1 5.008854e-04
Rlh_61_1 l_61_1 l_62_1 5.008854e-04
Rlv_61_1 l_61_1 l_61_2 5.008854e-04
Rlh_61_2 l_61_2 l_62_2 5.008854e-04
Rlv_61_2 l_61_2 l_61_3 5.008854e-04
Rlh_61_3 l_61_3 l_62_3 5.008854e-04
Rlv_61_3 l_61_3 l_61_4 5.008854e-04
Rlh_61_4 l_61_4 l_62_4 5.008854e-04
Rlv_61_4 l_61_4 l_61_5 5.008854e-04
Rlh_61_5 l_61_5 l_62_5 5.008854e-04
Rlv_61_5 l_61_5 l_61_6 5.008854e-04
Rlh_61_6 l_61_6 l_62_6 5.008854e-04
Rlv_61_6 l_61_6 l_61_7 5.008854e-04
Rlh_61_7 l_61_7 l_62_7 5.008854e-04
Rlv_61_7 l_61_7 l_61_8 5.008854e-04
Rlh_61_8 l_61_8 l_62_8 5.008854e-04
Rlv_61_8 l_61_8 l_61_9 5.008854e-04
Rlh_61_9 l_61_9 l_62_9 5.008854e-04
Rlv_61_9 l_61_9 l_61_10 5.008854e-04
Rlh_61_10 l_61_10 l_62_10 5.008854e-04
Rlv_61_10 l_61_10 l_61_11 5.008854e-04
Rlh_61_11 l_61_11 l_62_11 5.008854e-04
Rlv_61_11 l_61_11 l_61_12 5.008854e-04
Rlh_61_12 l_61_12 l_62_12 5.008854e-04
Rlv_61_12 l_61_12 l_61_13 5.008854e-04
Rlh_61_13 l_61_13 l_62_13 5.008854e-04
Rlv_61_13 l_61_13 l_61_14 5.008854e-04
Rlh_61_14 l_61_14 l_62_14 5.008854e-04
Rlv_61_14 l_61_14 l_61_15 5.008854e-04
Rlh_61_15 l_61_15 l_62_15 5.008854e-04
Rlv_61_15 l_61_15 l_61_16 5.008854e-04
Rlh_61_16 l_61_16 l_62_16 5.008854e-04
Rlv_61_16 l_61_16 l_61_17 5.008854e-04
Rlh_61_17 l_61_17 l_62_17 5.008854e-04
Rlv_61_17 l_61_17 l_61_18 5.008854e-04
Rlh_61_18 l_61_18 l_62_18 5.008854e-04
Rlv_61_18 l_61_18 l_61_19 5.008854e-04
Rlh_61_19 l_61_19 l_62_19 5.008854e-04
Rlv_61_19 l_61_19 l_61_20 5.008854e-04
Rlh_61_20 l_61_20 l_62_20 5.008854e-04
Rlv_61_20 l_61_20 l_61_21 5.008854e-04
Rlh_61_21 l_61_21 l_62_21 5.008854e-04
Rlv_61_21 l_61_21 l_61_22 5.008854e-04
Rlh_61_22 l_61_22 l_62_22 5.008854e-04
Rlv_61_22 l_61_22 l_61_23 5.008854e-04
Rlh_61_23 l_61_23 l_62_23 5.008854e-04
Rlv_61_23 l_61_23 l_61_24 5.008854e-04
Rlh_61_24 l_61_24 l_62_24 5.008854e-04
Rlv_61_24 l_61_24 l_61_25 5.008854e-04
Rlh_61_25 l_61_25 l_62_25 5.008854e-04
Rlv_61_25 l_61_25 l_61_26 5.008854e-04
Rlh_61_26 l_61_26 l_62_26 5.008854e-04
Rlv_61_26 l_61_26 l_61_27 5.008854e-04
Rlh_61_27 l_61_27 l_62_27 5.008854e-04
Rlv_61_27 l_61_27 l_61_28 5.008854e-04
Rlh_61_28 l_61_28 l_62_28 5.008854e-04
Rlv_61_28 l_61_28 l_61_29 5.008854e-04
Rlh_61_29 l_61_29 l_62_29 5.008854e-04
Rlv_61_29 l_61_29 l_61_30 5.008854e-04
Rlh_61_30 l_61_30 l_62_30 5.008854e-04
Rlv_61_30 l_61_30 l_61_31 5.008854e-04
Rlh_61_31 l_61_31 l_62_31 5.008854e-04
Rlv_61_31 l_61_31 l_61_32 5.008854e-04
Rlh_61_32 l_61_32 l_62_32 5.008854e-04
Rlv_61_32 l_61_32 l_61_33 5.008854e-04
Rlh_61_33 l_61_33 l_62_33 5.008854e-04
Rlv_61_33 l_61_33 l_61_34 5.008854e-04
Rlh_61_34 l_61_34 l_62_34 5.008854e-04
Rlv_61_34 l_61_34 l_61_35 5.008854e-04
Rlh_61_35 l_61_35 l_62_35 5.008854e-04
Rlv_61_35 l_61_35 l_61_36 5.008854e-04
Rlh_61_36 l_61_36 l_62_36 5.008854e-04
Rlv_61_36 l_61_36 l_61_37 5.008854e-04
Rlh_61_37 l_61_37 l_62_37 5.008854e-04
Rlv_61_37 l_61_37 l_61_38 5.008854e-04
Rlh_61_38 l_61_38 l_62_38 5.008854e-04
Rlv_61_38 l_61_38 l_61_39 5.008854e-04
Rlh_61_39 l_61_39 l_62_39 5.008854e-04
Rlv_61_39 l_61_39 l_61_40 5.008854e-04
Rlh_61_40 l_61_40 l_62_40 5.008854e-04
Rlv_61_40 l_61_40 l_61_41 5.008854e-04
Rlh_61_41 l_61_41 l_62_41 5.008854e-04
Rlv_61_41 l_61_41 l_61_42 5.008854e-04
Rlh_61_42 l_61_42 l_62_42 5.008854e-04
Rlv_61_42 l_61_42 l_61_43 5.008854e-04
Rlh_61_43 l_61_43 l_62_43 5.008854e-04
Rlv_61_43 l_61_43 l_61_44 5.008854e-04
Rlh_61_44 l_61_44 l_62_44 5.008854e-04
Rlv_61_44 l_61_44 l_61_45 5.008854e-04
Rlh_61_45 l_61_45 l_62_45 5.008854e-04
Rlv_61_45 l_61_45 l_61_46 5.008854e-04
Rlh_61_46 l_61_46 l_62_46 5.008854e-04
Rlv_61_46 l_61_46 l_61_47 5.008854e-04
Rlh_61_47 l_61_47 l_62_47 5.008854e-04
Rlv_61_47 l_61_47 l_61_48 5.008854e-04
Rlh_61_48 l_61_48 l_62_48 5.008854e-04
Rlv_61_48 l_61_48 l_61_49 5.008854e-04
Rlh_61_49 l_61_49 l_62_49 5.008854e-04
Rlv_61_49 l_61_49 l_61_50 5.008854e-04
Rlh_61_50 l_61_50 l_62_50 5.008854e-04
Rlv_61_50 l_61_50 l_61_51 5.008854e-04
Rlh_61_51 l_61_51 l_62_51 5.008854e-04
Rlv_61_51 l_61_51 l_61_52 5.008854e-04
Rlh_61_52 l_61_52 l_62_52 5.008854e-04
Rlv_61_52 l_61_52 l_61_53 5.008854e-04
Rlh_61_53 l_61_53 l_62_53 5.008854e-04
Rlv_61_53 l_61_53 l_61_54 5.008854e-04
Rlh_61_54 l_61_54 l_62_54 5.008854e-04
Rlv_61_54 l_61_54 l_61_55 5.008854e-04
Rlh_61_55 l_61_55 l_62_55 5.008854e-04
Rlv_61_55 l_61_55 l_61_56 5.008854e-04
Rlh_61_56 l_61_56 l_62_56 5.008854e-04
Rlv_61_56 l_61_56 l_61_57 5.008854e-04
Rlh_61_57 l_61_57 l_62_57 5.008854e-04
Rlv_61_57 l_61_57 l_61_58 5.008854e-04
Rlh_61_58 l_61_58 l_62_58 5.008854e-04
Rlv_61_58 l_61_58 l_61_59 5.008854e-04
Rlh_61_59 l_61_59 l_62_59 5.008854e-04
Rlv_61_59 l_61_59 l_61_60 5.008854e-04
Rlh_61_60 l_61_60 l_62_60 5.008854e-04
Rlv_61_60 l_61_60 l_61_61 5.008854e-04
Rlh_61_61 l_61_61 l_62_61 5.008854e-04
Rlv_61_61 l_61_61 l_61_62 5.008854e-04
Rlh_61_62 l_61_62 l_62_62 5.008854e-04
Rlv_61_62 l_61_62 l_61_63 5.008854e-04
Rlh_61_63 l_61_63 l_62_63 5.008854e-04
Rlv_61_63 l_61_63 l_61_64 5.008854e-04
Rlh_61_64 l_61_64 l_62_64 5.008854e-04
Rlv_61_64 l_61_64 l_61_65 5.008854e-04
Rlh_61_65 l_61_65 l_62_65 5.008854e-04
Rlv_61_65 l_61_65 l_61_66 5.008854e-04
Rlh_61_66 l_61_66 l_62_66 5.008854e-04
Rlv_61_66 l_61_66 l_61_67 5.008854e-04
Rlh_61_67 l_61_67 l_62_67 5.008854e-04
Rlv_61_67 l_61_67 l_61_68 5.008854e-04
Rlh_61_68 l_61_68 l_62_68 5.008854e-04
Rlv_61_68 l_61_68 l_61_69 5.008854e-04
Rlh_61_69 l_61_69 l_62_69 5.008854e-04
Rlv_61_69 l_61_69 l_61_70 5.008854e-04
Rlh_61_70 l_61_70 l_62_70 5.008854e-04
Rlv_61_70 l_61_70 l_61_71 5.008854e-04
Rlh_61_71 l_61_71 l_62_71 5.008854e-04
Rlh_62_0 l_62_0 l_63_0 5.008854e-04
Rlv_62_0 l_62_0 l_62_1 5.008854e-04
Rlh_62_1 l_62_1 l_63_1 5.008854e-04
Rlv_62_1 l_62_1 l_62_2 5.008854e-04
Rlh_62_2 l_62_2 l_63_2 5.008854e-04
Rlv_62_2 l_62_2 l_62_3 5.008854e-04
Rlh_62_3 l_62_3 l_63_3 5.008854e-04
Rlv_62_3 l_62_3 l_62_4 5.008854e-04
Rlh_62_4 l_62_4 l_63_4 5.008854e-04
Rlv_62_4 l_62_4 l_62_5 5.008854e-04
Rlh_62_5 l_62_5 l_63_5 5.008854e-04
Rlv_62_5 l_62_5 l_62_6 5.008854e-04
Rlh_62_6 l_62_6 l_63_6 5.008854e-04
Rlv_62_6 l_62_6 l_62_7 5.008854e-04
Rlh_62_7 l_62_7 l_63_7 5.008854e-04
Rlv_62_7 l_62_7 l_62_8 5.008854e-04
Rlh_62_8 l_62_8 l_63_8 5.008854e-04
Rlv_62_8 l_62_8 l_62_9 5.008854e-04
Rlh_62_9 l_62_9 l_63_9 5.008854e-04
Rlv_62_9 l_62_9 l_62_10 5.008854e-04
Rlh_62_10 l_62_10 l_63_10 5.008854e-04
Rlv_62_10 l_62_10 l_62_11 5.008854e-04
Rlh_62_11 l_62_11 l_63_11 5.008854e-04
Rlv_62_11 l_62_11 l_62_12 5.008854e-04
Rlh_62_12 l_62_12 l_63_12 5.008854e-04
Rlv_62_12 l_62_12 l_62_13 5.008854e-04
Rlh_62_13 l_62_13 l_63_13 5.008854e-04
Rlv_62_13 l_62_13 l_62_14 5.008854e-04
Rlh_62_14 l_62_14 l_63_14 5.008854e-04
Rlv_62_14 l_62_14 l_62_15 5.008854e-04
Rlh_62_15 l_62_15 l_63_15 5.008854e-04
Rlv_62_15 l_62_15 l_62_16 5.008854e-04
Rlh_62_16 l_62_16 l_63_16 5.008854e-04
Rlv_62_16 l_62_16 l_62_17 5.008854e-04
Rlh_62_17 l_62_17 l_63_17 5.008854e-04
Rlv_62_17 l_62_17 l_62_18 5.008854e-04
Rlh_62_18 l_62_18 l_63_18 5.008854e-04
Rlv_62_18 l_62_18 l_62_19 5.008854e-04
Rlh_62_19 l_62_19 l_63_19 5.008854e-04
Rlv_62_19 l_62_19 l_62_20 5.008854e-04
Rlh_62_20 l_62_20 l_63_20 5.008854e-04
Rlv_62_20 l_62_20 l_62_21 5.008854e-04
Rlh_62_21 l_62_21 l_63_21 5.008854e-04
Rlv_62_21 l_62_21 l_62_22 5.008854e-04
Rlh_62_22 l_62_22 l_63_22 5.008854e-04
Rlv_62_22 l_62_22 l_62_23 5.008854e-04
Rlh_62_23 l_62_23 l_63_23 5.008854e-04
Rlv_62_23 l_62_23 l_62_24 5.008854e-04
Rlh_62_24 l_62_24 l_63_24 5.008854e-04
Rlv_62_24 l_62_24 l_62_25 5.008854e-04
Rlh_62_25 l_62_25 l_63_25 5.008854e-04
Rlv_62_25 l_62_25 l_62_26 5.008854e-04
Rlh_62_26 l_62_26 l_63_26 5.008854e-04
Rlv_62_26 l_62_26 l_62_27 5.008854e-04
Rlh_62_27 l_62_27 l_63_27 5.008854e-04
Rlv_62_27 l_62_27 l_62_28 5.008854e-04
Rlh_62_28 l_62_28 l_63_28 5.008854e-04
Rlv_62_28 l_62_28 l_62_29 5.008854e-04
Rlh_62_29 l_62_29 l_63_29 5.008854e-04
Rlv_62_29 l_62_29 l_62_30 5.008854e-04
Rlh_62_30 l_62_30 l_63_30 5.008854e-04
Rlv_62_30 l_62_30 l_62_31 5.008854e-04
Rlh_62_31 l_62_31 l_63_31 5.008854e-04
Rlv_62_31 l_62_31 l_62_32 5.008854e-04
Rlh_62_32 l_62_32 l_63_32 5.008854e-04
Rlv_62_32 l_62_32 l_62_33 5.008854e-04
Rlh_62_33 l_62_33 l_63_33 5.008854e-04
Rlv_62_33 l_62_33 l_62_34 5.008854e-04
Rlh_62_34 l_62_34 l_63_34 5.008854e-04
Rlv_62_34 l_62_34 l_62_35 5.008854e-04
Rlh_62_35 l_62_35 l_63_35 5.008854e-04
Rlv_62_35 l_62_35 l_62_36 5.008854e-04
Rlh_62_36 l_62_36 l_63_36 5.008854e-04
Rlv_62_36 l_62_36 l_62_37 5.008854e-04
Rlh_62_37 l_62_37 l_63_37 5.008854e-04
Rlv_62_37 l_62_37 l_62_38 5.008854e-04
Rlh_62_38 l_62_38 l_63_38 5.008854e-04
Rlv_62_38 l_62_38 l_62_39 5.008854e-04
Rlh_62_39 l_62_39 l_63_39 5.008854e-04
Rlv_62_39 l_62_39 l_62_40 5.008854e-04
Rlh_62_40 l_62_40 l_63_40 5.008854e-04
Rlv_62_40 l_62_40 l_62_41 5.008854e-04
Rlh_62_41 l_62_41 l_63_41 5.008854e-04
Rlv_62_41 l_62_41 l_62_42 5.008854e-04
Rlh_62_42 l_62_42 l_63_42 5.008854e-04
Rlv_62_42 l_62_42 l_62_43 5.008854e-04
Rlh_62_43 l_62_43 l_63_43 5.008854e-04
Rlv_62_43 l_62_43 l_62_44 5.008854e-04
Rlh_62_44 l_62_44 l_63_44 5.008854e-04
Rlv_62_44 l_62_44 l_62_45 5.008854e-04
Rlh_62_45 l_62_45 l_63_45 5.008854e-04
Rlv_62_45 l_62_45 l_62_46 5.008854e-04
Rlh_62_46 l_62_46 l_63_46 5.008854e-04
Rlv_62_46 l_62_46 l_62_47 5.008854e-04
Rlh_62_47 l_62_47 l_63_47 5.008854e-04
Rlv_62_47 l_62_47 l_62_48 5.008854e-04
Rlh_62_48 l_62_48 l_63_48 5.008854e-04
Rlv_62_48 l_62_48 l_62_49 5.008854e-04
Rlh_62_49 l_62_49 l_63_49 5.008854e-04
Rlv_62_49 l_62_49 l_62_50 5.008854e-04
Rlh_62_50 l_62_50 l_63_50 5.008854e-04
Rlv_62_50 l_62_50 l_62_51 5.008854e-04
Rlh_62_51 l_62_51 l_63_51 5.008854e-04
Rlv_62_51 l_62_51 l_62_52 5.008854e-04
Rlh_62_52 l_62_52 l_63_52 5.008854e-04
Rlv_62_52 l_62_52 l_62_53 5.008854e-04
Rlh_62_53 l_62_53 l_63_53 5.008854e-04
Rlv_62_53 l_62_53 l_62_54 5.008854e-04
Rlh_62_54 l_62_54 l_63_54 5.008854e-04
Rlv_62_54 l_62_54 l_62_55 5.008854e-04
Rlh_62_55 l_62_55 l_63_55 5.008854e-04
Rlv_62_55 l_62_55 l_62_56 5.008854e-04
Rlh_62_56 l_62_56 l_63_56 5.008854e-04
Rlv_62_56 l_62_56 l_62_57 5.008854e-04
Rlh_62_57 l_62_57 l_63_57 5.008854e-04
Rlv_62_57 l_62_57 l_62_58 5.008854e-04
Rlh_62_58 l_62_58 l_63_58 5.008854e-04
Rlv_62_58 l_62_58 l_62_59 5.008854e-04
Rlh_62_59 l_62_59 l_63_59 5.008854e-04
Rlv_62_59 l_62_59 l_62_60 5.008854e-04
Rlh_62_60 l_62_60 l_63_60 5.008854e-04
Rlv_62_60 l_62_60 l_62_61 5.008854e-04
Rlh_62_61 l_62_61 l_63_61 5.008854e-04
Rlv_62_61 l_62_61 l_62_62 5.008854e-04
Rlh_62_62 l_62_62 l_63_62 5.008854e-04
Rlv_62_62 l_62_62 l_62_63 5.008854e-04
Rlh_62_63 l_62_63 l_63_63 5.008854e-04
Rlv_62_63 l_62_63 l_62_64 5.008854e-04
Rlh_62_64 l_62_64 l_63_64 5.008854e-04
Rlv_62_64 l_62_64 l_62_65 5.008854e-04
Rlh_62_65 l_62_65 l_63_65 5.008854e-04
Rlv_62_65 l_62_65 l_62_66 5.008854e-04
Rlh_62_66 l_62_66 l_63_66 5.008854e-04
Rlv_62_66 l_62_66 l_62_67 5.008854e-04
Rlh_62_67 l_62_67 l_63_67 5.008854e-04
Rlv_62_67 l_62_67 l_62_68 5.008854e-04
Rlh_62_68 l_62_68 l_63_68 5.008854e-04
Rlv_62_68 l_62_68 l_62_69 5.008854e-04
Rlh_62_69 l_62_69 l_63_69 5.008854e-04
Rlv_62_69 l_62_69 l_62_70 5.008854e-04
Rlh_62_70 l_62_70 l_63_70 5.008854e-04
Rlv_62_70 l_62_70 l_62_71 5.008854e-04
Rlh_62_71 l_62_71 l_63_71 5.008854e-04
Rlv_63_0 l_63_0 l_63_1 5.008854e-04
Rlv_63_1 l_63_1 l_63_2 5.008854e-04
Rlv_63_2 l_63_2 l_63_3 5.008854e-04
Rlv_63_3 l_63_3 l_63_4 5.008854e-04
Rlv_63_4 l_63_4 l_63_5 5.008854e-04
Rlv_63_5 l_63_5 l_63_6 5.008854e-04
Rlv_63_6 l_63_6 l_63_7 5.008854e-04
Rlv_63_7 l_63_7 l_63_8 5.008854e-04
Rlv_63_8 l_63_8 l_63_9 5.008854e-04
Rlv_63_9 l_63_9 l_63_10 5.008854e-04
Rlv_63_10 l_63_10 l_63_11 5.008854e-04
Rlv_63_11 l_63_11 l_63_12 5.008854e-04
Rlv_63_12 l_63_12 l_63_13 5.008854e-04
Rlv_63_13 l_63_13 l_63_14 5.008854e-04
Rlv_63_14 l_63_14 l_63_15 5.008854e-04
Rlv_63_15 l_63_15 l_63_16 5.008854e-04
Rlv_63_16 l_63_16 l_63_17 5.008854e-04
Rlv_63_17 l_63_17 l_63_18 5.008854e-04
Rlv_63_18 l_63_18 l_63_19 5.008854e-04
Rlv_63_19 l_63_19 l_63_20 5.008854e-04
Rlv_63_20 l_63_20 l_63_21 5.008854e-04
Rlv_63_21 l_63_21 l_63_22 5.008854e-04
Rlv_63_22 l_63_22 l_63_23 5.008854e-04
Rlv_63_23 l_63_23 l_63_24 5.008854e-04
Rlv_63_24 l_63_24 l_63_25 5.008854e-04
Rlv_63_25 l_63_25 l_63_26 5.008854e-04
Rlv_63_26 l_63_26 l_63_27 5.008854e-04
Rlv_63_27 l_63_27 l_63_28 5.008854e-04
Rlv_63_28 l_63_28 l_63_29 5.008854e-04
Rlv_63_29 l_63_29 l_63_30 5.008854e-04
Rlv_63_30 l_63_30 l_63_31 5.008854e-04
Rlv_63_31 l_63_31 l_63_32 5.008854e-04
Rlv_63_32 l_63_32 l_63_33 5.008854e-04
Rlv_63_33 l_63_33 l_63_34 5.008854e-04
Rlv_63_34 l_63_34 l_63_35 5.008854e-04
Rlv_63_35 l_63_35 l_63_36 5.008854e-04
Rlv_63_36 l_63_36 l_63_37 5.008854e-04
Rlv_63_37 l_63_37 l_63_38 5.008854e-04
Rlv_63_38 l_63_38 l_63_39 5.008854e-04
Rlv_63_39 l_63_39 l_63_40 5.008854e-04
Rlv_63_40 l_63_40 l_63_41 5.008854e-04
Rlv_63_41 l_63_41 l_63_42 5.008854e-04
Rlv_63_42 l_63_42 l_63_43 5.008854e-04
Rlv_63_43 l_63_43 l_63_44 5.008854e-04
Rlv_63_44 l_63_44 l_63_45 5.008854e-04
Rlv_63_45 l_63_45 l_63_46 5.008854e-04
Rlv_63_46 l_63_46 l_63_47 5.008854e-04
Rlv_63_47 l_63_47 l_63_48 5.008854e-04
Rlv_63_48 l_63_48 l_63_49 5.008854e-04
Rlv_63_49 l_63_49 l_63_50 5.008854e-04
Rlv_63_50 l_63_50 l_63_51 5.008854e-04
Rlv_63_51 l_63_51 l_63_52 5.008854e-04
Rlv_63_52 l_63_52 l_63_53 5.008854e-04
Rlv_63_53 l_63_53 l_63_54 5.008854e-04
Rlv_63_54 l_63_54 l_63_55 5.008854e-04
Rlv_63_55 l_63_55 l_63_56 5.008854e-04
Rlv_63_56 l_63_56 l_63_57 5.008854e-04
Rlv_63_57 l_63_57 l_63_58 5.008854e-04
Rlv_63_58 l_63_58 l_63_59 5.008854e-04
Rlv_63_59 l_63_59 l_63_60 5.008854e-04
Rlv_63_60 l_63_60 l_63_61 5.008854e-04
Rlv_63_61 l_63_61 l_63_62 5.008854e-04
Rlv_63_62 l_63_62 l_63_63 5.008854e-04
Rlv_63_63 l_63_63 l_63_64 5.008854e-04
Rlv_63_64 l_63_64 l_63_65 5.008854e-04
Rlv_63_65 l_63_65 l_63_66 5.008854e-04
Rlv_63_66 l_63_66 l_63_67 5.008854e-04
Rlv_63_67 l_63_67 l_63_68 5.008854e-04
Rlv_63_68 l_63_68 l_63_69 5.008854e-04
Rlv_63_69 l_63_69 l_63_70 5.008854e-04
Rlv_63_70 l_63_70 l_63_71 5.008854e-04
VSUP psu 0 4.75
RPATHP psu src_p 2.012302e-01
RPATHG src_g 0 6.156386e-02
RENTRY0 src_p p_14_6 1.219551e-03
RENTRY1 src_p p_14_6 1.219551e-03
RENTRY2 src_p p_14_6 1.219551e-03
RENTRY3 src_p p_14_5 1.219551e-03
RENTRY4 src_p p_14_5 1.219551e-03
RENTRY5 src_p p_14_5 1.219551e-03
RENTRY6 src_g g_10_6 8.139309e-05
RQ7 q1s p_20_69 1.219551e-03
RQ8 q1s p_20_69 1.219551e-03
RQ9 q1s p_20_70 1.219551e-03
RQ10 q1d l_22_70 1.219551e-03
RQ11 q1d l_22_70 1.219551e-03
RQ12 q1d l_22_69 1.219551e-03
RQ13 q1d l_22_69 1.219551e-03
RQ1 q1s q1d 1.638000e-02
Ih3 l_63_42 g_62_42 0.006225806451612902
Id6 l_30_17 g_31_17 0.006225806451612902
Ib8 l_14_1 g_15_1 0.006225806451612902
Ig1 l_55_58 g_54_58 0.006225806451612902
Ig5 l_55_26 g_54_26 0.006225806451612902
Ic7 l_23_10 g_22_10 0.006225806451612902
Ib7 l_15_10 g_14_10 0.006225806451612902
Ia1 l_7_58 g_6_58 0.006225806451612902
If6 l_46_17 g_47_17 0.006225806451612902
Id1 l_31_58 g_30_58 0.006225806451612902
Ih6 l_62_17 g_63_17 0.006225806451612902
If3 l_47_42 g_46_42 0.006225806451612902
Ia6 l_6_17 g_7_17 0.006225806451612902
Ic6 l_22_17 g_23_17 0.006225806451612902
Ig3 l_55_42 g_54_42 0.006225806451612902
Id7 l_31_10 g_30_10 0.006225806451612902
Ig2 l_54_49 g_55_49 0.006225806451612902
If7 l_47_10 g_46_10 0.006225806451612902
Ig7 l_55_10 g_54_10 0.006225806451612902
Id4 l_30_33 g_31_33 0.006225806451612902
If8 l_46_1 g_47_1 0.006225806451612902
Ie6 l_38_17 g_39_17 0.006225806451612902
Ib3 l_15_42 g_14_42 0.006225806451612902
Ia2 l_6_49 g_7_49 0.006225806451612902
Ie3 l_39_42 g_38_42 0.006225806451612902
If4 l_46_33 g_47_33 0.006225806451612902
Ia8 l_6_1 g_7_1 0.006225806451612902
Ib4 l_14_33 g_15_33 0.006225806451612902
Ie2 l_38_49 g_39_49 0.006225806451612902
Ic2 l_22_49 g_23_49 0.006225806451612902
Ig4 l_54_33 g_55_33 0.006225806451612902
Ig6 l_54_17 g_55_17 0.006225806451612902
Ie1 l_39_58 g_38_58 0.006225806451612902
Ie4 l_38_33 g_39_33 0.006225806451612902
Ih4 l_62_33 g_63_33 0.006225806451612902
Ie5 l_39_26 g_38_26 0.006225806451612902
If1 l_47_58 g_46_58 0.006225806451612902
Ih1 l_63_58 g_62_58 0.006225806451612902
Id5 l_31_26 g_30_26 0.006225806451612902
Id8 l_30_1 g_31_1 0.006225806451612902
Ie7 l_39_10 g_38_10 0.006225806451612902
Id2 l_30_49 g_31_49 0.006225806451612902
Ic8 l_22_1 g_23_1 0.006225806451612902
Ih5 l_63_26 g_62_26 0.006225806451612902
Ic4 l_22_33 g_23_33 0.006225806451612902
Ic3 l_23_42 g_22_42 0.006225806451612902
Ia3 l_7_42 g_6_42 0.006225806451612902
Ig8 l_54_1 g_55_1 0.006225806451612902
Ia7 l_7_10 g_6_10 0.006225806451612902
Ih2 l_62_49 g_63_49 0.006225806451612902
Ib2 l_14_49 g_15_49 0.006225806451612902
Ie8 l_38_1 g_39_1 0.006225806451612902
Ib1 l_15_58 g_14_58 0.006225806451612902
Ib5 l_15_26 g_14_26 0.006225806451612902
If5 l_47_26 g_46_26 0.006225806451612902
Ic5 l_23_26 g_22_26 0.006225806451612902
Ih7 l_63_10 g_62_10 0.006225806451612902
Ic1 l_23_58 g_22_58 0.006225806451612902
Ib6 l_14_17 g_15_17 0.006225806451612902
If2 l_46_49 g_47_49 0.006225806451612902
Ia5 l_7_26 g_6_26 0.006225806451612902
Id3 l_31_42 g_30_42 0.006225806451612902
Ih8 l_62_1 g_63_1 0.006225806451612902
Ia4 l_6_33 g_7_33 0.006225806451612902
Ihost p_61_47 g_60_47 0.45
.op
.control
run
let result_switch_drop = v(q1s) - v(q1d)
let result_drop_h3 = (v(src_p) - v(l_63_42) - (v(q1s) - v(q1d))) + (v(g_62_42) - v(src_g))
let result_vdd_h3 = v(l_63_42) - v(g_62_42)
let result_drop_d6 = (v(src_p) - v(l_30_17) - (v(q1s) - v(q1d))) + (v(g_31_17) - v(src_g))
let result_vdd_d6 = v(l_30_17) - v(g_31_17)
let result_drop_b8 = (v(src_p) - v(l_14_1) - (v(q1s) - v(q1d))) + (v(g_15_1) - v(src_g))
let result_vdd_b8 = v(l_14_1) - v(g_15_1)
let result_drop_g1 = (v(src_p) - v(l_55_58) - (v(q1s) - v(q1d))) + (v(g_54_58) - v(src_g))
let result_vdd_g1 = v(l_55_58) - v(g_54_58)
let result_drop_g5 = (v(src_p) - v(l_55_26) - (v(q1s) - v(q1d))) + (v(g_54_26) - v(src_g))
let result_vdd_g5 = v(l_55_26) - v(g_54_26)
let result_drop_c7 = (v(src_p) - v(l_23_10) - (v(q1s) - v(q1d))) + (v(g_22_10) - v(src_g))
let result_vdd_c7 = v(l_23_10) - v(g_22_10)
let result_drop_b7 = (v(src_p) - v(l_15_10) - (v(q1s) - v(q1d))) + (v(g_14_10) - v(src_g))
let result_vdd_b7 = v(l_15_10) - v(g_14_10)
let result_drop_a1 = (v(src_p) - v(l_7_58) - (v(q1s) - v(q1d))) + (v(g_6_58) - v(src_g))
let result_vdd_a1 = v(l_7_58) - v(g_6_58)
let result_drop_f6 = (v(src_p) - v(l_46_17) - (v(q1s) - v(q1d))) + (v(g_47_17) - v(src_g))
let result_vdd_f6 = v(l_46_17) - v(g_47_17)
let result_drop_d1 = (v(src_p) - v(l_31_58) - (v(q1s) - v(q1d))) + (v(g_30_58) - v(src_g))
let result_vdd_d1 = v(l_31_58) - v(g_30_58)
let result_drop_h6 = (v(src_p) - v(l_62_17) - (v(q1s) - v(q1d))) + (v(g_63_17) - v(src_g))
let result_vdd_h6 = v(l_62_17) - v(g_63_17)
let result_drop_f3 = (v(src_p) - v(l_47_42) - (v(q1s) - v(q1d))) + (v(g_46_42) - v(src_g))
let result_vdd_f3 = v(l_47_42) - v(g_46_42)
let result_drop_a6 = (v(src_p) - v(l_6_17) - (v(q1s) - v(q1d))) + (v(g_7_17) - v(src_g))
let result_vdd_a6 = v(l_6_17) - v(g_7_17)
let result_drop_c6 = (v(src_p) - v(l_22_17) - (v(q1s) - v(q1d))) + (v(g_23_17) - v(src_g))
let result_vdd_c6 = v(l_22_17) - v(g_23_17)
let result_drop_g3 = (v(src_p) - v(l_55_42) - (v(q1s) - v(q1d))) + (v(g_54_42) - v(src_g))
let result_vdd_g3 = v(l_55_42) - v(g_54_42)
let result_drop_d7 = (v(src_p) - v(l_31_10) - (v(q1s) - v(q1d))) + (v(g_30_10) - v(src_g))
let result_vdd_d7 = v(l_31_10) - v(g_30_10)
let result_drop_g2 = (v(src_p) - v(l_54_49) - (v(q1s) - v(q1d))) + (v(g_55_49) - v(src_g))
let result_vdd_g2 = v(l_54_49) - v(g_55_49)
let result_drop_f7 = (v(src_p) - v(l_47_10) - (v(q1s) - v(q1d))) + (v(g_46_10) - v(src_g))
let result_vdd_f7 = v(l_47_10) - v(g_46_10)
let result_drop_g7 = (v(src_p) - v(l_55_10) - (v(q1s) - v(q1d))) + (v(g_54_10) - v(src_g))
let result_vdd_g7 = v(l_55_10) - v(g_54_10)
let result_drop_d4 = (v(src_p) - v(l_30_33) - (v(q1s) - v(q1d))) + (v(g_31_33) - v(src_g))
let result_vdd_d4 = v(l_30_33) - v(g_31_33)
let result_drop_f8 = (v(src_p) - v(l_46_1) - (v(q1s) - v(q1d))) + (v(g_47_1) - v(src_g))
let result_vdd_f8 = v(l_46_1) - v(g_47_1)
let result_drop_e6 = (v(src_p) - v(l_38_17) - (v(q1s) - v(q1d))) + (v(g_39_17) - v(src_g))
let result_vdd_e6 = v(l_38_17) - v(g_39_17)
let result_drop_b3 = (v(src_p) - v(l_15_42) - (v(q1s) - v(q1d))) + (v(g_14_42) - v(src_g))
let result_vdd_b3 = v(l_15_42) - v(g_14_42)
let result_drop_a2 = (v(src_p) - v(l_6_49) - (v(q1s) - v(q1d))) + (v(g_7_49) - v(src_g))
let result_vdd_a2 = v(l_6_49) - v(g_7_49)
let result_drop_e3 = (v(src_p) - v(l_39_42) - (v(q1s) - v(q1d))) + (v(g_38_42) - v(src_g))
let result_vdd_e3 = v(l_39_42) - v(g_38_42)
let result_drop_f4 = (v(src_p) - v(l_46_33) - (v(q1s) - v(q1d))) + (v(g_47_33) - v(src_g))
let result_vdd_f4 = v(l_46_33) - v(g_47_33)
let result_drop_a8 = (v(src_p) - v(l_6_1) - (v(q1s) - v(q1d))) + (v(g_7_1) - v(src_g))
let result_vdd_a8 = v(l_6_1) - v(g_7_1)
let result_drop_b4 = (v(src_p) - v(l_14_33) - (v(q1s) - v(q1d))) + (v(g_15_33) - v(src_g))
let result_vdd_b4 = v(l_14_33) - v(g_15_33)
let result_drop_e2 = (v(src_p) - v(l_38_49) - (v(q1s) - v(q1d))) + (v(g_39_49) - v(src_g))
let result_vdd_e2 = v(l_38_49) - v(g_39_49)
let result_drop_c2 = (v(src_p) - v(l_22_49) - (v(q1s) - v(q1d))) + (v(g_23_49) - v(src_g))
let result_vdd_c2 = v(l_22_49) - v(g_23_49)
let result_drop_g4 = (v(src_p) - v(l_54_33) - (v(q1s) - v(q1d))) + (v(g_55_33) - v(src_g))
let result_vdd_g4 = v(l_54_33) - v(g_55_33)
let result_drop_g6 = (v(src_p) - v(l_54_17) - (v(q1s) - v(q1d))) + (v(g_55_17) - v(src_g))
let result_vdd_g6 = v(l_54_17) - v(g_55_17)
let result_drop_e1 = (v(src_p) - v(l_39_58) - (v(q1s) - v(q1d))) + (v(g_38_58) - v(src_g))
let result_vdd_e1 = v(l_39_58) - v(g_38_58)
let result_drop_e4 = (v(src_p) - v(l_38_33) - (v(q1s) - v(q1d))) + (v(g_39_33) - v(src_g))
let result_vdd_e4 = v(l_38_33) - v(g_39_33)
let result_drop_h4 = (v(src_p) - v(l_62_33) - (v(q1s) - v(q1d))) + (v(g_63_33) - v(src_g))
let result_vdd_h4 = v(l_62_33) - v(g_63_33)
let result_drop_e5 = (v(src_p) - v(l_39_26) - (v(q1s) - v(q1d))) + (v(g_38_26) - v(src_g))
let result_vdd_e5 = v(l_39_26) - v(g_38_26)
let result_drop_f1 = (v(src_p) - v(l_47_58) - (v(q1s) - v(q1d))) + (v(g_46_58) - v(src_g))
let result_vdd_f1 = v(l_47_58) - v(g_46_58)
let result_drop_h1 = (v(src_p) - v(l_63_58) - (v(q1s) - v(q1d))) + (v(g_62_58) - v(src_g))
let result_vdd_h1 = v(l_63_58) - v(g_62_58)
let result_drop_d5 = (v(src_p) - v(l_31_26) - (v(q1s) - v(q1d))) + (v(g_30_26) - v(src_g))
let result_vdd_d5 = v(l_31_26) - v(g_30_26)
let result_drop_d8 = (v(src_p) - v(l_30_1) - (v(q1s) - v(q1d))) + (v(g_31_1) - v(src_g))
let result_vdd_d8 = v(l_30_1) - v(g_31_1)
let result_drop_e7 = (v(src_p) - v(l_39_10) - (v(q1s) - v(q1d))) + (v(g_38_10) - v(src_g))
let result_vdd_e7 = v(l_39_10) - v(g_38_10)
let result_drop_d2 = (v(src_p) - v(l_30_49) - (v(q1s) - v(q1d))) + (v(g_31_49) - v(src_g))
let result_vdd_d2 = v(l_30_49) - v(g_31_49)
let result_drop_c8 = (v(src_p) - v(l_22_1) - (v(q1s) - v(q1d))) + (v(g_23_1) - v(src_g))
let result_vdd_c8 = v(l_22_1) - v(g_23_1)
let result_drop_h5 = (v(src_p) - v(l_63_26) - (v(q1s) - v(q1d))) + (v(g_62_26) - v(src_g))
let result_vdd_h5 = v(l_63_26) - v(g_62_26)
let result_drop_c4 = (v(src_p) - v(l_22_33) - (v(q1s) - v(q1d))) + (v(g_23_33) - v(src_g))
let result_vdd_c4 = v(l_22_33) - v(g_23_33)
let result_drop_c3 = (v(src_p) - v(l_23_42) - (v(q1s) - v(q1d))) + (v(g_22_42) - v(src_g))
let result_vdd_c3 = v(l_23_42) - v(g_22_42)
let result_drop_a3 = (v(src_p) - v(l_7_42) - (v(q1s) - v(q1d))) + (v(g_6_42) - v(src_g))
let result_vdd_a3 = v(l_7_42) - v(g_6_42)
let result_drop_g8 = (v(src_p) - v(l_54_1) - (v(q1s) - v(q1d))) + (v(g_55_1) - v(src_g))
let result_vdd_g8 = v(l_54_1) - v(g_55_1)
let result_drop_a7 = (v(src_p) - v(l_7_10) - (v(q1s) - v(q1d))) + (v(g_6_10) - v(src_g))
let result_vdd_a7 = v(l_7_10) - v(g_6_10)
let result_drop_h2 = (v(src_p) - v(l_62_49) - (v(q1s) - v(q1d))) + (v(g_63_49) - v(src_g))
let result_vdd_h2 = v(l_62_49) - v(g_63_49)
let result_drop_b2 = (v(src_p) - v(l_14_49) - (v(q1s) - v(q1d))) + (v(g_15_49) - v(src_g))
let result_vdd_b2 = v(l_14_49) - v(g_15_49)
let result_drop_e8 = (v(src_p) - v(l_38_1) - (v(q1s) - v(q1d))) + (v(g_39_1) - v(src_g))
let result_vdd_e8 = v(l_38_1) - v(g_39_1)
let result_drop_b1 = (v(src_p) - v(l_15_58) - (v(q1s) - v(q1d))) + (v(g_14_58) - v(src_g))
let result_vdd_b1 = v(l_15_58) - v(g_14_58)
let result_drop_b5 = (v(src_p) - v(l_15_26) - (v(q1s) - v(q1d))) + (v(g_14_26) - v(src_g))
let result_vdd_b5 = v(l_15_26) - v(g_14_26)
let result_drop_f5 = (v(src_p) - v(l_47_26) - (v(q1s) - v(q1d))) + (v(g_46_26) - v(src_g))
let result_vdd_f5 = v(l_47_26) - v(g_46_26)
let result_drop_c5 = (v(src_p) - v(l_23_26) - (v(q1s) - v(q1d))) + (v(g_22_26) - v(src_g))
let result_vdd_c5 = v(l_23_26) - v(g_22_26)
let result_drop_h7 = (v(src_p) - v(l_63_10) - (v(q1s) - v(q1d))) + (v(g_62_10) - v(src_g))
let result_vdd_h7 = v(l_63_10) - v(g_62_10)
let result_drop_c1 = (v(src_p) - v(l_23_58) - (v(q1s) - v(q1d))) + (v(g_22_58) - v(src_g))
let result_vdd_c1 = v(l_23_58) - v(g_22_58)
let result_drop_b6 = (v(src_p) - v(l_14_17) - (v(q1s) - v(q1d))) + (v(g_15_17) - v(src_g))
let result_vdd_b6 = v(l_14_17) - v(g_15_17)
let result_drop_f2 = (v(src_p) - v(l_46_49) - (v(q1s) - v(q1d))) + (v(g_47_49) - v(src_g))
let result_vdd_f2 = v(l_46_49) - v(g_47_49)
let result_drop_a5 = (v(src_p) - v(l_7_26) - (v(q1s) - v(q1d))) + (v(g_6_26) - v(src_g))
let result_vdd_a5 = v(l_7_26) - v(g_6_26)
let result_drop_d3 = (v(src_p) - v(l_31_42) - (v(q1s) - v(q1d))) + (v(g_30_42) - v(src_g))
let result_vdd_d3 = v(l_31_42) - v(g_30_42)
let result_drop_h8 = (v(src_p) - v(l_62_1) - (v(q1s) - v(q1d))) + (v(g_63_1) - v(src_g))
let result_vdd_h8 = v(l_62_1) - v(g_63_1)
let result_drop_a4 = (v(src_p) - v(l_6_33) - (v(q1s) - v(q1d))) + (v(g_7_33) - v(src_g))
let result_vdd_a4 = v(l_6_33) - v(g_7_33)
let result_pi_header = v(p_61_47) - v(g_60_47)
if result_vdd_a1 < 4.5
echo "ASSERTION FAILED: result_vdd_a1 below 4.5"
quit 1
end
if result_vdd_a1 > 4.75
echo "ASSERTION FAILED: result_vdd_a1 above 4.75"
quit 1
end
if result_vdd_a2 < 4.5
echo "ASSERTION FAILED: result_vdd_a2 below 4.5"
quit 1
end
if result_vdd_a2 > 4.75
echo "ASSERTION FAILED: result_vdd_a2 above 4.75"
quit 1
end
if result_vdd_a3 < 4.5
echo "ASSERTION FAILED: result_vdd_a3 below 4.5"
quit 1
end
if result_vdd_a3 > 4.75
echo "ASSERTION FAILED: result_vdd_a3 above 4.75"
quit 1
end
if result_vdd_a4 < 4.5
echo "ASSERTION FAILED: result_vdd_a4 below 4.5"
quit 1
end
if result_vdd_a4 > 4.75
echo "ASSERTION FAILED: result_vdd_a4 above 4.75"
quit 1
end
if result_vdd_a5 < 4.5
echo "ASSERTION FAILED: result_vdd_a5 below 4.5"
quit 1
end
if result_vdd_a5 > 4.75
echo "ASSERTION FAILED: result_vdd_a5 above 4.75"
quit 1
end
if result_vdd_a6 < 4.5
echo "ASSERTION FAILED: result_vdd_a6 below 4.5"
quit 1
end
if result_vdd_a6 > 4.75
echo "ASSERTION FAILED: result_vdd_a6 above 4.75"
quit 1
end
if result_vdd_a7 < 4.5
echo "ASSERTION FAILED: result_vdd_a7 below 4.5"
quit 1
end
if result_vdd_a7 > 4.75
echo "ASSERTION FAILED: result_vdd_a7 above 4.75"
quit 1
end
if result_vdd_a8 < 4.5
echo "ASSERTION FAILED: result_vdd_a8 below 4.5"
quit 1
end
if result_vdd_a8 > 4.75
echo "ASSERTION FAILED: result_vdd_a8 above 4.75"
quit 1
end
if result_vdd_b1 < 4.5
echo "ASSERTION FAILED: result_vdd_b1 below 4.5"
quit 1
end
if result_vdd_b1 > 4.75
echo "ASSERTION FAILED: result_vdd_b1 above 4.75"
quit 1
end
if result_vdd_b2 < 4.5
echo "ASSERTION FAILED: result_vdd_b2 below 4.5"
quit 1
end
if result_vdd_b2 > 4.75
echo "ASSERTION FAILED: result_vdd_b2 above 4.75"
quit 1
end
if result_vdd_b3 < 4.5
echo "ASSERTION FAILED: result_vdd_b3 below 4.5"
quit 1
end
if result_vdd_b3 > 4.75
echo "ASSERTION FAILED: result_vdd_b3 above 4.75"
quit 1
end
if result_vdd_b4 < 4.5
echo "ASSERTION FAILED: result_vdd_b4 below 4.5"
quit 1
end
if result_vdd_b4 > 4.75
echo "ASSERTION FAILED: result_vdd_b4 above 4.75"
quit 1
end
if result_vdd_b5 < 4.5
echo "ASSERTION FAILED: result_vdd_b5 below 4.5"
quit 1
end
if result_vdd_b5 > 4.75
echo "ASSERTION FAILED: result_vdd_b5 above 4.75"
quit 1
end
if result_vdd_b6 < 4.5
echo "ASSERTION FAILED: result_vdd_b6 below 4.5"
quit 1
end
if result_vdd_b6 > 4.75
echo "ASSERTION FAILED: result_vdd_b6 above 4.75"
quit 1
end
if result_vdd_b7 < 4.5
echo "ASSERTION FAILED: result_vdd_b7 below 4.5"
quit 1
end
if result_vdd_b7 > 4.75
echo "ASSERTION FAILED: result_vdd_b7 above 4.75"
quit 1
end
if result_vdd_b8 < 4.5
echo "ASSERTION FAILED: result_vdd_b8 below 4.5"
quit 1
end
if result_vdd_b8 > 4.75
echo "ASSERTION FAILED: result_vdd_b8 above 4.75"
quit 1
end
if result_vdd_c1 < 4.5
echo "ASSERTION FAILED: result_vdd_c1 below 4.5"
quit 1
end
if result_vdd_c1 > 4.75
echo "ASSERTION FAILED: result_vdd_c1 above 4.75"
quit 1
end
if result_vdd_c2 < 4.5
echo "ASSERTION FAILED: result_vdd_c2 below 4.5"
quit 1
end
if result_vdd_c2 > 4.75
echo "ASSERTION FAILED: result_vdd_c2 above 4.75"
quit 1
end
if result_vdd_c3 < 4.5
echo "ASSERTION FAILED: result_vdd_c3 below 4.5"
quit 1
end
if result_vdd_c3 > 4.75
echo "ASSERTION FAILED: result_vdd_c3 above 4.75"
quit 1
end
if result_vdd_c4 < 4.5
echo "ASSERTION FAILED: result_vdd_c4 below 4.5"
quit 1
end
if result_vdd_c4 > 4.75
echo "ASSERTION FAILED: result_vdd_c4 above 4.75"
quit 1
end
if result_vdd_c5 < 4.5
echo "ASSERTION FAILED: result_vdd_c5 below 4.5"
quit 1
end
if result_vdd_c5 > 4.75
echo "ASSERTION FAILED: result_vdd_c5 above 4.75"
quit 1
end
if result_vdd_c6 < 4.5
echo "ASSERTION FAILED: result_vdd_c6 below 4.5"
quit 1
end
if result_vdd_c6 > 4.75
echo "ASSERTION FAILED: result_vdd_c6 above 4.75"
quit 1
end
if result_vdd_c7 < 4.5
echo "ASSERTION FAILED: result_vdd_c7 below 4.5"
quit 1
end
if result_vdd_c7 > 4.75
echo "ASSERTION FAILED: result_vdd_c7 above 4.75"
quit 1
end
if result_vdd_c8 < 4.5
echo "ASSERTION FAILED: result_vdd_c8 below 4.5"
quit 1
end
if result_vdd_c8 > 4.75
echo "ASSERTION FAILED: result_vdd_c8 above 4.75"
quit 1
end
if result_vdd_d1 < 4.5
echo "ASSERTION FAILED: result_vdd_d1 below 4.5"
quit 1
end
if result_vdd_d1 > 4.75
echo "ASSERTION FAILED: result_vdd_d1 above 4.75"
quit 1
end
if result_vdd_d2 < 4.5
echo "ASSERTION FAILED: result_vdd_d2 below 4.5"
quit 1
end
if result_vdd_d2 > 4.75
echo "ASSERTION FAILED: result_vdd_d2 above 4.75"
quit 1
end
if result_vdd_d3 < 4.5
echo "ASSERTION FAILED: result_vdd_d3 below 4.5"
quit 1
end
if result_vdd_d3 > 4.75
echo "ASSERTION FAILED: result_vdd_d3 above 4.75"
quit 1
end
if result_vdd_d4 < 4.5
echo "ASSERTION FAILED: result_vdd_d4 below 4.5"
quit 1
end
if result_vdd_d4 > 4.75
echo "ASSERTION FAILED: result_vdd_d4 above 4.75"
quit 1
end
if result_vdd_d5 < 4.5
echo "ASSERTION FAILED: result_vdd_d5 below 4.5"
quit 1
end
if result_vdd_d5 > 4.75
echo "ASSERTION FAILED: result_vdd_d5 above 4.75"
quit 1
end
if result_vdd_d6 < 4.5
echo "ASSERTION FAILED: result_vdd_d6 below 4.5"
quit 1
end
if result_vdd_d6 > 4.75
echo "ASSERTION FAILED: result_vdd_d6 above 4.75"
quit 1
end
if result_vdd_d7 < 4.5
echo "ASSERTION FAILED: result_vdd_d7 below 4.5"
quit 1
end
if result_vdd_d7 > 4.75
echo "ASSERTION FAILED: result_vdd_d7 above 4.75"
quit 1
end
if result_vdd_d8 < 4.5
echo "ASSERTION FAILED: result_vdd_d8 below 4.5"
quit 1
end
if result_vdd_d8 > 4.75
echo "ASSERTION FAILED: result_vdd_d8 above 4.75"
quit 1
end
if result_vdd_e1 < 4.5
echo "ASSERTION FAILED: result_vdd_e1 below 4.5"
quit 1
end
if result_vdd_e1 > 4.75
echo "ASSERTION FAILED: result_vdd_e1 above 4.75"
quit 1
end
if result_vdd_e2 < 4.5
echo "ASSERTION FAILED: result_vdd_e2 below 4.5"
quit 1
end
if result_vdd_e2 > 4.75
echo "ASSERTION FAILED: result_vdd_e2 above 4.75"
quit 1
end
if result_vdd_e3 < 4.5
echo "ASSERTION FAILED: result_vdd_e3 below 4.5"
quit 1
end
if result_vdd_e3 > 4.75
echo "ASSERTION FAILED: result_vdd_e3 above 4.75"
quit 1
end
if result_vdd_e4 < 4.5
echo "ASSERTION FAILED: result_vdd_e4 below 4.5"
quit 1
end
if result_vdd_e4 > 4.75
echo "ASSERTION FAILED: result_vdd_e4 above 4.75"
quit 1
end
if result_vdd_e5 < 4.5
echo "ASSERTION FAILED: result_vdd_e5 below 4.5"
quit 1
end
if result_vdd_e5 > 4.75
echo "ASSERTION FAILED: result_vdd_e5 above 4.75"
quit 1
end
if result_vdd_e6 < 4.5
echo "ASSERTION FAILED: result_vdd_e6 below 4.5"
quit 1
end
if result_vdd_e6 > 4.75
echo "ASSERTION FAILED: result_vdd_e6 above 4.75"
quit 1
end
if result_vdd_e7 < 4.5
echo "ASSERTION FAILED: result_vdd_e7 below 4.5"
quit 1
end
if result_vdd_e7 > 4.75
echo "ASSERTION FAILED: result_vdd_e7 above 4.75"
quit 1
end
if result_vdd_e8 < 4.5
echo "ASSERTION FAILED: result_vdd_e8 below 4.5"
quit 1
end
if result_vdd_e8 > 4.75
echo "ASSERTION FAILED: result_vdd_e8 above 4.75"
quit 1
end
if result_vdd_f1 < 4.5
echo "ASSERTION FAILED: result_vdd_f1 below 4.5"
quit 1
end
if result_vdd_f1 > 4.75
echo "ASSERTION FAILED: result_vdd_f1 above 4.75"
quit 1
end
if result_vdd_f2 < 4.5
echo "ASSERTION FAILED: result_vdd_f2 below 4.5"
quit 1
end
if result_vdd_f2 > 4.75
echo "ASSERTION FAILED: result_vdd_f2 above 4.75"
quit 1
end
if result_vdd_f3 < 4.5
echo "ASSERTION FAILED: result_vdd_f3 below 4.5"
quit 1
end
if result_vdd_f3 > 4.75
echo "ASSERTION FAILED: result_vdd_f3 above 4.75"
quit 1
end
if result_vdd_f4 < 4.5
echo "ASSERTION FAILED: result_vdd_f4 below 4.5"
quit 1
end
if result_vdd_f4 > 4.75
echo "ASSERTION FAILED: result_vdd_f4 above 4.75"
quit 1
end
if result_vdd_f5 < 4.5
echo "ASSERTION FAILED: result_vdd_f5 below 4.5"
quit 1
end
if result_vdd_f5 > 4.75
echo "ASSERTION FAILED: result_vdd_f5 above 4.75"
quit 1
end
if result_vdd_f6 < 4.5
echo "ASSERTION FAILED: result_vdd_f6 below 4.5"
quit 1
end
if result_vdd_f6 > 4.75
echo "ASSERTION FAILED: result_vdd_f6 above 4.75"
quit 1
end
if result_vdd_f7 < 4.5
echo "ASSERTION FAILED: result_vdd_f7 below 4.5"
quit 1
end
if result_vdd_f7 > 4.75
echo "ASSERTION FAILED: result_vdd_f7 above 4.75"
quit 1
end
if result_vdd_f8 < 4.5
echo "ASSERTION FAILED: result_vdd_f8 below 4.5"
quit 1
end
if result_vdd_f8 > 4.75
echo "ASSERTION FAILED: result_vdd_f8 above 4.75"
quit 1
end
if result_vdd_g1 < 4.5
echo "ASSERTION FAILED: result_vdd_g1 below 4.5"
quit 1
end
if result_vdd_g1 > 4.75
echo "ASSERTION FAILED: result_vdd_g1 above 4.75"
quit 1
end
if result_vdd_g2 < 4.5
echo "ASSERTION FAILED: result_vdd_g2 below 4.5"
quit 1
end
if result_vdd_g2 > 4.75
echo "ASSERTION FAILED: result_vdd_g2 above 4.75"
quit 1
end
if result_vdd_g3 < 4.5
echo "ASSERTION FAILED: result_vdd_g3 below 4.5"
quit 1
end
if result_vdd_g3 > 4.75
echo "ASSERTION FAILED: result_vdd_g3 above 4.75"
quit 1
end
if result_vdd_g4 < 4.5
echo "ASSERTION FAILED: result_vdd_g4 below 4.5"
quit 1
end
if result_vdd_g4 > 4.75
echo "ASSERTION FAILED: result_vdd_g4 above 4.75"
quit 1
end
if result_vdd_g5 < 4.5
echo "ASSERTION FAILED: result_vdd_g5 below 4.5"
quit 1
end
if result_vdd_g5 > 4.75
echo "ASSERTION FAILED: result_vdd_g5 above 4.75"
quit 1
end
if result_vdd_g6 < 4.5
echo "ASSERTION FAILED: result_vdd_g6 below 4.5"
quit 1
end
if result_vdd_g6 > 4.75
echo "ASSERTION FAILED: result_vdd_g6 above 4.75"
quit 1
end
if result_vdd_g7 < 4.5
echo "ASSERTION FAILED: result_vdd_g7 below 4.5"
quit 1
end
if result_vdd_g7 > 4.75
echo "ASSERTION FAILED: result_vdd_g7 above 4.75"
quit 1
end
if result_vdd_g8 < 4.5
echo "ASSERTION FAILED: result_vdd_g8 below 4.5"
quit 1
end
if result_vdd_g8 > 4.75
echo "ASSERTION FAILED: result_vdd_g8 above 4.75"
quit 1
end
if result_vdd_h1 < 4.5
echo "ASSERTION FAILED: result_vdd_h1 below 4.5"
quit 1
end
if result_vdd_h1 > 4.75
echo "ASSERTION FAILED: result_vdd_h1 above 4.75"
quit 1
end
if result_vdd_h2 < 4.5
echo "ASSERTION FAILED: result_vdd_h2 below 4.5"
quit 1
end
if result_vdd_h2 > 4.75
echo "ASSERTION FAILED: result_vdd_h2 above 4.75"
quit 1
end
if result_vdd_h3 < 4.5
echo "ASSERTION FAILED: result_vdd_h3 below 4.5"
quit 1
end
if result_vdd_h3 > 4.75
echo "ASSERTION FAILED: result_vdd_h3 above 4.75"
quit 1
end
if result_vdd_h4 < 4.5
echo "ASSERTION FAILED: result_vdd_h4 below 4.5"
quit 1
end
if result_vdd_h4 > 4.75
echo "ASSERTION FAILED: result_vdd_h4 above 4.75"
quit 1
end
if result_vdd_h5 < 4.5
echo "ASSERTION FAILED: result_vdd_h5 below 4.5"
quit 1
end
if result_vdd_h5 > 4.75
echo "ASSERTION FAILED: result_vdd_h5 above 4.75"
quit 1
end
if result_vdd_h6 < 4.5
echo "ASSERTION FAILED: result_vdd_h6 below 4.5"
quit 1
end
if result_vdd_h6 > 4.75
echo "ASSERTION FAILED: result_vdd_h6 above 4.75"
quit 1
end
if result_vdd_h7 < 4.5
echo "ASSERTION FAILED: result_vdd_h7 below 4.5"
quit 1
end
if result_vdd_h7 > 4.75
echo "ASSERTION FAILED: result_vdd_h7 above 4.75"
quit 1
end
if result_vdd_h8 < 4.5
echo "ASSERTION FAILED: result_vdd_h8 below 4.5"
quit 1
end
if result_vdd_h8 > 4.75
echo "ASSERTION FAILED: result_vdd_h8 above 4.75"
quit 1
end
if result_pi_header < 4.5
echo "ASSERTION FAILED: result_pi_header below 4.5"
quit 1
end
if result_pi_header > 4.75
echo "ASSERTION FAILED: result_pi_header above 4.75"
quit 1
end
quit 0
.endc
.end
