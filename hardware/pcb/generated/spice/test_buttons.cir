Generated chess-board panel buttons, one press at a time
.model TL1105_DOME SW(Ron=0.1 Roff=100000000.0 Vt=0.5 Vh=0.1)
VDD 3v3 0 3.3
RPULL_SW1 btn_up 3v3 50000.0
VPRESS_SW1 press_0 0 PULSE(0 1 1.0m 1u 1u 0.5m 1)
RSTRAP_SW1_2b_2 0 0 0.1
SDOME_SW1_2b_1 0 btn_up press_0 0 TL1105_DOME
SDOME_SW1_2_1b 0 btn_up press_0 0 TL1105_DOME
RSTRAP_SW1_1b_1 btn_up btn_up 0.1
RPULL_SW10 btn_f3 3v3 50000.0
VPRESS_SW10 press_1 0 PULSE(0 1 2.0m 1u 1u 0.5m 1)
RSTRAP_SW10_2b_2 0 0 0.1
SDOME_SW10_2b_1 0 btn_f3 press_1 0 TL1105_DOME
SDOME_SW10_2_1b 0 btn_f3 press_1 0 TL1105_DOME
RSTRAP_SW10_1b_1 btn_f3 btn_f3 0.1
RPULL_SW11 btn_f4 3v3 50000.0
VPRESS_SW11 press_2 0 PULSE(0 1 3.0m 1u 1u 0.5m 1)
RSTRAP_SW11_2b_2 0 0 0.1
SDOME_SW11_2b_1 0 btn_f4 press_2 0 TL1105_DOME
SDOME_SW11_2_1b 0 btn_f4 press_2 0 TL1105_DOME
RSTRAP_SW11_1b_1 btn_f4 btn_f4 0.1
RPULL_SW12 btn_f5 3v3 50000.0
VPRESS_SW12 press_3 0 PULSE(0 1 4.0m 1u 1u 0.5m 1)
RSTRAP_SW12_2b_2 0 0 0.1
SDOME_SW12_2b_1 0 btn_f5 press_3 0 TL1105_DOME
SDOME_SW12_2_1b 0 btn_f5 press_3 0 TL1105_DOME
RSTRAP_SW12_1b_1 btn_f5 btn_f5 0.1
RPULL_SW2 btn_down 3v3 50000.0
VPRESS_SW2 press_4 0 PULSE(0 1 5.0m 1u 1u 0.5m 1)
RSTRAP_SW2_2b_2 0 0 0.1
SDOME_SW2_2b_1 0 btn_down press_4 0 TL1105_DOME
SDOME_SW2_2_1b 0 btn_down press_4 0 TL1105_DOME
RSTRAP_SW2_1b_1 btn_down btn_down 0.1
RPULL_SW3 btn_left 3v3 50000.0
VPRESS_SW3 press_5 0 PULSE(0 1 6.0m 1u 1u 0.5m 1)
RSTRAP_SW3_2b_2 0 0 0.1
SDOME_SW3_2b_1 0 btn_left press_5 0 TL1105_DOME
SDOME_SW3_2_1b 0 btn_left press_5 0 TL1105_DOME
RSTRAP_SW3_1b_1 btn_left btn_left 0.1
RPULL_SW4 btn_right 3v3 50000.0
VPRESS_SW4 press_6 0 PULSE(0 1 7.0m 1u 1u 0.5m 1)
RSTRAP_SW4_2b_2 0 0 0.1
SDOME_SW4_2b_1 0 btn_right press_6 0 TL1105_DOME
SDOME_SW4_2_1b 0 btn_right press_6 0 TL1105_DOME
RSTRAP_SW4_1b_1 btn_right btn_right 0.1
RPULL_SW5 btn_ok 3v3 50000.0
VPRESS_SW5 press_7 0 PULSE(0 1 8.0m 1u 1u 0.5m 1)
RSTRAP_SW5_2b_2 0 0 0.1
SDOME_SW5_2b_1 0 btn_ok press_7 0 TL1105_DOME
SDOME_SW5_2_1b 0 btn_ok press_7 0 TL1105_DOME
RSTRAP_SW5_1b_1 btn_ok btn_ok 0.1
RPULL_SW6 btn_reset 3v3 50000.0
VPRESS_SW6 press_8 0 PULSE(0 1 9.0m 1u 1u 0.5m 1)
RSTRAP_SW6_2b_2 0 0 0.1
SDOME_SW6_2b_1 0 btn_reset press_8 0 TL1105_DOME
SDOME_SW6_2_1b 0 btn_reset press_8 0 TL1105_DOME
RSTRAP_SW6_1b_1 btn_reset btn_reset 0.1
RPULL_SW7 btn_pass 3v3 50000.0
VPRESS_SW7 press_9 0 PULSE(0 1 10.0m 1u 1u 0.5m 1)
RSTRAP_SW7_2b_2 0 0 0.1
SDOME_SW7_2b_1 0 btn_pass press_9 0 TL1105_DOME
SDOME_SW7_2_1b 0 btn_pass press_9 0 TL1105_DOME
RSTRAP_SW7_1b_1 btn_pass btn_pass 0.1
RPULL_SW8 btn_f1 3v3 50000.0
VPRESS_SW8 press_10 0 PULSE(0 1 11.0m 1u 1u 0.5m 1)
RSTRAP_SW8_2b_2 0 0 0.1
SDOME_SW8_2b_1 0 btn_f1 press_10 0 TL1105_DOME
SDOME_SW8_2_1b 0 btn_f1 press_10 0 TL1105_DOME
RSTRAP_SW8_1b_1 btn_f1 btn_f1 0.1
RPULL_SW9 btn_f2 3v3 50000.0
VPRESS_SW9 press_11 0 PULSE(0 1 12.0m 1u 1u 0.5m 1)
RSTRAP_SW9_2b_2 0 0 0.1
SDOME_SW9_2b_1 0 btn_f2 press_11 0 TL1105_DOME
SDOME_SW9_2_1b 0 btn_f2 press_11 0 TL1105_DOME
RSTRAP_SW9_1b_1 btn_f2 btn_f2 0.1
.tran 10u 13.0m
.control
run
meas tran result_btn_up_idle FIND v(btn_up) AT=0.5m
meas tran result_btn_up_with_btn_up FIND v(btn_up) AT=1.25m
meas tran result_btn_up_with_btn_f3 FIND v(btn_up) AT=2.25m
meas tran result_btn_up_with_btn_f4 FIND v(btn_up) AT=3.25m
meas tran result_btn_up_with_btn_f5 FIND v(btn_up) AT=4.25m
meas tran result_btn_up_with_btn_down FIND v(btn_up) AT=5.25m
meas tran result_btn_up_with_btn_left FIND v(btn_up) AT=6.25m
meas tran result_btn_up_with_btn_right FIND v(btn_up) AT=7.25m
meas tran result_btn_up_with_btn_ok FIND v(btn_up) AT=8.25m
meas tran result_btn_up_with_btn_reset FIND v(btn_up) AT=9.25m
meas tran result_btn_up_with_btn_pass FIND v(btn_up) AT=10.25m
meas tran result_btn_up_with_btn_f1 FIND v(btn_up) AT=11.25m
meas tran result_btn_up_with_btn_f2 FIND v(btn_up) AT=12.25m
meas tran result_btn_f3_idle FIND v(btn_f3) AT=0.5m
meas tran result_btn_f3_with_btn_up FIND v(btn_f3) AT=1.25m
meas tran result_btn_f3_with_btn_f3 FIND v(btn_f3) AT=2.25m
meas tran result_btn_f3_with_btn_f4 FIND v(btn_f3) AT=3.25m
meas tran result_btn_f3_with_btn_f5 FIND v(btn_f3) AT=4.25m
meas tran result_btn_f3_with_btn_down FIND v(btn_f3) AT=5.25m
meas tran result_btn_f3_with_btn_left FIND v(btn_f3) AT=6.25m
meas tran result_btn_f3_with_btn_right FIND v(btn_f3) AT=7.25m
meas tran result_btn_f3_with_btn_ok FIND v(btn_f3) AT=8.25m
meas tran result_btn_f3_with_btn_reset FIND v(btn_f3) AT=9.25m
meas tran result_btn_f3_with_btn_pass FIND v(btn_f3) AT=10.25m
meas tran result_btn_f3_with_btn_f1 FIND v(btn_f3) AT=11.25m
meas tran result_btn_f3_with_btn_f2 FIND v(btn_f3) AT=12.25m
meas tran result_btn_f4_idle FIND v(btn_f4) AT=0.5m
meas tran result_btn_f4_with_btn_up FIND v(btn_f4) AT=1.25m
meas tran result_btn_f4_with_btn_f3 FIND v(btn_f4) AT=2.25m
meas tran result_btn_f4_with_btn_f4 FIND v(btn_f4) AT=3.25m
meas tran result_btn_f4_with_btn_f5 FIND v(btn_f4) AT=4.25m
meas tran result_btn_f4_with_btn_down FIND v(btn_f4) AT=5.25m
meas tran result_btn_f4_with_btn_left FIND v(btn_f4) AT=6.25m
meas tran result_btn_f4_with_btn_right FIND v(btn_f4) AT=7.25m
meas tran result_btn_f4_with_btn_ok FIND v(btn_f4) AT=8.25m
meas tran result_btn_f4_with_btn_reset FIND v(btn_f4) AT=9.25m
meas tran result_btn_f4_with_btn_pass FIND v(btn_f4) AT=10.25m
meas tran result_btn_f4_with_btn_f1 FIND v(btn_f4) AT=11.25m
meas tran result_btn_f4_with_btn_f2 FIND v(btn_f4) AT=12.25m
meas tran result_btn_f5_idle FIND v(btn_f5) AT=0.5m
meas tran result_btn_f5_with_btn_up FIND v(btn_f5) AT=1.25m
meas tran result_btn_f5_with_btn_f3 FIND v(btn_f5) AT=2.25m
meas tran result_btn_f5_with_btn_f4 FIND v(btn_f5) AT=3.25m
meas tran result_btn_f5_with_btn_f5 FIND v(btn_f5) AT=4.25m
meas tran result_btn_f5_with_btn_down FIND v(btn_f5) AT=5.25m
meas tran result_btn_f5_with_btn_left FIND v(btn_f5) AT=6.25m
meas tran result_btn_f5_with_btn_right FIND v(btn_f5) AT=7.25m
meas tran result_btn_f5_with_btn_ok FIND v(btn_f5) AT=8.25m
meas tran result_btn_f5_with_btn_reset FIND v(btn_f5) AT=9.25m
meas tran result_btn_f5_with_btn_pass FIND v(btn_f5) AT=10.25m
meas tran result_btn_f5_with_btn_f1 FIND v(btn_f5) AT=11.25m
meas tran result_btn_f5_with_btn_f2 FIND v(btn_f5) AT=12.25m
meas tran result_btn_down_idle FIND v(btn_down) AT=0.5m
meas tran result_btn_down_with_btn_up FIND v(btn_down) AT=1.25m
meas tran result_btn_down_with_btn_f3 FIND v(btn_down) AT=2.25m
meas tran result_btn_down_with_btn_f4 FIND v(btn_down) AT=3.25m
meas tran result_btn_down_with_btn_f5 FIND v(btn_down) AT=4.25m
meas tran result_btn_down_with_btn_down FIND v(btn_down) AT=5.25m
meas tran result_btn_down_with_btn_left FIND v(btn_down) AT=6.25m
meas tran result_btn_down_with_btn_right FIND v(btn_down) AT=7.25m
meas tran result_btn_down_with_btn_ok FIND v(btn_down) AT=8.25m
meas tran result_btn_down_with_btn_reset FIND v(btn_down) AT=9.25m
meas tran result_btn_down_with_btn_pass FIND v(btn_down) AT=10.25m
meas tran result_btn_down_with_btn_f1 FIND v(btn_down) AT=11.25m
meas tran result_btn_down_with_btn_f2 FIND v(btn_down) AT=12.25m
meas tran result_btn_left_idle FIND v(btn_left) AT=0.5m
meas tran result_btn_left_with_btn_up FIND v(btn_left) AT=1.25m
meas tran result_btn_left_with_btn_f3 FIND v(btn_left) AT=2.25m
meas tran result_btn_left_with_btn_f4 FIND v(btn_left) AT=3.25m
meas tran result_btn_left_with_btn_f5 FIND v(btn_left) AT=4.25m
meas tran result_btn_left_with_btn_down FIND v(btn_left) AT=5.25m
meas tran result_btn_left_with_btn_left FIND v(btn_left) AT=6.25m
meas tran result_btn_left_with_btn_right FIND v(btn_left) AT=7.25m
meas tran result_btn_left_with_btn_ok FIND v(btn_left) AT=8.25m
meas tran result_btn_left_with_btn_reset FIND v(btn_left) AT=9.25m
meas tran result_btn_left_with_btn_pass FIND v(btn_left) AT=10.25m
meas tran result_btn_left_with_btn_f1 FIND v(btn_left) AT=11.25m
meas tran result_btn_left_with_btn_f2 FIND v(btn_left) AT=12.25m
meas tran result_btn_right_idle FIND v(btn_right) AT=0.5m
meas tran result_btn_right_with_btn_up FIND v(btn_right) AT=1.25m
meas tran result_btn_right_with_btn_f3 FIND v(btn_right) AT=2.25m
meas tran result_btn_right_with_btn_f4 FIND v(btn_right) AT=3.25m
meas tran result_btn_right_with_btn_f5 FIND v(btn_right) AT=4.25m
meas tran result_btn_right_with_btn_down FIND v(btn_right) AT=5.25m
meas tran result_btn_right_with_btn_left FIND v(btn_right) AT=6.25m
meas tran result_btn_right_with_btn_right FIND v(btn_right) AT=7.25m
meas tran result_btn_right_with_btn_ok FIND v(btn_right) AT=8.25m
meas tran result_btn_right_with_btn_reset FIND v(btn_right) AT=9.25m
meas tran result_btn_right_with_btn_pass FIND v(btn_right) AT=10.25m
meas tran result_btn_right_with_btn_f1 FIND v(btn_right) AT=11.25m
meas tran result_btn_right_with_btn_f2 FIND v(btn_right) AT=12.25m
meas tran result_btn_ok_idle FIND v(btn_ok) AT=0.5m
meas tran result_btn_ok_with_btn_up FIND v(btn_ok) AT=1.25m
meas tran result_btn_ok_with_btn_f3 FIND v(btn_ok) AT=2.25m
meas tran result_btn_ok_with_btn_f4 FIND v(btn_ok) AT=3.25m
meas tran result_btn_ok_with_btn_f5 FIND v(btn_ok) AT=4.25m
meas tran result_btn_ok_with_btn_down FIND v(btn_ok) AT=5.25m
meas tran result_btn_ok_with_btn_left FIND v(btn_ok) AT=6.25m
meas tran result_btn_ok_with_btn_right FIND v(btn_ok) AT=7.25m
meas tran result_btn_ok_with_btn_ok FIND v(btn_ok) AT=8.25m
meas tran result_btn_ok_with_btn_reset FIND v(btn_ok) AT=9.25m
meas tran result_btn_ok_with_btn_pass FIND v(btn_ok) AT=10.25m
meas tran result_btn_ok_with_btn_f1 FIND v(btn_ok) AT=11.25m
meas tran result_btn_ok_with_btn_f2 FIND v(btn_ok) AT=12.25m
meas tran result_btn_reset_idle FIND v(btn_reset) AT=0.5m
meas tran result_btn_reset_with_btn_up FIND v(btn_reset) AT=1.25m
meas tran result_btn_reset_with_btn_f3 FIND v(btn_reset) AT=2.25m
meas tran result_btn_reset_with_btn_f4 FIND v(btn_reset) AT=3.25m
meas tran result_btn_reset_with_btn_f5 FIND v(btn_reset) AT=4.25m
meas tran result_btn_reset_with_btn_down FIND v(btn_reset) AT=5.25m
meas tran result_btn_reset_with_btn_left FIND v(btn_reset) AT=6.25m
meas tran result_btn_reset_with_btn_right FIND v(btn_reset) AT=7.25m
meas tran result_btn_reset_with_btn_ok FIND v(btn_reset) AT=8.25m
meas tran result_btn_reset_with_btn_reset FIND v(btn_reset) AT=9.25m
meas tran result_btn_reset_with_btn_pass FIND v(btn_reset) AT=10.25m
meas tran result_btn_reset_with_btn_f1 FIND v(btn_reset) AT=11.25m
meas tran result_btn_reset_with_btn_f2 FIND v(btn_reset) AT=12.25m
meas tran result_btn_pass_idle FIND v(btn_pass) AT=0.5m
meas tran result_btn_pass_with_btn_up FIND v(btn_pass) AT=1.25m
meas tran result_btn_pass_with_btn_f3 FIND v(btn_pass) AT=2.25m
meas tran result_btn_pass_with_btn_f4 FIND v(btn_pass) AT=3.25m
meas tran result_btn_pass_with_btn_f5 FIND v(btn_pass) AT=4.25m
meas tran result_btn_pass_with_btn_down FIND v(btn_pass) AT=5.25m
meas tran result_btn_pass_with_btn_left FIND v(btn_pass) AT=6.25m
meas tran result_btn_pass_with_btn_right FIND v(btn_pass) AT=7.25m
meas tran result_btn_pass_with_btn_ok FIND v(btn_pass) AT=8.25m
meas tran result_btn_pass_with_btn_reset FIND v(btn_pass) AT=9.25m
meas tran result_btn_pass_with_btn_pass FIND v(btn_pass) AT=10.25m
meas tran result_btn_pass_with_btn_f1 FIND v(btn_pass) AT=11.25m
meas tran result_btn_pass_with_btn_f2 FIND v(btn_pass) AT=12.25m
meas tran result_btn_f1_idle FIND v(btn_f1) AT=0.5m
meas tran result_btn_f1_with_btn_up FIND v(btn_f1) AT=1.25m
meas tran result_btn_f1_with_btn_f3 FIND v(btn_f1) AT=2.25m
meas tran result_btn_f1_with_btn_f4 FIND v(btn_f1) AT=3.25m
meas tran result_btn_f1_with_btn_f5 FIND v(btn_f1) AT=4.25m
meas tran result_btn_f1_with_btn_down FIND v(btn_f1) AT=5.25m
meas tran result_btn_f1_with_btn_left FIND v(btn_f1) AT=6.25m
meas tran result_btn_f1_with_btn_right FIND v(btn_f1) AT=7.25m
meas tran result_btn_f1_with_btn_ok FIND v(btn_f1) AT=8.25m
meas tran result_btn_f1_with_btn_reset FIND v(btn_f1) AT=9.25m
meas tran result_btn_f1_with_btn_pass FIND v(btn_f1) AT=10.25m
meas tran result_btn_f1_with_btn_f1 FIND v(btn_f1) AT=11.25m
meas tran result_btn_f1_with_btn_f2 FIND v(btn_f1) AT=12.25m
meas tran result_btn_f2_idle FIND v(btn_f2) AT=0.5m
meas tran result_btn_f2_with_btn_up FIND v(btn_f2) AT=1.25m
meas tran result_btn_f2_with_btn_f3 FIND v(btn_f2) AT=2.25m
meas tran result_btn_f2_with_btn_f4 FIND v(btn_f2) AT=3.25m
meas tran result_btn_f2_with_btn_f5 FIND v(btn_f2) AT=4.25m
meas tran result_btn_f2_with_btn_down FIND v(btn_f2) AT=5.25m
meas tran result_btn_f2_with_btn_left FIND v(btn_f2) AT=6.25m
meas tran result_btn_f2_with_btn_right FIND v(btn_f2) AT=7.25m
meas tran result_btn_f2_with_btn_ok FIND v(btn_f2) AT=8.25m
meas tran result_btn_f2_with_btn_reset FIND v(btn_f2) AT=9.25m
meas tran result_btn_f2_with_btn_pass FIND v(btn_f2) AT=10.25m
meas tran result_btn_f2_with_btn_f1 FIND v(btn_f2) AT=11.25m
meas tran result_btn_f2_with_btn_f2 FIND v(btn_f2) AT=12.25m
if result_btn_up_idle < 3.2
echo "ASSERTION FAILED: result_btn_up_idle below 3.2"
quit 1
end
if result_btn_up_idle > 3.4
echo "ASSERTION FAILED: result_btn_up_idle above 3.4"
quit 1
end
if result_btn_up_with_btn_up < 0
echo "ASSERTION FAILED: result_btn_up_with_btn_up below 0"
quit 1
end
if result_btn_up_with_btn_up > 0.1
echo "ASSERTION FAILED: result_btn_up_with_btn_up above 0.1"
quit 1
end
if result_btn_up_with_btn_down < 3.2
echo "ASSERTION FAILED: result_btn_up_with_btn_down below 3.2"
quit 1
end
if result_btn_up_with_btn_down > 3.4
echo "ASSERTION FAILED: result_btn_up_with_btn_down above 3.4"
quit 1
end
if result_btn_up_with_btn_left < 3.2
echo "ASSERTION FAILED: result_btn_up_with_btn_left below 3.2"
quit 1
end
if result_btn_up_with_btn_left > 3.4
echo "ASSERTION FAILED: result_btn_up_with_btn_left above 3.4"
quit 1
end
if result_btn_up_with_btn_right < 3.2
echo "ASSERTION FAILED: result_btn_up_with_btn_right below 3.2"
quit 1
end
if result_btn_up_with_btn_right > 3.4
echo "ASSERTION FAILED: result_btn_up_with_btn_right above 3.4"
quit 1
end
if result_btn_up_with_btn_ok < 3.2
echo "ASSERTION FAILED: result_btn_up_with_btn_ok below 3.2"
quit 1
end
if result_btn_up_with_btn_ok > 3.4
echo "ASSERTION FAILED: result_btn_up_with_btn_ok above 3.4"
quit 1
end
if result_btn_up_with_btn_reset < 3.2
echo "ASSERTION FAILED: result_btn_up_with_btn_reset below 3.2"
quit 1
end
if result_btn_up_with_btn_reset > 3.4
echo "ASSERTION FAILED: result_btn_up_with_btn_reset above 3.4"
quit 1
end
if result_btn_up_with_btn_pass < 3.2
echo "ASSERTION FAILED: result_btn_up_with_btn_pass below 3.2"
quit 1
end
if result_btn_up_with_btn_pass > 3.4
echo "ASSERTION FAILED: result_btn_up_with_btn_pass above 3.4"
quit 1
end
if result_btn_up_with_btn_f1 < 3.2
echo "ASSERTION FAILED: result_btn_up_with_btn_f1 below 3.2"
quit 1
end
if result_btn_up_with_btn_f1 > 3.4
echo "ASSERTION FAILED: result_btn_up_with_btn_f1 above 3.4"
quit 1
end
if result_btn_up_with_btn_f2 < 3.2
echo "ASSERTION FAILED: result_btn_up_with_btn_f2 below 3.2"
quit 1
end
if result_btn_up_with_btn_f2 > 3.4
echo "ASSERTION FAILED: result_btn_up_with_btn_f2 above 3.4"
quit 1
end
if result_btn_up_with_btn_f3 < 3.2
echo "ASSERTION FAILED: result_btn_up_with_btn_f3 below 3.2"
quit 1
end
if result_btn_up_with_btn_f3 > 3.4
echo "ASSERTION FAILED: result_btn_up_with_btn_f3 above 3.4"
quit 1
end
if result_btn_up_with_btn_f4 < 3.2
echo "ASSERTION FAILED: result_btn_up_with_btn_f4 below 3.2"
quit 1
end
if result_btn_up_with_btn_f4 > 3.4
echo "ASSERTION FAILED: result_btn_up_with_btn_f4 above 3.4"
quit 1
end
if result_btn_up_with_btn_f5 < 3.2
echo "ASSERTION FAILED: result_btn_up_with_btn_f5 below 3.2"
quit 1
end
if result_btn_up_with_btn_f5 > 3.4
echo "ASSERTION FAILED: result_btn_up_with_btn_f5 above 3.4"
quit 1
end
if result_btn_down_idle < 3.2
echo "ASSERTION FAILED: result_btn_down_idle below 3.2"
quit 1
end
if result_btn_down_idle > 3.4
echo "ASSERTION FAILED: result_btn_down_idle above 3.4"
quit 1
end
if result_btn_down_with_btn_up < 3.2
echo "ASSERTION FAILED: result_btn_down_with_btn_up below 3.2"
quit 1
end
if result_btn_down_with_btn_up > 3.4
echo "ASSERTION FAILED: result_btn_down_with_btn_up above 3.4"
quit 1
end
if result_btn_down_with_btn_down < 0
echo "ASSERTION FAILED: result_btn_down_with_btn_down below 0"
quit 1
end
if result_btn_down_with_btn_down > 0.1
echo "ASSERTION FAILED: result_btn_down_with_btn_down above 0.1"
quit 1
end
if result_btn_down_with_btn_left < 3.2
echo "ASSERTION FAILED: result_btn_down_with_btn_left below 3.2"
quit 1
end
if result_btn_down_with_btn_left > 3.4
echo "ASSERTION FAILED: result_btn_down_with_btn_left above 3.4"
quit 1
end
if result_btn_down_with_btn_right < 3.2
echo "ASSERTION FAILED: result_btn_down_with_btn_right below 3.2"
quit 1
end
if result_btn_down_with_btn_right > 3.4
echo "ASSERTION FAILED: result_btn_down_with_btn_right above 3.4"
quit 1
end
if result_btn_down_with_btn_ok < 3.2
echo "ASSERTION FAILED: result_btn_down_with_btn_ok below 3.2"
quit 1
end
if result_btn_down_with_btn_ok > 3.4
echo "ASSERTION FAILED: result_btn_down_with_btn_ok above 3.4"
quit 1
end
if result_btn_down_with_btn_reset < 3.2
echo "ASSERTION FAILED: result_btn_down_with_btn_reset below 3.2"
quit 1
end
if result_btn_down_with_btn_reset > 3.4
echo "ASSERTION FAILED: result_btn_down_with_btn_reset above 3.4"
quit 1
end
if result_btn_down_with_btn_pass < 3.2
echo "ASSERTION FAILED: result_btn_down_with_btn_pass below 3.2"
quit 1
end
if result_btn_down_with_btn_pass > 3.4
echo "ASSERTION FAILED: result_btn_down_with_btn_pass above 3.4"
quit 1
end
if result_btn_down_with_btn_f1 < 3.2
echo "ASSERTION FAILED: result_btn_down_with_btn_f1 below 3.2"
quit 1
end
if result_btn_down_with_btn_f1 > 3.4
echo "ASSERTION FAILED: result_btn_down_with_btn_f1 above 3.4"
quit 1
end
if result_btn_down_with_btn_f2 < 3.2
echo "ASSERTION FAILED: result_btn_down_with_btn_f2 below 3.2"
quit 1
end
if result_btn_down_with_btn_f2 > 3.4
echo "ASSERTION FAILED: result_btn_down_with_btn_f2 above 3.4"
quit 1
end
if result_btn_down_with_btn_f3 < 3.2
echo "ASSERTION FAILED: result_btn_down_with_btn_f3 below 3.2"
quit 1
end
if result_btn_down_with_btn_f3 > 3.4
echo "ASSERTION FAILED: result_btn_down_with_btn_f3 above 3.4"
quit 1
end
if result_btn_down_with_btn_f4 < 3.2
echo "ASSERTION FAILED: result_btn_down_with_btn_f4 below 3.2"
quit 1
end
if result_btn_down_with_btn_f4 > 3.4
echo "ASSERTION FAILED: result_btn_down_with_btn_f4 above 3.4"
quit 1
end
if result_btn_down_with_btn_f5 < 3.2
echo "ASSERTION FAILED: result_btn_down_with_btn_f5 below 3.2"
quit 1
end
if result_btn_down_with_btn_f5 > 3.4
echo "ASSERTION FAILED: result_btn_down_with_btn_f5 above 3.4"
quit 1
end
if result_btn_left_idle < 3.2
echo "ASSERTION FAILED: result_btn_left_idle below 3.2"
quit 1
end
if result_btn_left_idle > 3.4
echo "ASSERTION FAILED: result_btn_left_idle above 3.4"
quit 1
end
if result_btn_left_with_btn_up < 3.2
echo "ASSERTION FAILED: result_btn_left_with_btn_up below 3.2"
quit 1
end
if result_btn_left_with_btn_up > 3.4
echo "ASSERTION FAILED: result_btn_left_with_btn_up above 3.4"
quit 1
end
if result_btn_left_with_btn_down < 3.2
echo "ASSERTION FAILED: result_btn_left_with_btn_down below 3.2"
quit 1
end
if result_btn_left_with_btn_down > 3.4
echo "ASSERTION FAILED: result_btn_left_with_btn_down above 3.4"
quit 1
end
if result_btn_left_with_btn_left < 0
echo "ASSERTION FAILED: result_btn_left_with_btn_left below 0"
quit 1
end
if result_btn_left_with_btn_left > 0.1
echo "ASSERTION FAILED: result_btn_left_with_btn_left above 0.1"
quit 1
end
if result_btn_left_with_btn_right < 3.2
echo "ASSERTION FAILED: result_btn_left_with_btn_right below 3.2"
quit 1
end
if result_btn_left_with_btn_right > 3.4
echo "ASSERTION FAILED: result_btn_left_with_btn_right above 3.4"
quit 1
end
if result_btn_left_with_btn_ok < 3.2
echo "ASSERTION FAILED: result_btn_left_with_btn_ok below 3.2"
quit 1
end
if result_btn_left_with_btn_ok > 3.4
echo "ASSERTION FAILED: result_btn_left_with_btn_ok above 3.4"
quit 1
end
if result_btn_left_with_btn_reset < 3.2
echo "ASSERTION FAILED: result_btn_left_with_btn_reset below 3.2"
quit 1
end
if result_btn_left_with_btn_reset > 3.4
echo "ASSERTION FAILED: result_btn_left_with_btn_reset above 3.4"
quit 1
end
if result_btn_left_with_btn_pass < 3.2
echo "ASSERTION FAILED: result_btn_left_with_btn_pass below 3.2"
quit 1
end
if result_btn_left_with_btn_pass > 3.4
echo "ASSERTION FAILED: result_btn_left_with_btn_pass above 3.4"
quit 1
end
if result_btn_left_with_btn_f1 < 3.2
echo "ASSERTION FAILED: result_btn_left_with_btn_f1 below 3.2"
quit 1
end
if result_btn_left_with_btn_f1 > 3.4
echo "ASSERTION FAILED: result_btn_left_with_btn_f1 above 3.4"
quit 1
end
if result_btn_left_with_btn_f2 < 3.2
echo "ASSERTION FAILED: result_btn_left_with_btn_f2 below 3.2"
quit 1
end
if result_btn_left_with_btn_f2 > 3.4
echo "ASSERTION FAILED: result_btn_left_with_btn_f2 above 3.4"
quit 1
end
if result_btn_left_with_btn_f3 < 3.2
echo "ASSERTION FAILED: result_btn_left_with_btn_f3 below 3.2"
quit 1
end
if result_btn_left_with_btn_f3 > 3.4
echo "ASSERTION FAILED: result_btn_left_with_btn_f3 above 3.4"
quit 1
end
if result_btn_left_with_btn_f4 < 3.2
echo "ASSERTION FAILED: result_btn_left_with_btn_f4 below 3.2"
quit 1
end
if result_btn_left_with_btn_f4 > 3.4
echo "ASSERTION FAILED: result_btn_left_with_btn_f4 above 3.4"
quit 1
end
if result_btn_left_with_btn_f5 < 3.2
echo "ASSERTION FAILED: result_btn_left_with_btn_f5 below 3.2"
quit 1
end
if result_btn_left_with_btn_f5 > 3.4
echo "ASSERTION FAILED: result_btn_left_with_btn_f5 above 3.4"
quit 1
end
if result_btn_right_idle < 3.2
echo "ASSERTION FAILED: result_btn_right_idle below 3.2"
quit 1
end
if result_btn_right_idle > 3.4
echo "ASSERTION FAILED: result_btn_right_idle above 3.4"
quit 1
end
if result_btn_right_with_btn_up < 3.2
echo "ASSERTION FAILED: result_btn_right_with_btn_up below 3.2"
quit 1
end
if result_btn_right_with_btn_up > 3.4
echo "ASSERTION FAILED: result_btn_right_with_btn_up above 3.4"
quit 1
end
if result_btn_right_with_btn_down < 3.2
echo "ASSERTION FAILED: result_btn_right_with_btn_down below 3.2"
quit 1
end
if result_btn_right_with_btn_down > 3.4
echo "ASSERTION FAILED: result_btn_right_with_btn_down above 3.4"
quit 1
end
if result_btn_right_with_btn_left < 3.2
echo "ASSERTION FAILED: result_btn_right_with_btn_left below 3.2"
quit 1
end
if result_btn_right_with_btn_left > 3.4
echo "ASSERTION FAILED: result_btn_right_with_btn_left above 3.4"
quit 1
end
if result_btn_right_with_btn_right < 0
echo "ASSERTION FAILED: result_btn_right_with_btn_right below 0"
quit 1
end
if result_btn_right_with_btn_right > 0.1
echo "ASSERTION FAILED: result_btn_right_with_btn_right above 0.1"
quit 1
end
if result_btn_right_with_btn_ok < 3.2
echo "ASSERTION FAILED: result_btn_right_with_btn_ok below 3.2"
quit 1
end
if result_btn_right_with_btn_ok > 3.4
echo "ASSERTION FAILED: result_btn_right_with_btn_ok above 3.4"
quit 1
end
if result_btn_right_with_btn_reset < 3.2
echo "ASSERTION FAILED: result_btn_right_with_btn_reset below 3.2"
quit 1
end
if result_btn_right_with_btn_reset > 3.4
echo "ASSERTION FAILED: result_btn_right_with_btn_reset above 3.4"
quit 1
end
if result_btn_right_with_btn_pass < 3.2
echo "ASSERTION FAILED: result_btn_right_with_btn_pass below 3.2"
quit 1
end
if result_btn_right_with_btn_pass > 3.4
echo "ASSERTION FAILED: result_btn_right_with_btn_pass above 3.4"
quit 1
end
if result_btn_right_with_btn_f1 < 3.2
echo "ASSERTION FAILED: result_btn_right_with_btn_f1 below 3.2"
quit 1
end
if result_btn_right_with_btn_f1 > 3.4
echo "ASSERTION FAILED: result_btn_right_with_btn_f1 above 3.4"
quit 1
end
if result_btn_right_with_btn_f2 < 3.2
echo "ASSERTION FAILED: result_btn_right_with_btn_f2 below 3.2"
quit 1
end
if result_btn_right_with_btn_f2 > 3.4
echo "ASSERTION FAILED: result_btn_right_with_btn_f2 above 3.4"
quit 1
end
if result_btn_right_with_btn_f3 < 3.2
echo "ASSERTION FAILED: result_btn_right_with_btn_f3 below 3.2"
quit 1
end
if result_btn_right_with_btn_f3 > 3.4
echo "ASSERTION FAILED: result_btn_right_with_btn_f3 above 3.4"
quit 1
end
if result_btn_right_with_btn_f4 < 3.2
echo "ASSERTION FAILED: result_btn_right_with_btn_f4 below 3.2"
quit 1
end
if result_btn_right_with_btn_f4 > 3.4
echo "ASSERTION FAILED: result_btn_right_with_btn_f4 above 3.4"
quit 1
end
if result_btn_right_with_btn_f5 < 3.2
echo "ASSERTION FAILED: result_btn_right_with_btn_f5 below 3.2"
quit 1
end
if result_btn_right_with_btn_f5 > 3.4
echo "ASSERTION FAILED: result_btn_right_with_btn_f5 above 3.4"
quit 1
end
if result_btn_ok_idle < 3.2
echo "ASSERTION FAILED: result_btn_ok_idle below 3.2"
quit 1
end
if result_btn_ok_idle > 3.4
echo "ASSERTION FAILED: result_btn_ok_idle above 3.4"
quit 1
end
if result_btn_ok_with_btn_up < 3.2
echo "ASSERTION FAILED: result_btn_ok_with_btn_up below 3.2"
quit 1
end
if result_btn_ok_with_btn_up > 3.4
echo "ASSERTION FAILED: result_btn_ok_with_btn_up above 3.4"
quit 1
end
if result_btn_ok_with_btn_down < 3.2
echo "ASSERTION FAILED: result_btn_ok_with_btn_down below 3.2"
quit 1
end
if result_btn_ok_with_btn_down > 3.4
echo "ASSERTION FAILED: result_btn_ok_with_btn_down above 3.4"
quit 1
end
if result_btn_ok_with_btn_left < 3.2
echo "ASSERTION FAILED: result_btn_ok_with_btn_left below 3.2"
quit 1
end
if result_btn_ok_with_btn_left > 3.4
echo "ASSERTION FAILED: result_btn_ok_with_btn_left above 3.4"
quit 1
end
if result_btn_ok_with_btn_right < 3.2
echo "ASSERTION FAILED: result_btn_ok_with_btn_right below 3.2"
quit 1
end
if result_btn_ok_with_btn_right > 3.4
echo "ASSERTION FAILED: result_btn_ok_with_btn_right above 3.4"
quit 1
end
if result_btn_ok_with_btn_ok < 0
echo "ASSERTION FAILED: result_btn_ok_with_btn_ok below 0"
quit 1
end
if result_btn_ok_with_btn_ok > 0.1
echo "ASSERTION FAILED: result_btn_ok_with_btn_ok above 0.1"
quit 1
end
if result_btn_ok_with_btn_reset < 3.2
echo "ASSERTION FAILED: result_btn_ok_with_btn_reset below 3.2"
quit 1
end
if result_btn_ok_with_btn_reset > 3.4
echo "ASSERTION FAILED: result_btn_ok_with_btn_reset above 3.4"
quit 1
end
if result_btn_ok_with_btn_pass < 3.2
echo "ASSERTION FAILED: result_btn_ok_with_btn_pass below 3.2"
quit 1
end
if result_btn_ok_with_btn_pass > 3.4
echo "ASSERTION FAILED: result_btn_ok_with_btn_pass above 3.4"
quit 1
end
if result_btn_ok_with_btn_f1 < 3.2
echo "ASSERTION FAILED: result_btn_ok_with_btn_f1 below 3.2"
quit 1
end
if result_btn_ok_with_btn_f1 > 3.4
echo "ASSERTION FAILED: result_btn_ok_with_btn_f1 above 3.4"
quit 1
end
if result_btn_ok_with_btn_f2 < 3.2
echo "ASSERTION FAILED: result_btn_ok_with_btn_f2 below 3.2"
quit 1
end
if result_btn_ok_with_btn_f2 > 3.4
echo "ASSERTION FAILED: result_btn_ok_with_btn_f2 above 3.4"
quit 1
end
if result_btn_ok_with_btn_f3 < 3.2
echo "ASSERTION FAILED: result_btn_ok_with_btn_f3 below 3.2"
quit 1
end
if result_btn_ok_with_btn_f3 > 3.4
echo "ASSERTION FAILED: result_btn_ok_with_btn_f3 above 3.4"
quit 1
end
if result_btn_ok_with_btn_f4 < 3.2
echo "ASSERTION FAILED: result_btn_ok_with_btn_f4 below 3.2"
quit 1
end
if result_btn_ok_with_btn_f4 > 3.4
echo "ASSERTION FAILED: result_btn_ok_with_btn_f4 above 3.4"
quit 1
end
if result_btn_ok_with_btn_f5 < 3.2
echo "ASSERTION FAILED: result_btn_ok_with_btn_f5 below 3.2"
quit 1
end
if result_btn_ok_with_btn_f5 > 3.4
echo "ASSERTION FAILED: result_btn_ok_with_btn_f5 above 3.4"
quit 1
end
if result_btn_reset_idle < 3.2
echo "ASSERTION FAILED: result_btn_reset_idle below 3.2"
quit 1
end
if result_btn_reset_idle > 3.4
echo "ASSERTION FAILED: result_btn_reset_idle above 3.4"
quit 1
end
if result_btn_reset_with_btn_up < 3.2
echo "ASSERTION FAILED: result_btn_reset_with_btn_up below 3.2"
quit 1
end
if result_btn_reset_with_btn_up > 3.4
echo "ASSERTION FAILED: result_btn_reset_with_btn_up above 3.4"
quit 1
end
if result_btn_reset_with_btn_down < 3.2
echo "ASSERTION FAILED: result_btn_reset_with_btn_down below 3.2"
quit 1
end
if result_btn_reset_with_btn_down > 3.4
echo "ASSERTION FAILED: result_btn_reset_with_btn_down above 3.4"
quit 1
end
if result_btn_reset_with_btn_left < 3.2
echo "ASSERTION FAILED: result_btn_reset_with_btn_left below 3.2"
quit 1
end
if result_btn_reset_with_btn_left > 3.4
echo "ASSERTION FAILED: result_btn_reset_with_btn_left above 3.4"
quit 1
end
if result_btn_reset_with_btn_right < 3.2
echo "ASSERTION FAILED: result_btn_reset_with_btn_right below 3.2"
quit 1
end
if result_btn_reset_with_btn_right > 3.4
echo "ASSERTION FAILED: result_btn_reset_with_btn_right above 3.4"
quit 1
end
if result_btn_reset_with_btn_ok < 3.2
echo "ASSERTION FAILED: result_btn_reset_with_btn_ok below 3.2"
quit 1
end
if result_btn_reset_with_btn_ok > 3.4
echo "ASSERTION FAILED: result_btn_reset_with_btn_ok above 3.4"
quit 1
end
if result_btn_reset_with_btn_reset < 0
echo "ASSERTION FAILED: result_btn_reset_with_btn_reset below 0"
quit 1
end
if result_btn_reset_with_btn_reset > 0.1
echo "ASSERTION FAILED: result_btn_reset_with_btn_reset above 0.1"
quit 1
end
if result_btn_reset_with_btn_pass < 3.2
echo "ASSERTION FAILED: result_btn_reset_with_btn_pass below 3.2"
quit 1
end
if result_btn_reset_with_btn_pass > 3.4
echo "ASSERTION FAILED: result_btn_reset_with_btn_pass above 3.4"
quit 1
end
if result_btn_reset_with_btn_f1 < 3.2
echo "ASSERTION FAILED: result_btn_reset_with_btn_f1 below 3.2"
quit 1
end
if result_btn_reset_with_btn_f1 > 3.4
echo "ASSERTION FAILED: result_btn_reset_with_btn_f1 above 3.4"
quit 1
end
if result_btn_reset_with_btn_f2 < 3.2
echo "ASSERTION FAILED: result_btn_reset_with_btn_f2 below 3.2"
quit 1
end
if result_btn_reset_with_btn_f2 > 3.4
echo "ASSERTION FAILED: result_btn_reset_with_btn_f2 above 3.4"
quit 1
end
if result_btn_reset_with_btn_f3 < 3.2
echo "ASSERTION FAILED: result_btn_reset_with_btn_f3 below 3.2"
quit 1
end
if result_btn_reset_with_btn_f3 > 3.4
echo "ASSERTION FAILED: result_btn_reset_with_btn_f3 above 3.4"
quit 1
end
if result_btn_reset_with_btn_f4 < 3.2
echo "ASSERTION FAILED: result_btn_reset_with_btn_f4 below 3.2"
quit 1
end
if result_btn_reset_with_btn_f4 > 3.4
echo "ASSERTION FAILED: result_btn_reset_with_btn_f4 above 3.4"
quit 1
end
if result_btn_reset_with_btn_f5 < 3.2
echo "ASSERTION FAILED: result_btn_reset_with_btn_f5 below 3.2"
quit 1
end
if result_btn_reset_with_btn_f5 > 3.4
echo "ASSERTION FAILED: result_btn_reset_with_btn_f5 above 3.4"
quit 1
end
if result_btn_pass_idle < 3.2
echo "ASSERTION FAILED: result_btn_pass_idle below 3.2"
quit 1
end
if result_btn_pass_idle > 3.4
echo "ASSERTION FAILED: result_btn_pass_idle above 3.4"
quit 1
end
if result_btn_pass_with_btn_up < 3.2
echo "ASSERTION FAILED: result_btn_pass_with_btn_up below 3.2"
quit 1
end
if result_btn_pass_with_btn_up > 3.4
echo "ASSERTION FAILED: result_btn_pass_with_btn_up above 3.4"
quit 1
end
if result_btn_pass_with_btn_down < 3.2
echo "ASSERTION FAILED: result_btn_pass_with_btn_down below 3.2"
quit 1
end
if result_btn_pass_with_btn_down > 3.4
echo "ASSERTION FAILED: result_btn_pass_with_btn_down above 3.4"
quit 1
end
if result_btn_pass_with_btn_left < 3.2
echo "ASSERTION FAILED: result_btn_pass_with_btn_left below 3.2"
quit 1
end
if result_btn_pass_with_btn_left > 3.4
echo "ASSERTION FAILED: result_btn_pass_with_btn_left above 3.4"
quit 1
end
if result_btn_pass_with_btn_right < 3.2
echo "ASSERTION FAILED: result_btn_pass_with_btn_right below 3.2"
quit 1
end
if result_btn_pass_with_btn_right > 3.4
echo "ASSERTION FAILED: result_btn_pass_with_btn_right above 3.4"
quit 1
end
if result_btn_pass_with_btn_ok < 3.2
echo "ASSERTION FAILED: result_btn_pass_with_btn_ok below 3.2"
quit 1
end
if result_btn_pass_with_btn_ok > 3.4
echo "ASSERTION FAILED: result_btn_pass_with_btn_ok above 3.4"
quit 1
end
if result_btn_pass_with_btn_reset < 3.2
echo "ASSERTION FAILED: result_btn_pass_with_btn_reset below 3.2"
quit 1
end
if result_btn_pass_with_btn_reset > 3.4
echo "ASSERTION FAILED: result_btn_pass_with_btn_reset above 3.4"
quit 1
end
if result_btn_pass_with_btn_pass < 0
echo "ASSERTION FAILED: result_btn_pass_with_btn_pass below 0"
quit 1
end
if result_btn_pass_with_btn_pass > 0.1
echo "ASSERTION FAILED: result_btn_pass_with_btn_pass above 0.1"
quit 1
end
if result_btn_pass_with_btn_f1 < 3.2
echo "ASSERTION FAILED: result_btn_pass_with_btn_f1 below 3.2"
quit 1
end
if result_btn_pass_with_btn_f1 > 3.4
echo "ASSERTION FAILED: result_btn_pass_with_btn_f1 above 3.4"
quit 1
end
if result_btn_pass_with_btn_f2 < 3.2
echo "ASSERTION FAILED: result_btn_pass_with_btn_f2 below 3.2"
quit 1
end
if result_btn_pass_with_btn_f2 > 3.4
echo "ASSERTION FAILED: result_btn_pass_with_btn_f2 above 3.4"
quit 1
end
if result_btn_pass_with_btn_f3 < 3.2
echo "ASSERTION FAILED: result_btn_pass_with_btn_f3 below 3.2"
quit 1
end
if result_btn_pass_with_btn_f3 > 3.4
echo "ASSERTION FAILED: result_btn_pass_with_btn_f3 above 3.4"
quit 1
end
if result_btn_pass_with_btn_f4 < 3.2
echo "ASSERTION FAILED: result_btn_pass_with_btn_f4 below 3.2"
quit 1
end
if result_btn_pass_with_btn_f4 > 3.4
echo "ASSERTION FAILED: result_btn_pass_with_btn_f4 above 3.4"
quit 1
end
if result_btn_pass_with_btn_f5 < 3.2
echo "ASSERTION FAILED: result_btn_pass_with_btn_f5 below 3.2"
quit 1
end
if result_btn_pass_with_btn_f5 > 3.4
echo "ASSERTION FAILED: result_btn_pass_with_btn_f5 above 3.4"
quit 1
end
if result_btn_f1_idle < 3.2
echo "ASSERTION FAILED: result_btn_f1_idle below 3.2"
quit 1
end
if result_btn_f1_idle > 3.4
echo "ASSERTION FAILED: result_btn_f1_idle above 3.4"
quit 1
end
if result_btn_f1_with_btn_up < 3.2
echo "ASSERTION FAILED: result_btn_f1_with_btn_up below 3.2"
quit 1
end
if result_btn_f1_with_btn_up > 3.4
echo "ASSERTION FAILED: result_btn_f1_with_btn_up above 3.4"
quit 1
end
if result_btn_f1_with_btn_down < 3.2
echo "ASSERTION FAILED: result_btn_f1_with_btn_down below 3.2"
quit 1
end
if result_btn_f1_with_btn_down > 3.4
echo "ASSERTION FAILED: result_btn_f1_with_btn_down above 3.4"
quit 1
end
if result_btn_f1_with_btn_left < 3.2
echo "ASSERTION FAILED: result_btn_f1_with_btn_left below 3.2"
quit 1
end
if result_btn_f1_with_btn_left > 3.4
echo "ASSERTION FAILED: result_btn_f1_with_btn_left above 3.4"
quit 1
end
if result_btn_f1_with_btn_right < 3.2
echo "ASSERTION FAILED: result_btn_f1_with_btn_right below 3.2"
quit 1
end
if result_btn_f1_with_btn_right > 3.4
echo "ASSERTION FAILED: result_btn_f1_with_btn_right above 3.4"
quit 1
end
if result_btn_f1_with_btn_ok < 3.2
echo "ASSERTION FAILED: result_btn_f1_with_btn_ok below 3.2"
quit 1
end
if result_btn_f1_with_btn_ok > 3.4
echo "ASSERTION FAILED: result_btn_f1_with_btn_ok above 3.4"
quit 1
end
if result_btn_f1_with_btn_reset < 3.2
echo "ASSERTION FAILED: result_btn_f1_with_btn_reset below 3.2"
quit 1
end
if result_btn_f1_with_btn_reset > 3.4
echo "ASSERTION FAILED: result_btn_f1_with_btn_reset above 3.4"
quit 1
end
if result_btn_f1_with_btn_pass < 3.2
echo "ASSERTION FAILED: result_btn_f1_with_btn_pass below 3.2"
quit 1
end
if result_btn_f1_with_btn_pass > 3.4
echo "ASSERTION FAILED: result_btn_f1_with_btn_pass above 3.4"
quit 1
end
if result_btn_f1_with_btn_f1 < 0
echo "ASSERTION FAILED: result_btn_f1_with_btn_f1 below 0"
quit 1
end
if result_btn_f1_with_btn_f1 > 0.1
echo "ASSERTION FAILED: result_btn_f1_with_btn_f1 above 0.1"
quit 1
end
if result_btn_f1_with_btn_f2 < 3.2
echo "ASSERTION FAILED: result_btn_f1_with_btn_f2 below 3.2"
quit 1
end
if result_btn_f1_with_btn_f2 > 3.4
echo "ASSERTION FAILED: result_btn_f1_with_btn_f2 above 3.4"
quit 1
end
if result_btn_f1_with_btn_f3 < 3.2
echo "ASSERTION FAILED: result_btn_f1_with_btn_f3 below 3.2"
quit 1
end
if result_btn_f1_with_btn_f3 > 3.4
echo "ASSERTION FAILED: result_btn_f1_with_btn_f3 above 3.4"
quit 1
end
if result_btn_f1_with_btn_f4 < 3.2
echo "ASSERTION FAILED: result_btn_f1_with_btn_f4 below 3.2"
quit 1
end
if result_btn_f1_with_btn_f4 > 3.4
echo "ASSERTION FAILED: result_btn_f1_with_btn_f4 above 3.4"
quit 1
end
if result_btn_f1_with_btn_f5 < 3.2
echo "ASSERTION FAILED: result_btn_f1_with_btn_f5 below 3.2"
quit 1
end
if result_btn_f1_with_btn_f5 > 3.4
echo "ASSERTION FAILED: result_btn_f1_with_btn_f5 above 3.4"
quit 1
end
if result_btn_f2_idle < 3.2
echo "ASSERTION FAILED: result_btn_f2_idle below 3.2"
quit 1
end
if result_btn_f2_idle > 3.4
echo "ASSERTION FAILED: result_btn_f2_idle above 3.4"
quit 1
end
if result_btn_f2_with_btn_up < 3.2
echo "ASSERTION FAILED: result_btn_f2_with_btn_up below 3.2"
quit 1
end
if result_btn_f2_with_btn_up > 3.4
echo "ASSERTION FAILED: result_btn_f2_with_btn_up above 3.4"
quit 1
end
if result_btn_f2_with_btn_down < 3.2
echo "ASSERTION FAILED: result_btn_f2_with_btn_down below 3.2"
quit 1
end
if result_btn_f2_with_btn_down > 3.4
echo "ASSERTION FAILED: result_btn_f2_with_btn_down above 3.4"
quit 1
end
if result_btn_f2_with_btn_left < 3.2
echo "ASSERTION FAILED: result_btn_f2_with_btn_left below 3.2"
quit 1
end
if result_btn_f2_with_btn_left > 3.4
echo "ASSERTION FAILED: result_btn_f2_with_btn_left above 3.4"
quit 1
end
if result_btn_f2_with_btn_right < 3.2
echo "ASSERTION FAILED: result_btn_f2_with_btn_right below 3.2"
quit 1
end
if result_btn_f2_with_btn_right > 3.4
echo "ASSERTION FAILED: result_btn_f2_with_btn_right above 3.4"
quit 1
end
if result_btn_f2_with_btn_ok < 3.2
echo "ASSERTION FAILED: result_btn_f2_with_btn_ok below 3.2"
quit 1
end
if result_btn_f2_with_btn_ok > 3.4
echo "ASSERTION FAILED: result_btn_f2_with_btn_ok above 3.4"
quit 1
end
if result_btn_f2_with_btn_reset < 3.2
echo "ASSERTION FAILED: result_btn_f2_with_btn_reset below 3.2"
quit 1
end
if result_btn_f2_with_btn_reset > 3.4
echo "ASSERTION FAILED: result_btn_f2_with_btn_reset above 3.4"
quit 1
end
if result_btn_f2_with_btn_pass < 3.2
echo "ASSERTION FAILED: result_btn_f2_with_btn_pass below 3.2"
quit 1
end
if result_btn_f2_with_btn_pass > 3.4
echo "ASSERTION FAILED: result_btn_f2_with_btn_pass above 3.4"
quit 1
end
if result_btn_f2_with_btn_f1 < 3.2
echo "ASSERTION FAILED: result_btn_f2_with_btn_f1 below 3.2"
quit 1
end
if result_btn_f2_with_btn_f1 > 3.4
echo "ASSERTION FAILED: result_btn_f2_with_btn_f1 above 3.4"
quit 1
end
if result_btn_f2_with_btn_f2 < 0
echo "ASSERTION FAILED: result_btn_f2_with_btn_f2 below 0"
quit 1
end
if result_btn_f2_with_btn_f2 > 0.1
echo "ASSERTION FAILED: result_btn_f2_with_btn_f2 above 0.1"
quit 1
end
if result_btn_f2_with_btn_f3 < 3.2
echo "ASSERTION FAILED: result_btn_f2_with_btn_f3 below 3.2"
quit 1
end
if result_btn_f2_with_btn_f3 > 3.4
echo "ASSERTION FAILED: result_btn_f2_with_btn_f3 above 3.4"
quit 1
end
if result_btn_f2_with_btn_f4 < 3.2
echo "ASSERTION FAILED: result_btn_f2_with_btn_f4 below 3.2"
quit 1
end
if result_btn_f2_with_btn_f4 > 3.4
echo "ASSERTION FAILED: result_btn_f2_with_btn_f4 above 3.4"
quit 1
end
if result_btn_f2_with_btn_f5 < 3.2
echo "ASSERTION FAILED: result_btn_f2_with_btn_f5 below 3.2"
quit 1
end
if result_btn_f2_with_btn_f5 > 3.4
echo "ASSERTION FAILED: result_btn_f2_with_btn_f5 above 3.4"
quit 1
end
if result_btn_f3_idle < 3.2
echo "ASSERTION FAILED: result_btn_f3_idle below 3.2"
quit 1
end
if result_btn_f3_idle > 3.4
echo "ASSERTION FAILED: result_btn_f3_idle above 3.4"
quit 1
end
if result_btn_f3_with_btn_up < 3.2
echo "ASSERTION FAILED: result_btn_f3_with_btn_up below 3.2"
quit 1
end
if result_btn_f3_with_btn_up > 3.4
echo "ASSERTION FAILED: result_btn_f3_with_btn_up above 3.4"
quit 1
end
if result_btn_f3_with_btn_down < 3.2
echo "ASSERTION FAILED: result_btn_f3_with_btn_down below 3.2"
quit 1
end
if result_btn_f3_with_btn_down > 3.4
echo "ASSERTION FAILED: result_btn_f3_with_btn_down above 3.4"
quit 1
end
if result_btn_f3_with_btn_left < 3.2
echo "ASSERTION FAILED: result_btn_f3_with_btn_left below 3.2"
quit 1
end
if result_btn_f3_with_btn_left > 3.4
echo "ASSERTION FAILED: result_btn_f3_with_btn_left above 3.4"
quit 1
end
if result_btn_f3_with_btn_right < 3.2
echo "ASSERTION FAILED: result_btn_f3_with_btn_right below 3.2"
quit 1
end
if result_btn_f3_with_btn_right > 3.4
echo "ASSERTION FAILED: result_btn_f3_with_btn_right above 3.4"
quit 1
end
if result_btn_f3_with_btn_ok < 3.2
echo "ASSERTION FAILED: result_btn_f3_with_btn_ok below 3.2"
quit 1
end
if result_btn_f3_with_btn_ok > 3.4
echo "ASSERTION FAILED: result_btn_f3_with_btn_ok above 3.4"
quit 1
end
if result_btn_f3_with_btn_reset < 3.2
echo "ASSERTION FAILED: result_btn_f3_with_btn_reset below 3.2"
quit 1
end
if result_btn_f3_with_btn_reset > 3.4
echo "ASSERTION FAILED: result_btn_f3_with_btn_reset above 3.4"
quit 1
end
if result_btn_f3_with_btn_pass < 3.2
echo "ASSERTION FAILED: result_btn_f3_with_btn_pass below 3.2"
quit 1
end
if result_btn_f3_with_btn_pass > 3.4
echo "ASSERTION FAILED: result_btn_f3_with_btn_pass above 3.4"
quit 1
end
if result_btn_f3_with_btn_f1 < 3.2
echo "ASSERTION FAILED: result_btn_f3_with_btn_f1 below 3.2"
quit 1
end
if result_btn_f3_with_btn_f1 > 3.4
echo "ASSERTION FAILED: result_btn_f3_with_btn_f1 above 3.4"
quit 1
end
if result_btn_f3_with_btn_f2 < 3.2
echo "ASSERTION FAILED: result_btn_f3_with_btn_f2 below 3.2"
quit 1
end
if result_btn_f3_with_btn_f2 > 3.4
echo "ASSERTION FAILED: result_btn_f3_with_btn_f2 above 3.4"
quit 1
end
if result_btn_f3_with_btn_f3 < 0
echo "ASSERTION FAILED: result_btn_f3_with_btn_f3 below 0"
quit 1
end
if result_btn_f3_with_btn_f3 > 0.1
echo "ASSERTION FAILED: result_btn_f3_with_btn_f3 above 0.1"
quit 1
end
if result_btn_f3_with_btn_f4 < 3.2
echo "ASSERTION FAILED: result_btn_f3_with_btn_f4 below 3.2"
quit 1
end
if result_btn_f3_with_btn_f4 > 3.4
echo "ASSERTION FAILED: result_btn_f3_with_btn_f4 above 3.4"
quit 1
end
if result_btn_f3_with_btn_f5 < 3.2
echo "ASSERTION FAILED: result_btn_f3_with_btn_f5 below 3.2"
quit 1
end
if result_btn_f3_with_btn_f5 > 3.4
echo "ASSERTION FAILED: result_btn_f3_with_btn_f5 above 3.4"
quit 1
end
if result_btn_f4_idle < 3.2
echo "ASSERTION FAILED: result_btn_f4_idle below 3.2"
quit 1
end
if result_btn_f4_idle > 3.4
echo "ASSERTION FAILED: result_btn_f4_idle above 3.4"
quit 1
end
if result_btn_f4_with_btn_up < 3.2
echo "ASSERTION FAILED: result_btn_f4_with_btn_up below 3.2"
quit 1
end
if result_btn_f4_with_btn_up > 3.4
echo "ASSERTION FAILED: result_btn_f4_with_btn_up above 3.4"
quit 1
end
if result_btn_f4_with_btn_down < 3.2
echo "ASSERTION FAILED: result_btn_f4_with_btn_down below 3.2"
quit 1
end
if result_btn_f4_with_btn_down > 3.4
echo "ASSERTION FAILED: result_btn_f4_with_btn_down above 3.4"
quit 1
end
if result_btn_f4_with_btn_left < 3.2
echo "ASSERTION FAILED: result_btn_f4_with_btn_left below 3.2"
quit 1
end
if result_btn_f4_with_btn_left > 3.4
echo "ASSERTION FAILED: result_btn_f4_with_btn_left above 3.4"
quit 1
end
if result_btn_f4_with_btn_right < 3.2
echo "ASSERTION FAILED: result_btn_f4_with_btn_right below 3.2"
quit 1
end
if result_btn_f4_with_btn_right > 3.4
echo "ASSERTION FAILED: result_btn_f4_with_btn_right above 3.4"
quit 1
end
if result_btn_f4_with_btn_ok < 3.2
echo "ASSERTION FAILED: result_btn_f4_with_btn_ok below 3.2"
quit 1
end
if result_btn_f4_with_btn_ok > 3.4
echo "ASSERTION FAILED: result_btn_f4_with_btn_ok above 3.4"
quit 1
end
if result_btn_f4_with_btn_reset < 3.2
echo "ASSERTION FAILED: result_btn_f4_with_btn_reset below 3.2"
quit 1
end
if result_btn_f4_with_btn_reset > 3.4
echo "ASSERTION FAILED: result_btn_f4_with_btn_reset above 3.4"
quit 1
end
if result_btn_f4_with_btn_pass < 3.2
echo "ASSERTION FAILED: result_btn_f4_with_btn_pass below 3.2"
quit 1
end
if result_btn_f4_with_btn_pass > 3.4
echo "ASSERTION FAILED: result_btn_f4_with_btn_pass above 3.4"
quit 1
end
if result_btn_f4_with_btn_f1 < 3.2
echo "ASSERTION FAILED: result_btn_f4_with_btn_f1 below 3.2"
quit 1
end
if result_btn_f4_with_btn_f1 > 3.4
echo "ASSERTION FAILED: result_btn_f4_with_btn_f1 above 3.4"
quit 1
end
if result_btn_f4_with_btn_f2 < 3.2
echo "ASSERTION FAILED: result_btn_f4_with_btn_f2 below 3.2"
quit 1
end
if result_btn_f4_with_btn_f2 > 3.4
echo "ASSERTION FAILED: result_btn_f4_with_btn_f2 above 3.4"
quit 1
end
if result_btn_f4_with_btn_f3 < 3.2
echo "ASSERTION FAILED: result_btn_f4_with_btn_f3 below 3.2"
quit 1
end
if result_btn_f4_with_btn_f3 > 3.4
echo "ASSERTION FAILED: result_btn_f4_with_btn_f3 above 3.4"
quit 1
end
if result_btn_f4_with_btn_f4 < 0
echo "ASSERTION FAILED: result_btn_f4_with_btn_f4 below 0"
quit 1
end
if result_btn_f4_with_btn_f4 > 0.1
echo "ASSERTION FAILED: result_btn_f4_with_btn_f4 above 0.1"
quit 1
end
if result_btn_f4_with_btn_f5 < 3.2
echo "ASSERTION FAILED: result_btn_f4_with_btn_f5 below 3.2"
quit 1
end
if result_btn_f4_with_btn_f5 > 3.4
echo "ASSERTION FAILED: result_btn_f4_with_btn_f5 above 3.4"
quit 1
end
if result_btn_f5_idle < 3.2
echo "ASSERTION FAILED: result_btn_f5_idle below 3.2"
quit 1
end
if result_btn_f5_idle > 3.4
echo "ASSERTION FAILED: result_btn_f5_idle above 3.4"
quit 1
end
if result_btn_f5_with_btn_up < 3.2
echo "ASSERTION FAILED: result_btn_f5_with_btn_up below 3.2"
quit 1
end
if result_btn_f5_with_btn_up > 3.4
echo "ASSERTION FAILED: result_btn_f5_with_btn_up above 3.4"
quit 1
end
if result_btn_f5_with_btn_down < 3.2
echo "ASSERTION FAILED: result_btn_f5_with_btn_down below 3.2"
quit 1
end
if result_btn_f5_with_btn_down > 3.4
echo "ASSERTION FAILED: result_btn_f5_with_btn_down above 3.4"
quit 1
end
if result_btn_f5_with_btn_left < 3.2
echo "ASSERTION FAILED: result_btn_f5_with_btn_left below 3.2"
quit 1
end
if result_btn_f5_with_btn_left > 3.4
echo "ASSERTION FAILED: result_btn_f5_with_btn_left above 3.4"
quit 1
end
if result_btn_f5_with_btn_right < 3.2
echo "ASSERTION FAILED: result_btn_f5_with_btn_right below 3.2"
quit 1
end
if result_btn_f5_with_btn_right > 3.4
echo "ASSERTION FAILED: result_btn_f5_with_btn_right above 3.4"
quit 1
end
if result_btn_f5_with_btn_ok < 3.2
echo "ASSERTION FAILED: result_btn_f5_with_btn_ok below 3.2"
quit 1
end
if result_btn_f5_with_btn_ok > 3.4
echo "ASSERTION FAILED: result_btn_f5_with_btn_ok above 3.4"
quit 1
end
if result_btn_f5_with_btn_reset < 3.2
echo "ASSERTION FAILED: result_btn_f5_with_btn_reset below 3.2"
quit 1
end
if result_btn_f5_with_btn_reset > 3.4
echo "ASSERTION FAILED: result_btn_f5_with_btn_reset above 3.4"
quit 1
end
if result_btn_f5_with_btn_pass < 3.2
echo "ASSERTION FAILED: result_btn_f5_with_btn_pass below 3.2"
quit 1
end
if result_btn_f5_with_btn_pass > 3.4
echo "ASSERTION FAILED: result_btn_f5_with_btn_pass above 3.4"
quit 1
end
if result_btn_f5_with_btn_f1 < 3.2
echo "ASSERTION FAILED: result_btn_f5_with_btn_f1 below 3.2"
quit 1
end
if result_btn_f5_with_btn_f1 > 3.4
echo "ASSERTION FAILED: result_btn_f5_with_btn_f1 above 3.4"
quit 1
end
if result_btn_f5_with_btn_f2 < 3.2
echo "ASSERTION FAILED: result_btn_f5_with_btn_f2 below 3.2"
quit 1
end
if result_btn_f5_with_btn_f2 > 3.4
echo "ASSERTION FAILED: result_btn_f5_with_btn_f2 above 3.4"
quit 1
end
if result_btn_f5_with_btn_f3 < 3.2
echo "ASSERTION FAILED: result_btn_f5_with_btn_f3 below 3.2"
quit 1
end
if result_btn_f5_with_btn_f3 > 3.4
echo "ASSERTION FAILED: result_btn_f5_with_btn_f3 above 3.4"
quit 1
end
if result_btn_f5_with_btn_f4 < 3.2
echo "ASSERTION FAILED: result_btn_f5_with_btn_f4 below 3.2"
quit 1
end
if result_btn_f5_with_btn_f4 > 3.4
echo "ASSERTION FAILED: result_btn_f5_with_btn_f4 above 3.4"
quit 1
end
if result_btn_f5_with_btn_f5 < 0
echo "ASSERTION FAILED: result_btn_f5_with_btn_f5 below 0"
quit 1
end
if result_btn_f5_with_btn_f5 > 0.1
echo "ASSERTION FAILED: result_btn_f5_with_btn_f5 above 0.1"
quit 1
end
quit 0
.endc
.end
